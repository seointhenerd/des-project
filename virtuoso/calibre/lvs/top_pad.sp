* SPICE NETLIST
***************************************

.SUBCKT crtmom PLUS MINUS BULK
.ENDS
***************************************
.SUBCKT cfmom PLUS MINUS BULK
.ENDS
***************************************
.SUBCKT cfmom_rf PLUS MINUS BULK
.ENDS
***************************************
.SUBCKT cfmom_mx PLUS1 MINUS1 PLUS2 MINUS2 BULK
.ENDS
***************************************
.SUBCKT lcesd1_rf PLUS MINUS
.ENDS
***************************************
.SUBCKT lcesd2_rf PLUS MINUS
.ENDS
***************************************
.SUBCKT mimcap_2p0_shield PLUS MINUS BULK
.ENDS
***************************************
.SUBCKT mimcap_2p0_sin TOP BOT
.ENDS
***************************************
.SUBCKT mimcap_2p0_sin_3t PLUS MINUS BULK
.ENDS
***************************************
.SUBCKT mimcap_2p0_wos PLUS MINUS BULK
.ENDS
***************************************
.SUBCKT moscap_rf PLUS MINUS BULK
.ENDS
***************************************
.SUBCKT moscap_rf33 PLUS MINUS BULK
.ENDS
***************************************
.SUBCKT moscap_rf33_nw PLUS MINUS BULK
.ENDS
***************************************
.SUBCKT moscap_rf_nw PLUS MINUS BULK
.ENDS
***************************************
.SUBCKT nmos_rf D G S B
.ENDS
***************************************
.SUBCKT nmos_rf33 D G S B
.ENDS
***************************************
.SUBCKT nmos_rf33_6t D G S B NG PG
.ENDS
***************************************
.SUBCKT nmos_rf_6t D G S B NG PG
.ENDS
***************************************
.SUBCKT nmoscap PLUS MINUS
.ENDS
***************************************
.SUBCKT nmoscap_33 PLUS MINUS
.ENDS
***************************************
.SUBCKT pmos_rf D G S B
.ENDS
***************************************
.SUBCKT pmos_rf33 D G S B
.ENDS
***************************************
.SUBCKT pmos_rf33_5t D G S B PG
.ENDS
***************************************
.SUBCKT pmos_rf33_nw D G S B
.ENDS
***************************************
.SUBCKT pmos_rf33_nw_5t D G S B PG
.ENDS
***************************************
.SUBCKT pmos_rf_5t D G S B PG
.ENDS
***************************************
.SUBCKT pmos_rf_nw D G S B
.ENDS
***************************************
.SUBCKT pmos_rf_nw_5t D G S B PG
.ENDS
***************************************
.SUBCKT rnod_m PLUS MINUS B
.ENDS
***************************************
.SUBCKT rnodrpo_m PLUS MINUS B
.ENDS
***************************************
.SUBCKT rnodw_m PLUS MINUS B
.ENDS
***************************************
.SUBCKT rnpo1_dis PLUS MINUS B
.ENDS
***************************************
.SUBCKT rnpo1rpo_dis PLUS MINUS B
.ENDS
***************************************
.SUBCKT rnpo1w_dis PLUS MINUS B
.ENDS
***************************************
.SUBCKT rnwod_m PLUS MINUS B
.ENDS
***************************************
.SUBCKT rnwsti_m PLUS MINUS B
.ENDS
***************************************
.SUBCKT rpod_m PLUS MINUS B
.ENDS
***************************************
.SUBCKT rpodrpo_m PLUS MINUS B
.ENDS
***************************************
.SUBCKT rpodw_m PLUS MINUS B
.ENDS
***************************************
.SUBCKT rppo1_dis PLUS MINUS B
.ENDS
***************************************
.SUBCKT rppo1rpo_dis PLUS MINUS B
.ENDS
***************************************
.SUBCKT rppo1w_dis PLUS MINUS B
.ENDS
***************************************
.SUBCKT rppolyhri_dis PLUS MINUS B
.ENDS
***************************************
.SUBCKT rppolyhri_rf PLUS MINUS BULK
.ENDS
***************************************
.SUBCKT rppolyl_rf PLUS MINUS BULK
.ENDS
***************************************
.SUBCKT rppolys_rf PLUS MINUS BULK
.ENDS
***************************************
.SUBCKT rppolywo_rf PLUS MINUS BULK
.ENDS
***************************************
.SUBCKT sbd_rf PLUS MINUS BULK
.ENDS
***************************************
.SUBCKT sbd_rf_nw PLUS MINUS BULK
.ENDS
***************************************
.SUBCKT spiral_std_mu_x_40k PLUS MINUS BULK
.ENDS
***************************************
.SUBCKT spiral_sym_ct_mu_x_40k PLUS MINUS BULK CTAP
.ENDS
***************************************
.SUBCKT spiral_sym_mu_x_40k PLUS MINUS BULK
.ENDS
***************************************
.SUBCKT xjvar_nr36 PLUS MINUS BULK
.ENDS
***************************************
.SUBCKT xjvar_w40 PLUS MINUS BULK
.ENDS
***************************************
.SUBCKT pad_corner
** N=4 EP=0 IP=0 FDC=0
*.CALIBRE ISOLATED NETS: VSS VDD
.ENDS
***************************************
.SUBCKT ICV_142
** N=4 EP=0 IP=4 FDC=0
.ENDS
***************************************
.SUBCKT pad_fill_32
** N=4 EP=0 IP=0 FDC=0
*.CALIBRE ISOLATED NETS: VSS VDD
.ENDS
***************************************
.SUBCKT ICV_141
** N=4 EP=0 IP=20 FDC=0
.ENDS
***************************************
.SUBCKT padbox
** N=1 EP=0 IP=0 FDC=0
.ENDS
***************************************
.SUBCKT pad_in VSS pad VDD DataIn
** N=24 EP=4 IP=1 FDC=96
M0 VSS VSS 7 VSS N L=3.5e-07 W=9e-06 $X=5700 $Y=147100 $D=0
M1 8 7 VSS VSS N L=3.5e-07 W=9e-06 $X=8100 $Y=147100 $D=0
M2 VSS VSS 10 VSS N L=3.5e-07 W=9e-06 $X=13200 $Y=147100 $D=0
M3 10 VSS VSS VSS N L=3.5e-07 W=9e-06 $X=15600 $Y=147100 $D=0
M4 pad 10 VSS VSS N L=3.5e-07 W=2e-05 $X=15770 $Y=191300 $D=0
M5 VSS 10 pad VSS N L=3.5e-07 W=2e-05 $X=15770 $Y=196210 $D=0
M6 pad 10 VSS VSS N L=3.5e-07 W=2e-05 $X=15770 $Y=197780 $D=0
M7 VSS 10 pad VSS N L=3.5e-07 W=2e-05 $X=15770 $Y=202690 $D=0
M8 pad 10 VSS VSS N L=3.5e-07 W=2e-05 $X=15770 $Y=204260 $D=0
M9 VSS 10 pad VSS N L=3.5e-07 W=2e-05 $X=15770 $Y=209170 $D=0
M10 pad 10 VSS VSS N L=3.5e-07 W=2e-05 $X=15770 $Y=210740 $D=0
M11 VSS 10 pad VSS N L=3.5e-07 W=2e-05 $X=15770 $Y=215650 $D=0
M12 pad 10 VSS VSS N L=3.5e-07 W=2e-05 $X=15770 $Y=217220 $D=0
M13 VSS 10 pad VSS N L=3.5e-07 W=2e-05 $X=15770 $Y=222130 $D=0
M14 VSS VSS 10 VSS N L=3.5e-07 W=9e-06 $X=18000 $Y=147100 $D=0
M15 10 VSS VSS VSS N L=3.5e-07 W=9e-06 $X=20400 $Y=147100 $D=0
M16 VSS VSS 10 VSS N L=3.5e-07 W=9e-06 $X=22800 $Y=147100 $D=0
M17 10 7 VSS VSS N L=3.5e-07 W=9e-06 $X=25200 $Y=147100 $D=0
M18 VSS 7 10 VSS N L=3.5e-07 W=9e-06 $X=27600 $Y=147100 $D=0
M19 10 7 VSS VSS N L=3.5e-07 W=9e-06 $X=30000 $Y=147100 $D=0
M20 VSS 7 10 VSS N L=3.5e-07 W=9e-06 $X=32400 $Y=147100 $D=0
M21 10 7 VSS VSS N L=3.5e-07 W=9e-06 $X=34800 $Y=147100 $D=0
M22 9 8 10 VSS N L=3.5e-07 W=9e-06 $X=37200 $Y=147100 $D=0
M23 10 8 9 VSS N L=3.5e-07 W=9e-06 $X=39600 $Y=147100 $D=0
M24 9 8 10 VSS N L=3.5e-07 W=9e-06 $X=42000 $Y=147100 $D=0
M25 10 8 9 VSS N L=3.5e-07 W=9e-06 $X=44400 $Y=147100 $D=0
M26 pad 10 VSS VSS N L=3.5e-07 W=2e-05 $X=54230 $Y=191300 $D=0
M27 VSS 10 pad VSS N L=3.5e-07 W=2e-05 $X=54230 $Y=196210 $D=0
M28 pad 10 VSS VSS N L=3.5e-07 W=2e-05 $X=54230 $Y=197780 $D=0
M29 VSS 10 pad VSS N L=3.5e-07 W=2e-05 $X=54230 $Y=202690 $D=0
M30 pad 10 VSS VSS N L=3.5e-07 W=2e-05 $X=54230 $Y=204260 $D=0
M31 VSS 10 pad VSS N L=3.5e-07 W=2e-05 $X=54230 $Y=209170 $D=0
M32 pad 10 VSS VSS N L=3.5e-07 W=2e-05 $X=54230 $Y=210740 $D=0
M33 VSS 10 pad VSS N L=3.5e-07 W=2e-05 $X=54230 $Y=215650 $D=0
M34 pad 10 VSS VSS N L=3.5e-07 W=2e-05 $X=54230 $Y=217220 $D=0
M35 VSS 10 pad VSS N L=3.5e-07 W=2e-05 $X=54230 $Y=222130 $D=0
M36 11 pad VSS VSS N L=3.5e-07 W=9e-06 $X=59400 $Y=146950 $D=0
M37 VSS pad 11 VSS N L=3.5e-07 W=9e-06 $X=61800 $Y=146950 $D=0
M38 11 pad VSS VSS N L=3.5e-07 W=9e-06 $X=64200 $Y=146950 $D=0
M39 VSS pad 11 VSS N L=3.5e-07 W=9e-06 $X=66600 $Y=146950 $D=0
M40 11 pad VSS VSS N L=3.5e-07 W=9e-06 $X=69000 $Y=146950 $D=0
M41 VSS pad 11 VSS N L=3.5e-07 W=9e-06 $X=71400 $Y=146950 $D=0
M42 DataIn 11 VSS VSS N L=3.5e-07 W=9e-06 $X=73800 $Y=146950 $D=0
M43 VSS 11 DataIn VSS N L=3.5e-07 W=9e-06 $X=76200 $Y=146950 $D=0
M44 DataIn 11 VSS VSS N L=3.5e-07 W=9e-06 $X=78600 $Y=146950 $D=0
M45 VSS 11 DataIn VSS N L=3.5e-07 W=9e-06 $X=81000 $Y=146950 $D=0
M46 DataIn 11 VSS VSS N L=3.5e-07 W=9e-06 $X=83400 $Y=146950 $D=0
M47 VSS 11 DataIn VSS N L=3.5e-07 W=9e-06 $X=85800 $Y=146950 $D=0
M48 VDD VSS 7 VDD P L=3.5e-07 W=1.56e-05 $X=5700 $Y=165550 $D=16
M49 8 7 VDD VDD P L=3.5e-07 W=1.56e-05 $X=8100 $Y=165550 $D=16
M50 VDD VSS 9 VDD P L=3.5e-07 W=1.56e-05 $X=13200 $Y=165550 $D=16
M51 9 VSS VDD VDD P L=3.5e-07 W=1.56e-05 $X=15600 $Y=165550 $D=16
M52 pad 9 VDD VDD P L=3.5e-07 W=2e-05 $X=15795 $Y=97085 $D=16
M53 VDD 9 pad VDD P L=3.5e-07 W=2e-05 $X=15795 $Y=101995 $D=16
M54 pad 9 VDD VDD P L=3.5e-07 W=2e-05 $X=15795 $Y=103565 $D=16
M55 VDD 9 pad VDD P L=3.5e-07 W=2e-05 $X=15795 $Y=108475 $D=16
M56 pad 9 VDD VDD P L=3.5e-07 W=2e-05 $X=15795 $Y=110045 $D=16
M57 VDD 9 pad VDD P L=3.5e-07 W=2e-05 $X=15795 $Y=114955 $D=16
M58 pad 9 VDD VDD P L=3.5e-07 W=2e-05 $X=15795 $Y=116525 $D=16
M59 VDD 9 pad VDD P L=3.5e-07 W=2e-05 $X=15795 $Y=121435 $D=16
M60 pad 9 VDD VDD P L=3.5e-07 W=2e-05 $X=15795 $Y=123005 $D=16
M61 VDD 9 pad VDD P L=3.5e-07 W=2e-05 $X=15795 $Y=127915 $D=16
M62 VDD VSS 9 VDD P L=3.5e-07 W=1.56e-05 $X=18000 $Y=165550 $D=16
M63 9 VSS VDD VDD P L=3.5e-07 W=1.56e-05 $X=20400 $Y=165550 $D=16
M64 VDD VSS 9 VDD P L=3.5e-07 W=1.56e-05 $X=22800 $Y=165550 $D=16
M65 9 8 VDD VDD P L=3.5e-07 W=1.56e-05 $X=25200 $Y=165550 $D=16
M66 VDD 8 9 VDD P L=3.5e-07 W=1.56e-05 $X=27600 $Y=165550 $D=16
M67 9 8 VDD VDD P L=3.5e-07 W=1.56e-05 $X=30000 $Y=165550 $D=16
M68 VDD 8 9 VDD P L=3.5e-07 W=1.56e-05 $X=32400 $Y=165550 $D=16
M69 9 8 VDD VDD P L=3.5e-07 W=1.56e-05 $X=34800 $Y=165550 $D=16
M70 10 7 9 VDD P L=3.5e-07 W=1.56e-05 $X=37200 $Y=165550 $D=16
M71 9 7 10 VDD P L=3.5e-07 W=1.56e-05 $X=39600 $Y=165550 $D=16
M72 10 7 9 VDD P L=3.5e-07 W=1.56e-05 $X=42000 $Y=165550 $D=16
M73 9 7 10 VDD P L=3.5e-07 W=1.56e-05 $X=44400 $Y=165550 $D=16
M74 pad 9 VDD VDD P L=3.5e-07 W=2e-05 $X=53330 $Y=97085 $D=16
M75 VDD 9 pad VDD P L=3.5e-07 W=2e-05 $X=53330 $Y=101995 $D=16
M76 pad 9 VDD VDD P L=3.5e-07 W=2e-05 $X=53330 $Y=103565 $D=16
M77 VDD 9 pad VDD P L=3.5e-07 W=2e-05 $X=53330 $Y=108475 $D=16
M78 pad 9 VDD VDD P L=3.5e-07 W=2e-05 $X=53330 $Y=110045 $D=16
M79 VDD 9 pad VDD P L=3.5e-07 W=2e-05 $X=53330 $Y=114955 $D=16
M80 pad 9 VDD VDD P L=3.5e-07 W=2e-05 $X=53330 $Y=116525 $D=16
M81 VDD 9 pad VDD P L=3.5e-07 W=2e-05 $X=53330 $Y=121435 $D=16
M82 pad 9 VDD VDD P L=3.5e-07 W=2e-05 $X=53330 $Y=123005 $D=16
M83 VDD 9 pad VDD P L=3.5e-07 W=2e-05 $X=53330 $Y=127915 $D=16
M84 11 pad VDD VDD P L=3.5e-07 W=1.56e-05 $X=59400 $Y=165550 $D=16
M85 VDD pad 11 VDD P L=3.5e-07 W=1.56e-05 $X=61800 $Y=165550 $D=16
M86 11 pad VDD VDD P L=3.5e-07 W=1.56e-05 $X=64200 $Y=165550 $D=16
M87 VDD pad 11 VDD P L=3.5e-07 W=1.56e-05 $X=66600 $Y=165550 $D=16
M88 11 pad VDD VDD P L=3.5e-07 W=1.56e-05 $X=69000 $Y=165550 $D=16
M89 VDD pad 11 VDD P L=3.5e-07 W=1.56e-05 $X=71400 $Y=165550 $D=16
M90 DataIn 11 VDD VDD P L=3.5e-07 W=1.56e-05 $X=73800 $Y=165550 $D=16
M91 VDD 11 DataIn VDD P L=3.5e-07 W=1.56e-05 $X=76200 $Y=165550 $D=16
M92 DataIn 11 VDD VDD P L=3.5e-07 W=1.56e-05 $X=78600 $Y=165550 $D=16
M93 VDD 11 DataIn VDD P L=3.5e-07 W=1.56e-05 $X=81000 $Y=165550 $D=16
M94 DataIn 11 VDD VDD P L=3.5e-07 W=1.56e-05 $X=83400 $Y=165550 $D=16
M95 VDD 11 DataIn VDD P L=3.5e-07 W=1.56e-05 $X=85800 $Y=165550 $D=16
.ENDS
***************************************
.SUBCKT pad_fill_005
** N=4 EP=0 IP=0 FDC=0
*.CALIBRE ISOLATED NETS: VSS VDD
.ENDS
***************************************
.SUBCKT ICV_140 1 2 3 4
** N=6 EP=4 IP=42 FDC=96
X1 1 4 2 3 pad_in $T=0 523240 0 270 $X=0 $Y=432340
.ENDS
***************************************
.SUBCKT ICV_139
** N=5 EP=0 IP=48 FDC=0
.ENDS
***************************************
.SUBCKT ICV_138 1 2 3 4
** N=6 EP=4 IP=22 FDC=96
X4 1 4 2 3 pad_in $T=0 813280 0 270 $X=0 $Y=722380
.ENDS
***************************************
.SUBCKT ICV_137
** N=4 EP=0 IP=36 FDC=0
.ENDS
***************************************
.SUBCKT ICV_2 VSS VDD
** N=38 EP=2 IP=1 FDC=1
D0 VSS VDD pdio_m AREA=9e-10 PJ=0.00012 $X=8570 $Y=96300 $D=31
.ENDS
***************************************
.SUBCKT ICV_136
** N=4 EP=0 IP=20 FDC=0
.ENDS
***************************************
.SUBCKT ICV_135
** N=4 EP=0 IP=36 FDC=0
.ENDS
***************************************
.SUBCKT ICV_10
** N=4 EP=0 IP=4 FDC=0
.ENDS
***************************************
.SUBCKT ICV_8
** N=4 EP=0 IP=4 FDC=0
.ENDS
***************************************
.SUBCKT ICV_7
** N=4 EP=0 IP=4 FDC=0
.ENDS
***************************************
.SUBCKT ICV_4
** N=4 EP=0 IP=4 FDC=0
.ENDS
***************************************
.SUBCKT ICV_132
** N=4 EP=0 IP=8 FDC=0
.ENDS
***************************************
.SUBCKT ICV_133
** N=4 EP=0 IP=8 FDC=0
.ENDS
***************************************
.SUBCKT pad_fill_8
** N=4 EP=0 IP=0 FDC=0
*.CALIBRE ISOLATED NETS: VSS VDD
.ENDS
***************************************
.SUBCKT pad_fill_4
** N=4 EP=0 IP=0 FDC=0
*.CALIBRE ISOLATED NETS: VSS VDD
.ENDS
***************************************
.SUBCKT pad_fill_2
** N=4 EP=0 IP=0 FDC=0
*.CALIBRE ISOLATED NETS: VSS VDD
.ENDS
***************************************
.SUBCKT pad_fill_01
** N=4 EP=0 IP=0 FDC=0
*.CALIBRE ISOLATED NETS: VSS VDD
.ENDS
***************************************
.SUBCKT ICV_134
** N=4 EP=0 IP=80 FDC=0
.ENDS
***************************************
.SUBCKT ICV_21
** N=4 EP=0 IP=8 FDC=0
.ENDS
***************************************
.SUBCKT ICV_19
** N=4 EP=0 IP=8 FDC=0
.ENDS
***************************************
.SUBCKT ICV_20
** N=4 EP=0 IP=8 FDC=0
.ENDS
***************************************
.SUBCKT ICV_22 1 2 3 4 5 6 7 8
** N=10 EP=8 IP=214 FDC=288
X5 1 6 2 3 pad_in $T=761330 1536560 0 180 $X=670430 $Y=1302460
X6 1 7 2 4 pad_in $T=1025390 1536560 0 180 $X=934490 $Y=1302460
X7 1 8 2 5 pad_in $T=1289455 1536560 0 180 $X=1198555 $Y=1302460
.ENDS
***************************************
.SUBCKT FILL32
** N=8 EP=0 IP=0 FDC=0
.ENDS
***************************************
.SUBCKT ICV_26
** N=4 EP=0 IP=8 FDC=0
.ENDS
***************************************
.SUBCKT ICV_29
** N=5 EP=0 IP=8 FDC=0
.ENDS
***************************************
.SUBCKT ICV_30
** N=5 EP=0 IP=10 FDC=0
.ENDS
***************************************
.SUBCKT ICV_31
** N=7 EP=0 IP=10 FDC=0
.ENDS
***************************************
.SUBCKT ICV_32
** N=11 EP=0 IP=14 FDC=0
.ENDS
***************************************
.SUBCKT ICV_34
** N=11 EP=0 IP=22 FDC=0
.ENDS
***************************************
.SUBCKT ICV_27
** N=4 EP=0 IP=8 FDC=0
.ENDS
***************************************
.SUBCKT FILL16
** N=8 EP=0 IP=0 FDC=0
.ENDS
***************************************
.SUBCKT ICV_25
** N=4 EP=0 IP=8 FDC=0
.ENDS
***************************************
.SUBCKT FILL4
** N=4 EP=0 IP=0 FDC=0
.ENDS
***************************************
.SUBCKT FILL2
** N=4 EP=0 IP=0 FDC=0
.ENDS
***************************************
.SUBCKT ICV_37
** N=4 EP=0 IP=8 FDC=0
.ENDS
***************************************
.SUBCKT FILL1
** N=4 EP=0 IP=0 FDC=0
.ENDS
***************************************
.SUBCKT ICV_130
** N=4 EP=0 IP=12 FDC=0
.ENDS
***************************************
.SUBCKT ICV_131
** N=26 EP=0 IP=529 FDC=0
.ENDS
***************************************
.SUBCKT ICV_115
** N=5 EP=0 IP=8 FDC=0
.ENDS
***************************************
.SUBCKT ICV_116
** N=5 EP=0 IP=10 FDC=0
.ENDS
***************************************
.SUBCKT ICV_120
** N=7 EP=0 IP=10 FDC=0
.ENDS
***************************************
.SUBCKT ICV_121
** N=11 EP=0 IP=14 FDC=0
.ENDS
***************************************
.SUBCKT ICV_127
** N=19 EP=0 IP=22 FDC=0
.ENDS
***************************************
.SUBCKT ICV_128
** N=19 EP=0 IP=38 FDC=0
.ENDS
***************************************
.SUBCKT FILL8
** N=8 EP=0 IP=0 FDC=0
.ENDS
***************************************
.SUBCKT DFFQSRX1 D CLK SETB RESETB VSS VDD Q
** N=34 EP=7 IP=0 FDC=40
M0 VSS D 20 VSS N L=1.8e-07 W=2.2e-07 $X=945 $Y=750 $D=0
M1 10 CLK VSS VSS N L=1.8e-07 W=2.2e-07 $X=1745 $Y=750 $D=0
M2 11 10 20 VSS N L=1.8e-07 W=2.2e-07 $X=3245 $Y=755 $D=0
M3 12 11 VSS VSS N L=1.8e-07 W=2.2e-07 $X=4745 $Y=755 $D=0
M4 13 12 VSS VSS N L=1.8e-07 W=2.2e-07 $X=6250 $Y=760 $D=0
M5 VSS 14 13 VSS N L=1.8e-07 W=2.2e-07 $X=7050 $Y=760 $D=0
M6 15 13 VSS VSS N L=1.8e-07 W=2.2e-07 $X=7850 $Y=1120 $D=0
M7 VSS SETB 14 VSS N L=1.8e-07 W=2.2e-07 $X=9355 $Y=755 $D=0
M8 22 CLK 11 VSS N L=1.8e-07 W=2.2e-07 $X=10860 $Y=750 $D=0
M9 33 15 VSS VSS N L=1.8e-07 W=4.4e-07 $X=12320 $Y=965 $D=0
M10 22 RESETB 33 VSS N L=1.8e-07 W=4.4e-07 $X=13040 $Y=965 $D=0
M11 16 CLK 15 VSS N L=1.8e-07 W=2.2e-07 $X=14500 $Y=755 $D=0
M12 34 16 VSS VSS N L=1.8e-07 W=4.4e-07 $X=15960 $Y=740 $D=0
M13 17 RESETB 34 VSS N L=1.8e-07 W=4.4e-07 $X=16680 $Y=740 $D=0
M14 18 17 VSS VSS N L=1.8e-07 W=2.2e-07 $X=18140 $Y=755 $D=0
M15 19 18 VSS VSS N L=1.8e-07 W=2.2e-07 $X=19640 $Y=755 $D=0
M16 VSS 14 19 VSS N L=1.8e-07 W=2.2e-07 $X=20440 $Y=755 $D=0
M17 24 19 VSS VSS N L=1.8e-07 W=2.2e-07 $X=21240 $Y=755 $D=0
M18 16 10 24 VSS N L=1.8e-07 W=2.2e-07 $X=22740 $Y=755 $D=0
M19 Q 17 VSS VSS N L=1.8e-07 W=2.2e-07 $X=24240 $Y=755 $D=0
M20 VDD D 20 VDD P L=1.8e-07 W=4.4e-07 $X=945 $Y=2705 $D=16
M21 10 CLK VDD VDD P L=1.8e-07 W=4.4e-07 $X=1665 $Y=2705 $D=16
M22 11 CLK 20 VDD P L=1.8e-07 W=4.4e-07 $X=3245 $Y=2725 $D=16
M23 12 11 VDD VDD P L=1.8e-07 W=4.4e-07 $X=4745 $Y=2725 $D=16
M24 21 12 13 VDD P L=1.8e-07 W=8.8e-07 $X=6250 $Y=2300 $D=16
M25 VDD 14 21 VDD P L=1.8e-07 W=8.8e-07 $X=6970 $Y=2300 $D=16
M26 15 13 VDD VDD P L=1.8e-07 W=4.4e-07 $X=7730 $Y=2520 $D=16
M27 VDD SETB 14 VDD P L=1.8e-07 W=4.4e-07 $X=9355 $Y=2535 $D=16
M28 22 10 11 VDD P L=1.8e-07 W=4.4e-07 $X=10815 $Y=2505 $D=16
M29 22 15 VDD VDD P L=1.8e-07 W=4.4e-07 $X=12320 $Y=2505 $D=16
M30 VDD RESETB 22 VDD P L=1.8e-07 W=4.4e-07 $X=13040 $Y=2505 $D=16
M31 16 10 15 VDD P L=1.8e-07 W=4.4e-07 $X=14500 $Y=2505 $D=16
M32 17 16 VDD VDD P L=1.8e-07 W=4.4e-07 $X=15960 $Y=2665 $D=16
M33 VDD RESETB 17 VDD P L=1.8e-07 W=4.4e-07 $X=16680 $Y=2665 $D=16
M34 18 17 VDD VDD P L=1.8e-07 W=4.4e-07 $X=18140 $Y=2725 $D=16
M35 23 18 19 VDD P L=1.8e-07 W=8.8e-07 $X=19640 $Y=2285 $D=16
M36 VDD 14 23 VDD P L=1.8e-07 W=8.8e-07 $X=20360 $Y=2285 $D=16
M37 24 19 VDD VDD P L=1.8e-07 W=4.4e-07 $X=21120 $Y=2505 $D=16
M38 16 CLK 24 VDD P L=1.8e-07 W=4.4e-07 $X=22740 $Y=2505 $D=16
M39 Q 17 VDD VDD P L=1.8e-07 W=4.4e-07 $X=24200 $Y=2505 $D=16
.ENDS
***************************************
.SUBCKT NOR2X1 A B VSS VDD Z
** N=10 EP=5 IP=0 FDC=4
M0 Z A VSS VSS N L=1.8e-07 W=2.2e-07 $X=925 $Y=760 $D=0
M1 VSS B Z VSS N L=1.8e-07 W=2.2e-07 $X=1725 $Y=760 $D=0
M2 8 A VDD VDD P L=1.8e-07 W=8.8e-07 $X=925 $Y=2300 $D=16
M3 Z B 8 VDD P L=1.8e-07 W=8.8e-07 $X=1645 $Y=2300 $D=16
.ENDS
***************************************
.SUBCKT ICV_23
** N=4 EP=0 IP=8 FDC=0
.ENDS
***************************************
.SUBCKT XOR2X1 B A VDD VSS Z
** N=11 EP=5 IP=0 FDC=10
M0 VSS B 10 VSS N L=1.8e-07 W=4.4e-07 $X=630 $Y=985 $D=0
M1 8 A VSS VSS N L=1.8e-07 W=4.4e-07 $X=1350 $Y=985 $D=0
M2 9 8 10 VSS N L=1.8e-07 W=4.4e-07 $X=3205 $Y=1000 $D=0
M3 B A 9 VSS N L=1.8e-07 W=4.4e-07 $X=3925 $Y=1000 $D=0
M4 Z 9 VSS VSS N L=1.8e-07 W=4.4e-07 $X=5345 $Y=1000 $D=0
M5 VDD B 10 VDD P L=1.8e-07 W=4.4e-07 $X=630 $Y=2435 $D=16
M6 8 A VDD VDD P L=1.8e-07 W=4.4e-07 $X=1350 $Y=2435 $D=16
M7 9 A 10 VDD P L=1.8e-07 W=4.4e-07 $X=3205 $Y=2435 $D=16
M8 B 8 9 VDD P L=1.8e-07 W=4.4e-07 $X=3925 $Y=2435 $D=16
M9 Z 9 VDD VDD P L=1.8e-07 W=4.4e-07 $X=5345 $Y=2435 $D=16
.ENDS
***************************************
.SUBCKT NAND2X1 A B VSS VDD Z
** N=9 EP=5 IP=0 FDC=4
M0 9 A VSS VSS N L=1.8e-07 W=4.4e-07 $X=985 $Y=745 $D=0
M1 Z B 9 VSS N L=1.8e-07 W=4.4e-07 $X=1705 $Y=745 $D=0
M2 Z A VDD VDD P L=1.8e-07 W=4.4e-07 $X=985 $Y=2670 $D=16
M3 VDD B Z VDD P L=1.8e-07 W=4.4e-07 $X=1705 $Y=2670 $D=16
.ENDS
***************************************
.SUBCKT INVX2 A VSS VDD Z
** N=6 EP=4 IP=0 FDC=2
M0 Z A VSS VSS N L=1.8e-07 W=4.4e-07 $X=740 $Y=740 $D=0
M1 Z A VDD VDD P L=1.8e-07 W=8.8e-07 $X=740 $Y=2300 $D=16
.ENDS
***************************************
.SUBCKT ICV_33
** N=4 EP=0 IP=8 FDC=0
.ENDS
***************************************
.SUBCKT ICV_125
** N=5 EP=0 IP=13 FDC=0
.ENDS
***************************************
.SUBCKT ICV_126
** N=7 EP=0 IP=10 FDC=0
.ENDS
***************************************
.SUBCKT ICV_24
** N=4 EP=0 IP=8 FDC=0
.ENDS
***************************************
.SUBCKT ICV_123
** N=5 EP=0 IP=8 FDC=0
.ENDS
***************************************
.SUBCKT ICV_124
** N=7 EP=0 IP=10 FDC=0
.ENDS
***************************************
.SUBCKT ICV_129 1 2 3 4 5 6 7 8 9 10 11 12 13 14
** N=71 EP=14 IP=1021 FDC=244
X90 19 10 11 2 1 2 17 DFFQSRX1 $T=759040 568080 0 0 $X=758610 $Y=567690
X91 12 10 11 2 1 2 7 DFFQSRX1 $T=789840 583760 1 0 $X=789410 $Y=579205
X92 24 10 11 2 1 2 23 DFFQSRX1 $T=831840 568080 1 180 $X=806210 $Y=567690
X93 26 10 11 2 1 2 6 DFFQSRX1 $T=835200 575920 1 180 $X=809570 $Y=575530
X94 13 14 11 2 1 2 9 DFFQSRX1 $T=848640 583760 1 0 $X=848210 $Y=579205
X95 3 18 1 2 19 NOR2X1 $T=789280 575920 1 180 $X=786050 $Y=575530
X96 3 25 1 2 24 NOR2X1 $T=814480 575920 1 0 $X=814050 $Y=571365
X97 3 8 1 2 26 NOR2X1 $T=821200 583760 1 0 $X=820770 $Y=579205
X102 20 17 2 1 18 XOR2X1 $T=797120 575920 1 180 $X=790530 $Y=575530
X103 5 23 2 1 25 XOR2X1 $T=815040 583760 1 0 $X=814610 $Y=579205
X104 21 17 1 2 4 NAND2X1 $T=801040 575920 1 180 $X=797810 $Y=575530
X105 22 23 1 2 20 NAND2X1 $T=803840 575920 0 0 $X=803410 $Y=575530
X106 20 1 2 21 INVX2 $T=799360 575920 1 0 $X=798930 $Y=571365
X107 5 1 2 22 INVX2 $T=809440 575920 1 180 $X=807330 $Y=575530
.ENDS
***************************************
.SUBCKT ICV_67
** N=4 EP=0 IP=8 FDC=0
.ENDS
***************************************
.SUBCKT ICV_117
** N=4 EP=0 IP=8 FDC=0
.ENDS
***************************************
.SUBCKT ICV_39
** N=4 EP=0 IP=8 FDC=0
.ENDS
***************************************
.SUBCKT ICV_114
** N=4 EP=0 IP=8 FDC=0
.ENDS
***************************************
.SUBCKT ICV_42
** N=4 EP=0 IP=8 FDC=0
.ENDS
***************************************
.SUBCKT ICV_113
** N=4 EP=0 IP=8 FDC=0
.ENDS
***************************************
.SUBCKT ICV_35
** N=4 EP=0 IP=8 FDC=0
.ENDS
***************************************
.SUBCKT ICV_119 1 2 3 4 5 6 7
** N=9 EP=7 IP=13 FDC=40
X0 4 7 5 6 1 2 3 DFFQSRX1 $T=1680 0 0 0 $X=1250 $Y=-390
.ENDS
***************************************
.SUBCKT OR2X1 A B VSS VDD Z
** N=12 EP=5 IP=0 FDC=6
M0 8 A VSS VSS N L=1.8e-07 W=2.2e-07 $X=835 $Y=760 $D=0
M1 VSS B 8 VSS N L=1.8e-07 W=2.2e-07 $X=1635 $Y=760 $D=0
M2 Z 8 VSS VSS N L=1.8e-07 W=2.2e-07 $X=2435 $Y=760 $D=0
M3 9 A 8 VDD P L=1.8e-07 W=8.8e-07 $X=835 $Y=2300 $D=16
M4 VDD B 9 VDD P L=1.8e-07 W=8.8e-07 $X=1555 $Y=2300 $D=16
M5 Z 8 VDD VDD P L=1.8e-07 W=4.4e-07 $X=2315 $Y=2520 $D=16
.ENDS
***************************************
.SUBCKT ICV_38
** N=4 EP=0 IP=8 FDC=0
.ENDS
***************************************
.SUBCKT MUX2X1 A S B VSS VDD Z
** N=16 EP=6 IP=0 FDC=12
M0 VSS S 9 VSS N L=1.8e-07 W=4.4e-07 $X=940 $Y=960 $D=0
M1 15 A VSS VSS N L=1.8e-07 W=4.4e-07 $X=1660 $Y=960 $D=0
M2 10 9 15 VSS N L=1.8e-07 W=4.4e-07 $X=2380 $Y=960 $D=0
M3 16 S 10 VSS N L=1.8e-07 W=4.4e-07 $X=3100 $Y=960 $D=0
M4 VSS B 16 VSS N L=1.8e-07 W=4.4e-07 $X=3920 $Y=740 $D=0
M5 Z 10 VSS VSS N L=1.8e-07 W=4.4e-07 $X=4640 $Y=740 $D=0
M6 VDD S 9 VDD P L=1.8e-07 W=4.4e-07 $X=940 $Y=2520 $D=16
M7 11 A VDD VDD P L=1.8e-07 W=4.4e-07 $X=1660 $Y=2520 $D=16
M8 10 S 11 VDD P L=1.8e-07 W=4.4e-07 $X=2380 $Y=2520 $D=16
M9 12 9 10 VDD P L=1.8e-07 W=4.4e-07 $X=3100 $Y=2520 $D=16
M10 VDD B 12 VDD P L=1.8e-07 W=4.4e-07 $X=3920 $Y=2735 $D=16
M11 Z 10 VDD VDD P L=1.8e-07 W=4.4e-07 $X=4640 $Y=2735 $D=16
.ENDS
***************************************
.SUBCKT ICV_118 1 2 3 4 5 6
** N=8 EP=6 IP=13 FDC=40
X1 4 6 5 2 1 2 3 DFFQSRX1 $T=560 0 0 0 $X=130 $Y=-390
.ENDS
***************************************
.SUBCKT NAND3X1 A B C VSS VDD Z
** N=10 EP=6 IP=0 FDC=6
M0 9 A VSS VSS N L=1.8e-07 W=6.6e-07 $X=1210 $Y=745 $D=0
M1 10 B 9 VSS N L=1.8e-07 W=6.6e-07 $X=1930 $Y=745 $D=0
M2 Z C 10 VSS N L=1.8e-07 W=6.6e-07 $X=2650 $Y=745 $D=0
M3 Z A VDD VDD P L=1.8e-07 W=4.4e-07 $X=1210 $Y=2670 $D=16
M4 VDD B Z VDD P L=1.8e-07 W=4.4e-07 $X=1930 $Y=2670 $D=16
M5 Z C VDD VDD P L=1.8e-07 W=4.4e-07 $X=2650 $Y=2670 $D=16
.ENDS
***************************************
.SUBCKT BUFX1 A VSS VDD Z
** N=7 EP=4 IP=0 FDC=4
M0 VSS A 7 VSS N L=1.8e-07 W=2.2e-07 $X=925 $Y=760 $D=0
M1 Z 7 VSS VSS N L=1.8e-07 W=2.2e-07 $X=1725 $Y=760 $D=0
M2 VDD A 7 VDD P L=1.8e-07 W=4.4e-07 $X=925 $Y=2715 $D=16
M3 Z 7 VDD VDD P L=1.8e-07 W=4.4e-07 $X=1645 $Y=2715 $D=16
.ENDS
***************************************
.SUBCKT ICV_49
** N=4 EP=0 IP=8 FDC=0
.ENDS
***************************************
.SUBCKT ANTENNA VSS A
** N=5 EP=2 IP=0 FDC=1
*.CALIBRE ISOLATED NETS: VDD
D0 VSS A DN AREA=3.9e-13 PJ=2.54e-06 $X=300 $Y=655 $D=26
.ENDS
***************************************
.SUBCKT AND2X1 A B VSS VDD Z
** N=10 EP=5 IP=0 FDC=6
M0 10 A 8 VSS N L=1.8e-07 W=4.4e-07 $X=905 $Y=750 $D=0
M1 VSS B 10 VSS N L=1.8e-07 W=4.4e-07 $X=1625 $Y=750 $D=0
M2 Z 8 VSS VSS N L=1.8e-07 W=2.2e-07 $X=2385 $Y=860 $D=0
M3 8 A VDD VDD P L=1.8e-07 W=4.4e-07 $X=905 $Y=2670 $D=16
M4 VDD B 8 VDD P L=1.8e-07 W=4.4e-07 $X=1625 $Y=2670 $D=16
M5 Z 8 VDD VDD P L=1.8e-07 W=4.4e-07 $X=2385 $Y=2670 $D=16
.ENDS
***************************************
.SUBCKT ICV_47
** N=4 EP=0 IP=8 FDC=0
.ENDS
***************************************
.SUBCKT ICV_122 1 2 3 4 5 6 7 8 9 10 11 12 13 14 15 16 17 18 19 20
+ 21 22 23 24 25 26 27 28 29 30 31 32 33 34 35 36 37 38 39 40
+ 41 42 43 44 45 46 47 48 49 50 51 52 53 54 55 56 57 58 59 60
+ 61 62 63 64 65 66 67 68 69 70 71 72 73 74 75 76 77 78 79 80
+ 81 82 83 84 85 86 87 88 89 90 91 92 93 94 95 96 97 98 99 100
+ 101 102 103 104 105 106 107 108 109 110 111 112 113 114 115 116 117 118 119 120
+ 121 122 123 124 125 126 127 128 129 130 131 132 133 134 135 136 140 141 142 143
+ 144 146 147 148 149 150 151 152 153 154
** N=674 EP=150 IP=7589 FDC=8778
X477 193 140 141 2 1 2 5 DFFQSRX1 $T=603360 701360 1 0 $X=602930 $Y=696805
X478 194 140 141 2 1 2 187 DFFQSRX1 $T=603360 709200 1 0 $X=602930 $Y=704645
X479 189 140 141 2 1 2 4 DFFQSRX1 $T=603360 717040 1 0 $X=602930 $Y=712485
X480 212 235 141 2 1 2 192 DFFQSRX1 $T=642000 685680 0 180 $X=616370 $Y=681125
X481 206 235 141 2 1 2 191 DFFQSRX1 $T=642560 677840 0 180 $X=616930 $Y=673285
X482 15 236 2 141 1 2 200 DFFQSRX1 $T=649280 615120 1 180 $X=623650 $Y=614730
X483 216 236 2 141 1 2 201 DFFQSRX1 $T=649280 638640 1 180 $X=623650 $Y=638250
X484 219 236 141 2 1 2 202 DFFQSRX1 $T=649280 646480 1 180 $X=623650 $Y=646090
X485 223 236 141 2 1 2 203 DFFQSRX1 $T=649840 654320 1 180 $X=624210 $Y=653930
X486 220 235 141 2 1 2 204 DFFQSRX1 $T=650400 693520 1 180 $X=624770 $Y=693130
X487 143 235 141 2 1 2 11 DFFQSRX1 $T=632480 717040 0 0 $X=632050 $Y=716650
X488 229 236 141 2 1 2 214 DFFQSRX1 $T=659920 662160 0 180 $X=634290 $Y=657605
X489 233 35 141 2 1 2 210 DFFQSRX1 $T=673360 701360 0 180 $X=647730 $Y=696805
X490 248 35 141 2 1 2 247 DFFQSRX1 $T=678960 638640 0 0 $X=678530 $Y=638250
X491 238 35 141 2 1 2 237 DFFQSRX1 $T=678960 677840 0 0 $X=678530 $Y=677450
X492 243 147 141 2 1 2 249 DFFQSRX1 $T=678960 701360 0 0 $X=678530 $Y=700970
X493 146 147 141 2 1 2 25 DFFQSRX1 $T=678960 724880 1 0 $X=678530 $Y=720325
X494 251 35 141 2 1 2 253 DFFQSRX1 $T=682880 630800 0 0 $X=682450 $Y=630410
X495 252 35 141 2 1 2 20 DFFQSRX1 $T=683440 654320 0 0 $X=683010 $Y=653930
X496 258 35 141 2 1 2 257 DFFQSRX1 $T=687360 615120 0 0 $X=686930 $Y=614730
X497 263 281 141 2 1 2 21 DFFQSRX1 $T=720960 685680 1 180 $X=695330 $Y=685290
X498 254 147 141 2 1 2 23 DFFQSRX1 $T=696880 701360 1 0 $X=696450 $Y=696805
X499 270 297 141 2 1 2 22 DFFQSRX1 $T=722080 709200 0 180 $X=696450 $Y=704645
X500 267 297 141 2 1 2 24 DFFQSRX1 $T=724880 709200 1 180 $X=699250 $Y=708810
X501 148 297 141 2 1 2 129 DFFQSRX1 $T=729360 724880 0 180 $X=703730 $Y=720325
X502 269 35 141 2 1 2 265 DFFQSRX1 $T=708640 638640 0 0 $X=708210 $Y=638250
X503 271 35 141 2 1 2 261 DFFQSRX1 $T=709200 622960 0 0 $X=708770 $Y=622570
X504 290 35 141 2 1 2 268 DFFQSRX1 $T=741680 646480 1 180 $X=716050 $Y=646090
X505 275 281 141 2 1 2 278 DFFQSRX1 $T=717040 662160 0 0 $X=716610 $Y=661770
X506 289 293 141 2 1 2 27 DFFQSRX1 $T=742800 677840 1 180 $X=717170 $Y=677450
X507 302 297 141 2 1 2 28 DFFQSRX1 $T=743920 717040 0 180 $X=718290 $Y=712485
X508 272 35 141 2 1 2 30 DFFQSRX1 $T=723200 646480 1 0 $X=722770 $Y=641925
X509 292 297 141 2 1 2 29 DFFQSRX1 $T=748960 709200 0 180 $X=723330 $Y=704645
X510 285 35 141 2 1 2 273 DFFQSRX1 $T=751760 622960 0 180 $X=726130 $Y=618405
X511 299 35 141 2 1 2 298 DFFQSRX1 $T=732160 607280 0 0 $X=731730 $Y=606890
X512 301 293 141 2 1 2 303 DFFQSRX1 $T=743360 654320 1 0 $X=742930 $Y=649765
X513 284 297 141 2 1 2 280 DFFQSRX1 $T=744480 701360 1 0 $X=744050 $Y=696805
X514 304 35 141 2 1 2 300 DFFQSRX1 $T=771920 670000 0 180 $X=746290 $Y=665445
X515 306 35 141 2 1 2 34 DFFQSRX1 $T=771920 685680 1 180 $X=746290 $Y=685290
X516 305 293 141 2 1 2 313 DFFQSRX1 $T=748400 677840 0 0 $X=747970 $Y=677450
X517 308 35 141 2 1 2 286 DFFQSRX1 $T=751200 646480 1 0 $X=750770 $Y=641925
X518 309 297 141 2 1 2 316 DFFQSRX1 $T=751200 709200 1 0 $X=750770 $Y=704645
X519 324 35 141 2 1 2 294 DFFQSRX1 $T=779760 630800 0 180 $X=754130 $Y=626245
X520 317 35 141 2 1 2 312 DFFQSRX1 $T=756240 622960 1 0 $X=755810 $Y=618405
X521 319 35 141 2 1 2 307 DFFQSRX1 $T=784240 630800 1 180 $X=758610 $Y=630410
X522 328 293 141 2 1 2 331 DFFQSRX1 $T=759040 662160 0 0 $X=758610 $Y=661770
X523 322 35 141 2 1 2 36 DFFQSRX1 $T=759040 717040 1 0 $X=758610 $Y=712485
X524 329 349 141 2 1 2 320 DFFQSRX1 $T=798800 638640 0 180 $X=773170 $Y=634085
X525 333 35 141 2 1 2 335 DFFQSRX1 $T=774720 622960 0 0 $X=774290 $Y=622570
X526 326 35 141 2 1 2 347 DFFQSRX1 $T=789840 591600 1 0 $X=789410 $Y=587045
X527 342 35 141 2 1 2 340 DFFQSRX1 $T=789840 607280 0 0 $X=789410 $Y=606890
X528 352 35 141 2 1 2 345 DFFQSRX1 $T=789840 615120 0 0 $X=789410 $Y=614730
X529 338 35 141 2 1 2 38 DFFQSRX1 $T=789840 646480 0 0 $X=789410 $Y=646090
X530 325 349 141 2 1 2 334 DFFQSRX1 $T=789840 670000 0 0 $X=789410 $Y=669610
X531 346 35 141 2 1 2 330 DFFQSRX1 $T=789840 685680 0 0 $X=789410 $Y=685290
X532 388 349 141 2 1 2 403 DFFQSRX1 $T=803280 638640 1 0 $X=802850 $Y=634085
X533 387 467 141 2 1 2 363 DFFQSRX1 $T=829040 622960 1 180 $X=803410 $Y=622570
X534 372 349 141 2 1 2 413 DFFQSRX1 $T=804400 646480 1 0 $X=803970 $Y=641925
X535 367 349 141 2 1 2 79 DFFQSRX1 $T=805520 654320 1 0 $X=805090 $Y=649765
X536 386 35 141 2 1 2 408 DFFQSRX1 $T=809440 607280 1 0 $X=809010 $Y=602725
X537 419 35 141 2 1 2 379 DFFQSRX1 $T=835200 591600 1 180 $X=809570 $Y=591210
X538 453 467 141 2 1 2 455 DFFQSRX1 $T=817840 615120 0 0 $X=817410 $Y=614730
X539 456 149 141 2 1 2 77 DFFQSRX1 $T=854240 685680 1 180 $X=828610 $Y=685290
X540 463 474 141 2 1 2 440 DFFQSRX1 $T=860400 638640 0 180 $X=834770 $Y=634085
X541 460 467 141 2 1 2 478 DFFQSRX1 $T=835760 599440 0 0 $X=835330 $Y=599050
X542 461 474 141 2 1 2 477 DFFQSRX1 $T=843040 662160 1 0 $X=842610 $Y=657605
X543 469 149 141 2 1 2 88 DFFQSRX1 $T=843600 677840 1 0 $X=843170 $Y=673285
X544 492 149 141 2 1 2 85 DFFQSRX1 $T=873840 701360 1 180 $X=848210 $Y=700970
X545 476 149 141 2 1 2 480 DFFQSRX1 $T=848640 717040 1 0 $X=848210 $Y=712485
X546 479 149 141 2 1 2 482 DFFQSRX1 $T=849200 677840 0 0 $X=848770 $Y=677450
X547 487 495 141 2 1 2 466 DFFQSRX1 $T=875520 630800 0 180 $X=849890 $Y=626245
X548 471 467 141 2 1 2 488 DFFQSRX1 $T=854240 615120 1 0 $X=853810 $Y=610565
X549 489 495 141 2 1 2 530 DFFQSRX1 $T=866000 607280 1 0 $X=865570 $Y=602725
X550 505 495 141 2 1 2 513 DFFQSRX1 $T=867120 638640 1 0 $X=866690 $Y=634085
X551 536 151 141 2 1 2 497 DFFQSRX1 $T=895680 591600 1 180 $X=870050 $Y=591210
X552 529 495 141 2 1 2 498 DFFQSRX1 $T=895680 607280 1 180 $X=870050 $Y=606890
X553 519 542 141 2 1 2 499 DFFQSRX1 $T=895680 662160 1 180 $X=870050 $Y=661770
X554 510 542 141 2 1 2 500 DFFQSRX1 $T=895680 670000 1 180 $X=870050 $Y=669610
X555 522 542 141 2 1 2 501 DFFQSRX1 $T=895680 685680 0 180 $X=870050 $Y=681125
X556 534 495 141 2 1 2 548 DFFQSRX1 $T=883920 622960 0 0 $X=883490 $Y=622570
X557 526 100 141 2 1 2 90 DFFQSRX1 $T=897360 717040 1 0 $X=896930 $Y=712485
X558 152 100 141 2 1 2 97 DFFQSRX1 $T=922560 717040 1 180 $X=896930 $Y=716650
X559 537 540 141 2 1 2 570 DFFQSRX1 $T=901280 638640 1 0 $X=900850 $Y=634085
X560 543 540 141 2 1 2 547 DFFQSRX1 $T=901280 646480 1 0 $X=900850 $Y=641925
X561 544 540 141 2 1 2 549 DFFQSRX1 $T=901280 654320 1 0 $X=900850 $Y=649765
X562 545 542 141 2 1 2 550 DFFQSRX1 $T=901280 670000 1 0 $X=900850 $Y=665445
X563 539 542 141 2 1 2 99 DFFQSRX1 $T=901280 685680 0 0 $X=900850 $Y=685290
X564 520 542 141 2 1 2 95 DFFQSRX1 $T=901280 701360 1 0 $X=900850 $Y=696805
X565 562 151 141 2 1 2 558 DFFQSRX1 $T=904640 591600 1 0 $X=904210 $Y=587045
X566 579 151 141 2 1 2 556 DFFQSRX1 $T=941040 591600 1 180 $X=915410 $Y=591210
X567 587 151 141 2 1 2 561 DFFQSRX1 $T=942720 607280 1 180 $X=917090 $Y=606890
X568 563 151 141 2 1 2 588 DFFQSRX1 $T=918080 622960 0 0 $X=917650 $Y=622570
X569 574 540 141 2 1 2 591 DFFQSRX1 $T=919200 638640 0 0 $X=918770 $Y=638250
X570 566 100 141 2 1 2 572 DFFQSRX1 $T=921440 693520 0 0 $X=921010 $Y=693130
X571 592 582 141 2 1 2 565 DFFQSRX1 $T=947200 662160 0 180 $X=921570 $Y=657605
X572 584 100 141 2 1 2 590 DFFQSRX1 $T=922000 685680 1 0 $X=921570 $Y=681125
X573 554 100 141 2 1 2 560 DFFQSRX1 $T=922000 709200 1 0 $X=921570 $Y=704645
X574 583 582 141 2 1 2 589 DFFQSRX1 $T=926480 677840 1 0 $X=926050 $Y=673285
X575 605 582 141 2 1 2 623 DFFQSRX1 $T=949440 677840 0 0 $X=949010 $Y=677450
X576 616 151 141 2 1 2 608 DFFQSRX1 $T=984160 630800 1 180 $X=958530 $Y=630410
X577 618 154 141 2 1 2 634 DFFQSRX1 $T=962880 701360 0 0 $X=962450 $Y=700970
X578 153 154 141 2 1 2 130 DFFQSRX1 $T=963440 724880 1 0 $X=963010 $Y=720325
X579 631 151 141 2 1 2 612 DFFQSRX1 $T=989200 638640 1 180 $X=963570 $Y=638250
X580 617 151 141 2 1 2 619 DFFQSRX1 $T=966240 646480 0 0 $X=965810 $Y=646090
X581 624 151 141 2 1 2 628 DFFQSRX1 $T=966800 670000 1 0 $X=966370 $Y=665445
X582 637 151 141 2 1 2 630 DFFQSRX1 $T=1006560 685680 1 180 $X=980930 $Y=685290
X583 187 190 1 2 189 NOR2X1 $T=611760 693520 1 0 $X=611330 $Y=688965
X584 187 195 1 2 193 NOR2X1 $T=615680 693520 0 0 $X=615250 $Y=693130
X585 7 6 1 2 199 NOR2X1 $T=629120 701360 1 180 $X=625890 $Y=700970
X586 209 211 1 2 206 NOR2X1 $T=630800 677840 0 0 $X=630370 $Y=677450
X587 204 7 1 2 213 NOR2X1 $T=634160 701360 1 180 $X=630930 $Y=700970
X588 218 6 1 2 215 NOR2X1 $T=637520 709200 0 180 $X=634290 $Y=704645
X589 201 221 1 2 219 NOR2X1 $T=635280 630800 0 0 $X=634850 $Y=630410
X590 213 8 1 2 220 NOR2X1 $T=635280 701360 1 0 $X=634850 $Y=696805
X591 214 211 1 2 8 NOR2X1 $T=639760 677840 1 180 $X=636530 $Y=677450
X592 218 204 1 2 222 NOR2X1 $T=639760 701360 1 180 $X=636530 $Y=700970
X593 215 8 1 2 226 NOR2X1 $T=640320 709200 1 0 $X=639890 $Y=704645
X594 214 224 1 2 9 NOR2X1 $T=643680 677840 0 0 $X=643250 $Y=677450
X595 209 225 1 2 10 NOR2X1 $T=648160 685680 0 180 $X=644930 $Y=681125
X596 15 339 1 2 39 NOR2X1 $T=787040 591600 1 0 $X=786610 $Y=587045
X597 43 353 1 2 355 NOR2X1 $T=799360 709200 0 180 $X=796130 $Y=704645
X598 359 47 1 2 354 NOR2X1 $T=802160 709200 1 180 $X=798930 $Y=708810
X599 364 355 1 2 369 NOR2X1 $T=804400 701360 0 0 $X=803970 $Y=700970
X600 383 377 1 2 382 NOR2X1 $T=812240 701360 1 180 $X=809010 $Y=700970
X601 390 369 1 2 383 NOR2X1 $T=813360 701360 0 180 $X=810130 $Y=696805
X602 359 55 1 2 385 NOR2X1 $T=813360 717040 0 180 $X=810130 $Y=712485
X603 394 398 1 2 395 NOR2X1 $T=813360 599440 1 0 $X=812930 $Y=594885
X604 408 379 1 2 394 NOR2X1 $T=819520 599440 1 180 $X=816290 $Y=599050
X605 15 379 1 2 419 NOR2X1 $T=823440 599440 0 180 $X=820210 $Y=594885
X606 414 421 1 2 417 NOR2X1 $T=820640 701360 0 0 $X=820210 $Y=700970
X607 67 407 1 2 414 NOR2X1 $T=824000 709200 0 180 $X=820770 $Y=704645
X608 451 406 1 2 439 NOR2X1 $T=840800 701360 1 180 $X=837570 $Y=700970
X609 391 452 1 2 131 NOR2X1 $T=839680 724880 1 0 $X=839250 $Y=720325
X610 569 571 1 2 568 NOR2X1 $T=924240 717040 0 0 $X=923810 $Y=716650
X611 124 123 1 2 581 NOR2X1 $T=961760 717040 1 180 $X=958530 $Y=716650
X706 44 41 2 1 339 XOR2X1 $T=799360 583760 1 180 $X=792770 $Y=583370
X707 412 413 2 1 420 XOR2X1 $T=818960 677840 1 0 $X=818530 $Y=673285
X708 410 64 2 1 73 XOR2X1 $T=819520 583760 0 0 $X=819090 $Y=583370
X709 47 359 2 1 418 XOR2X1 $T=819520 717040 1 0 $X=819090 $Y=712485
X710 437 444 2 1 432 XOR2X1 $T=838000 677840 0 180 $X=831410 $Y=673285
X711 87 477 2 1 472 XOR2X1 $T=857600 693520 0 0 $X=857170 $Y=693130
X712 504 502 2 1 485 XOR2X1 $T=874400 670000 0 180 $X=867810 $Y=665445
X713 92 500 2 1 531 XOR2X1 $T=887280 693520 0 0 $X=886850 $Y=693130
X714 551 501 2 1 517 XOR2X1 $T=911360 709200 0 180 $X=904770 $Y=704645
X715 188 191 1 2 190 NAND2X1 $T=612320 685680 0 0 $X=611890 $Y=685290
X716 196 3 1 2 194 NAND2X1 $T=618480 701360 1 180 $X=615250 $Y=700970
X717 198 191 1 2 195 NAND2X1 $T=619600 693520 0 180 $X=616370 $Y=688965
X718 197 192 1 2 188 NAND2X1 $T=617920 685680 0 0 $X=617490 $Y=685290
X719 199 187 1 2 196 NAND2X1 $T=623520 701360 1 180 $X=620290 $Y=700970
X720 207 203 1 2 205 NAND2X1 $T=629680 662160 1 180 $X=626450 $Y=661770
X721 208 202 1 2 211 NAND2X1 $T=632480 670000 0 0 $X=632050 $Y=669610
X722 203 202 1 2 224 NAND2X1 $T=640320 670000 1 180 $X=637090 $Y=669610
X723 228 214 1 2 227 NAND2X1 $T=645920 670000 0 180 $X=642690 $Y=665445
X724 230 227 1 2 229 NAND2X1 $T=650400 670000 0 180 $X=647170 $Y=665445
X725 26 250 1 2 262 NAND2X1 $T=713120 693520 0 180 $X=709890 $Y=688965
X726 26 279 1 2 318 NAND2X1 $T=769120 693520 0 180 $X=765890 $Y=688965
X727 12 327 1 2 326 NAND2X1 $T=779760 599440 0 0 $X=779330 $Y=599050
X728 26 280 1 2 332 NAND2X1 $T=785360 693520 0 180 $X=782130 $Y=688965
X729 40 318 1 2 341 NAND2X1 $T=790400 693520 1 180 $X=787170 $Y=693130
X730 344 41 1 2 343 NAND2X1 $T=790400 583760 0 0 $X=789970 $Y=583370
X731 40 332 1 2 351 NAND2X1 $T=796560 693520 1 180 $X=793330 $Y=693130
X732 46 303 1 2 356 NAND2X1 $T=800480 654320 1 180 $X=797250 $Y=653930
X733 46 260 1 2 357 NAND2X1 $T=800480 670000 0 180 $X=797250 $Y=665445
X734 40 262 1 2 360 NAND2X1 $T=802720 693520 0 180 $X=799490 $Y=688965
X735 47 49 1 2 48 NAND2X1 $T=799920 724880 1 0 $X=799490 $Y=720325
X736 355 49 1 2 362 NAND2X1 $T=801040 717040 0 0 $X=800610 $Y=716650
X737 46 320 1 2 366 NAND2X1 $T=806640 654320 1 180 $X=803410 $Y=653930
X738 354 52 1 2 368 NAND2X1 $T=803840 709200 0 0 $X=803410 $Y=708810
X739 46 278 1 2 373 NAND2X1 $T=808320 677840 0 180 $X=805090 $Y=673285
X740 50 53 1 2 51 NAND2X1 $T=808880 717040 1 180 $X=805650 $Y=716650
X741 358 384 1 2 381 NAND2X1 $T=809440 677840 1 0 $X=809010 $Y=673285
X742 389 56 1 2 384 NAND2X1 $T=813360 685680 0 180 $X=810130 $Y=681125
X743 60 57 1 2 55 NAND2X1 $T=813360 724880 0 180 $X=810130 $Y=720325
X744 26 62 1 2 389 NAND2X1 $T=812240 693520 1 0 $X=811810 $Y=688965
X745 378 63 1 2 393 NAND2X1 $T=812240 709200 1 0 $X=811810 $Y=704645
X746 46 277 1 2 396 NAND2X1 $T=815600 662160 0 180 $X=812370 $Y=657605
X747 61 65 1 2 375 NAND2X1 $T=813360 662160 0 0 $X=812930 $Y=661770
X748 365 402 1 2 399 NAND2X1 $T=813920 685680 1 0 $X=813490 $Y=681125
X749 398 64 1 2 66 NAND2X1 $T=817280 583760 1 180 $X=814050 $Y=583370
X750 46 363 1 2 404 NAND2X1 $T=814480 654320 0 0 $X=814050 $Y=653930
X751 405 381 1 2 400 NAND2X1 $T=817280 677840 0 180 $X=814050 $Y=673285
X752 380 52 1 2 401 NAND2X1 $T=814480 693520 0 0 $X=814050 $Y=693130
X753 385 67 1 2 392 NAND2X1 $T=815040 709200 0 0 $X=814610 $Y=708810
X754 371 67 1 2 397 NAND2X1 $T=815040 717040 1 0 $X=814610 $Y=712485
X755 409 56 1 2 402 NAND2X1 $T=819520 685680 1 180 $X=816290 $Y=685290
X756 45 413 1 2 376 NAND2X1 $T=818400 662160 1 0 $X=817970 $Y=657605
X757 26 65 1 2 409 NAND2X1 $T=818960 693520 1 0 $X=818530 $Y=688965
X758 416 399 1 2 415 NAND2X1 $T=822880 685680 0 180 $X=819650 $Y=681125
X759 61 71 1 2 370 NAND2X1 $T=820640 662160 0 0 $X=820210 $Y=661770
X760 420 61 1 2 416 NAND2X1 $T=823440 677840 1 180 $X=820210 $Y=677450
X761 379 408 1 2 410 NAND2X1 $T=821760 599440 0 0 $X=821330 $Y=599050
X762 46 331 1 2 424 NAND2X1 $T=826240 662160 0 180 $X=823010 $Y=657605
X763 26 71 1 2 425 NAND2X1 $T=825120 693520 1 0 $X=824690 $Y=688965
X764 74 359 1 2 426 NAND2X1 $T=826800 709200 1 0 $X=826370 $Y=704645
X765 76 59 1 2 427 NAND2X1 $T=829600 724880 0 180 $X=826370 $Y=720325
X766 45 79 1 2 374 NAND2X1 $T=827360 662160 0 0 $X=826930 $Y=661770
X767 432 61 1 2 405 NAND2X1 $T=830160 677840 0 180 $X=826930 $Y=673285
X768 425 56 1 2 429 NAND2X1 $T=827360 693520 0 0 $X=826930 $Y=693130
X769 361 429 1 2 78 NAND2X1 $T=827360 701360 1 0 $X=826930 $Y=696805
X770 82 59 1 2 438 NAND2X1 $T=836320 709200 1 180 $X=833090 $Y=708810
X771 45 444 1 2 447 NAND2X1 $T=837440 662160 0 0 $X=837010 $Y=661770
X772 360 442 1 2 448 NAND2X1 $T=840800 693520 1 180 $X=837570 $Y=693130
X773 82 359 1 2 449 NAND2X1 $T=840800 709200 1 180 $X=837570 $Y=708810
X774 61 62 1 2 450 NAND2X1 $T=839680 670000 1 0 $X=839250 $Y=665445
X775 457 448 1 2 456 NAND2X1 $T=845280 693520 1 180 $X=842050 $Y=693130
X776 61 77 1 2 459 NAND2X1 $T=845280 670000 1 0 $X=844850 $Y=665445
X777 46 316 1 2 86 NAND2X1 $T=850880 709200 1 180 $X=847650 $Y=708810
X778 472 61 1 2 457 NAND2X1 $T=853120 693520 0 0 $X=852690 $Y=693130
X779 45 477 1 2 464 NAND2X1 $T=856480 662160 0 0 $X=856050 $Y=661770
X780 45 88 1 2 470 NAND2X1 $T=857600 670000 1 0 $X=857170 $Y=665445
X781 61 88 1 2 483 NAND2X1 $T=862640 662160 0 0 $X=862210 $Y=661770
X782 485 61 1 2 473 NAND2X1 $T=865440 670000 0 180 $X=862210 $Y=665445
X783 351 491 1 2 490 NAND2X1 $T=866000 693520 0 0 $X=865570 $Y=693130
X784 493 490 1 2 492 NAND2X1 $T=869360 709200 1 180 $X=866130 $Y=708810
X785 45 502 1 2 484 NAND2X1 $T=868800 654320 0 0 $X=868370 $Y=653930
X786 46 403 1 2 496 NAND2X1 $T=871600 693520 0 180 $X=868370 $Y=688965
X787 46 334 1 2 503 NAND2X1 $T=873840 685680 1 180 $X=870610 $Y=685290
X788 341 507 1 2 509 NAND2X1 $T=879440 701360 0 180 $X=876210 $Y=696805
X789 61 90 1 2 511 NAND2X1 $T=877200 685680 0 0 $X=876770 $Y=685290
X790 46 482 1 2 512 NAND2X1 $T=880000 693520 0 180 $X=876770 $Y=688965
X791 517 61 1 2 493 NAND2X1 $T=881120 709200 0 0 $X=880690 $Y=708810
X792 61 85 1 2 518 NAND2X1 $T=881680 693520 0 0 $X=881250 $Y=693130
X793 61 91 1 2 521 NAND2X1 $T=883360 709200 1 0 $X=882930 $Y=704645
X794 45 500 1 2 515 NAND2X1 $T=885600 677840 1 0 $X=885170 $Y=673285
X795 527 509 1 2 526 NAND2X1 $T=889520 709200 1 180 $X=886290 $Y=708810
X796 45 94 1 2 93 NAND2X1 $T=887840 724880 1 0 $X=887410 $Y=720325
X797 45 95 1 2 524 NAND2X1 $T=888400 701360 0 0 $X=887970 $Y=700970
X798 45 501 1 2 523 NAND2X1 $T=890080 693520 1 0 $X=889650 $Y=688965
X799 533 56 1 2 532 NAND2X1 $T=894560 709200 1 180 $X=891330 $Y=708810
X800 525 532 1 2 96 NAND2X1 $T=891760 717040 0 0 $X=891330 $Y=716650
X801 531 61 1 2 527 NAND2X1 $T=894000 701360 0 0 $X=893570 $Y=700970
X802 26 97 1 2 533 NAND2X1 $T=897920 709200 0 0 $X=897490 $Y=708810
X803 61 97 1 2 538 NAND2X1 $T=900160 709200 1 0 $X=899730 $Y=704645
X804 45 99 1 2 541 NAND2X1 $T=906880 693520 0 0 $X=906450 $Y=693130
X805 101 102 1 2 564 NAND2X1 $T=919760 724880 1 0 $X=919330 $Y=720325
X806 593 111 1 2 573 NAND2X1 $T=936000 717040 1 0 $X=935570 $Y=712485
X807 112 586 1 2 593 NAND2X1 $T=939920 717040 1 180 $X=936690 $Y=716650
X808 113 115 1 2 595 NAND2X1 $T=941040 724880 1 0 $X=940610 $Y=720325
X809 602 121 1 2 609 NAND2X1 $T=955600 724880 0 180 $X=952370 $Y=720325
X810 609 604 1 2 122 NAND2X1 $T=956160 717040 1 180 $X=952930 $Y=716650
X811 4 1 2 197 INVX2 $T=617360 709200 0 0 $X=616930 $Y=708810
X812 203 1 2 208 INVX2 $T=628560 670000 0 0 $X=628130 $Y=669610
X813 202 1 2 207 INVX2 $T=633040 662160 1 180 $X=630930 $Y=661770
X814 216 1 2 221 INVX2 $T=635840 630800 1 0 $X=635410 $Y=626245
X815 214 1 2 209 INVX2 $T=649840 677840 1 180 $X=647730 $Y=677450
X816 9 1 2 230 INVX2 $T=648720 670000 0 0 $X=648290 $Y=669610
X817 354 1 2 353 INVX2 $T=797120 709200 0 0 $X=796690 $Y=708810
X818 44 1 2 344 INVX2 $T=801040 583760 1 180 $X=798930 $Y=583370
X819 51 1 2 378 INVX2 $T=808320 709200 0 0 $X=807890 $Y=708810
X820 369 1 2 380 INVX2 $T=809440 693520 0 0 $X=809010 $Y=693130
X821 59 1 2 359 INVX2 $T=812800 709200 1 180 $X=810690 $Y=708810
X822 385 1 2 407 INVX2 $T=817280 709200 1 0 $X=816850 $Y=704645
X823 69 1 2 390 INVX2 $T=818960 717040 1 180 $X=816850 $Y=716650
X824 410 1 2 398 INVX2 $T=819520 591600 0 180 $X=817410 $Y=587045
X825 15 1 2 348 INVX2 $T=827360 599440 0 0 $X=826930 $Y=599050
X826 50 1 2 436 INVX2 $T=832400 717040 0 0 $X=831970 $Y=716650
X827 580 1 2 575 INVX2 $T=930960 717040 1 180 $X=928850 $Y=716650
X828 119 1 2 600 INVX2 $T=951120 717040 0 180 $X=949010 $Y=712485
X1053 1 2 6 142 141 2 140 ICV_119 $T=611200 724880 1 0 $X=610770 $Y=720325
X1054 1 2 216 200 2 141 236 ICV_119 $T=622400 622960 0 0 $X=621970 $Y=622570
X1055 1 2 14 234 141 2 35 ICV_119 $T=646480 717040 1 0 $X=646050 $Y=712485
X1056 1 2 19 245 141 2 147 ICV_119 $T=675600 717040 1 0 $X=675170 $Y=712485
X1057 1 2 241 239 141 2 35 ICV_119 $T=677280 670000 1 0 $X=676850 $Y=665445
X1058 1 2 18 242 141 2 35 ICV_119 $T=677280 685680 1 0 $X=676850 $Y=681125
X1059 1 2 255 256 141 2 35 ICV_119 $T=685120 646480 0 0 $X=684690 $Y=646090
X1060 1 2 260 259 141 2 281 ICV_119 $T=692960 670000 0 0 $X=692530 $Y=669610
X1061 1 2 277 274 141 2 281 ICV_119 $T=715360 654320 0 0 $X=714930 $Y=653930
X1062 1 2 283 287 141 2 35 ICV_119 $T=720960 599440 0 0 $X=720530 $Y=599050
X1063 1 2 291 296 141 2 35 ICV_119 $T=732160 638640 1 0 $X=731730 $Y=634085
X1064 1 2 288 282 141 2 293 ICV_119 $T=742240 670000 0 0 $X=741810 $Y=669610
X1065 1 2 310 314 141 2 35 ICV_119 $T=745600 591600 0 0 $X=745170 $Y=591210
X1066 1 2 465 458 141 2 467 ICV_119 $T=832960 607280 0 0 $X=832530 $Y=606890
X1067 1 2 502 481 141 2 474 ICV_119 $T=849760 646480 1 0 $X=849330 $Y=641925
X1068 1 2 528 486 141 2 151 ICV_119 $T=863200 599440 0 0 $X=862770 $Y=599050
X1069 1 2 516 508 141 2 495 ICV_119 $T=865440 622960 1 0 $X=865010 $Y=618405
X1070 1 2 514 506 141 2 474 ICV_119 $T=865440 654320 1 0 $X=865010 $Y=649765
X1071 1 2 555 552 141 2 540 ICV_119 $T=899600 630800 1 0 $X=899170 $Y=626245
X1072 1 2 546 553 141 2 542 ICV_119 $T=899600 677840 1 0 $X=899170 $Y=673285
X1073 1 2 576 557 141 2 151 ICV_119 $T=915280 599440 0 0 $X=914850 $Y=599050
X1074 1 2 585 559 141 2 540 ICV_119 $T=916960 630800 0 0 $X=916530 $Y=630410
X1075 1 2 599 578 141 2 540 ICV_119 $T=919760 646480 0 0 $X=919330 $Y=646090
X1076 1 2 613 603 141 2 151 ICV_119 $T=947760 622960 0 0 $X=947330 $Y=622570
X1077 1 2 636 622 141 2 151 ICV_119 $T=978560 654320 1 0 $X=978130 $Y=649765
X1078 1 2 127 639 141 2 151 ICV_119 $T=979680 717040 0 0 $X=979250 $Y=716650
X1079 5 192 1 2 198 OR2X1 $T=625200 693520 0 180 $X=621410 $Y=688965
X1080 208 222 1 2 225 OR2X1 $T=636960 685680 0 0 $X=636530 $Y=685290
X1081 187 224 1 2 228 OR2X1 $T=642560 670000 0 0 $X=642130 $Y=669610
X1082 15 336 1 2 12 OR2X1 $T=787600 599440 1 180 $X=783810 $Y=599050
X1083 347 343 1 2 336 OR2X1 $T=792080 599440 1 180 $X=788290 $Y=599050
X1084 313 45 1 2 358 OR2X1 $T=797120 677840 1 0 $X=796690 $Y=673285
X1085 249 45 1 2 361 OR2X1 $T=799920 701360 1 0 $X=799490 $Y=696805
X1086 288 45 1 2 365 OR2X1 $T=802160 677840 1 0 $X=801730 $Y=673285
X1087 77 46 1 2 442 OR2X1 $T=832960 693520 0 0 $X=832530 $Y=693130
X1088 85 46 1 2 491 OR2X1 $T=874400 693520 1 180 $X=870610 $Y=693130
X1089 90 46 1 2 507 OR2X1 $T=880000 693520 1 180 $X=876210 $Y=693130
X1090 480 45 1 2 525 OR2X1 $T=883360 717040 0 0 $X=882930 $Y=716650
X1091 109 108 1 2 586 OR2X1 $T=935440 717040 1 180 $X=931650 $Y=716650
X1092 600 117 1 2 597 OR2X1 $T=947200 717040 0 180 $X=943410 $Y=712485
X1115 192 206 210 1 2 212 MUX2X1 $T=627440 685680 0 0 $X=627010 $Y=685290
X1116 13 12 210 1 2 233 MUX2X1 $T=657680 701360 0 0 $X=657250 $Y=700970
X1117 13 15 232 1 2 231 MUX2X1 $T=664960 693520 1 180 $X=658930 $Y=693130
X1118 232 12 14 1 2 234 MUX2X1 $T=659360 709200 1 0 $X=658930 $Y=704645
X1119 232 15 237 1 2 238 MUX2X1 $T=673360 677840 0 0 $X=672930 $Y=677450
X1120 237 15 240 1 2 246 MUX2X1 $T=682320 662160 1 0 $X=681890 $Y=657605
X1121 240 15 247 1 2 248 MUX2X1 $T=684560 646480 1 0 $X=684130 $Y=641925
X1122 240 12 241 1 2 239 MUX2X1 $T=690160 662160 1 180 $X=684130 $Y=661770
X1123 237 12 18 1 2 242 MUX2X1 $T=691280 677840 0 180 $X=685250 $Y=673285
X1124 249 9 14 1 2 243 MUX2X1 $T=691840 709200 0 180 $X=685810 $Y=704645
X1125 250 9 241 1 2 244 MUX2X1 $T=692400 693520 0 180 $X=686370 $Y=688965
X1126 19 8 241 1 2 245 MUX2X1 $T=692400 709200 1 180 $X=686370 $Y=708810
X1127 247 15 253 1 2 251 MUX2X1 $T=698560 638640 0 180 $X=692530 $Y=634085
X1128 247 12 20 1 2 252 MUX2X1 $T=698560 662160 0 180 $X=692530 $Y=657605
X1129 23 8 255 1 2 254 MUX2X1 $T=700800 693520 0 180 $X=694770 $Y=688965
X1130 253 15 257 1 2 258 MUX2X1 $T=696880 622960 0 0 $X=696450 $Y=622570
X1131 253 12 255 1 2 256 MUX2X1 $T=702480 646480 0 180 $X=696450 $Y=641925
X1132 260 9 210 1 2 259 MUX2X1 $T=709760 677840 0 180 $X=703730 $Y=673285
X1133 21 8 261 1 2 263 MUX2X1 $T=707520 685680 1 0 $X=707090 $Y=681125
X1134 24 8 265 1 2 267 MUX2X1 $T=709760 717040 0 0 $X=709330 $Y=716650
X1135 22 8 268 1 2 270 MUX2X1 $T=711440 701360 0 0 $X=711010 $Y=700970
X1136 257 15 266 1 2 264 MUX2X1 $T=719280 615120 0 180 $X=713250 $Y=610565
X1137 257 12 265 1 2 269 MUX2X1 $T=721520 630800 1 180 $X=715490 $Y=630410
X1138 266 12 261 1 2 271 MUX2X1 $T=720400 615120 0 0 $X=719970 $Y=614730
X1139 273 12 30 1 2 272 MUX2X1 $T=731600 630800 1 180 $X=725570 $Y=630410
X1140 277 9 18 1 2 274 MUX2X1 $T=732160 662160 0 180 $X=726130 $Y=657605
X1141 278 9 20 1 2 275 MUX2X1 $T=732160 670000 1 180 $X=726130 $Y=669610
X1142 279 9 255 1 2 276 MUX2X1 $T=732160 685680 1 180 $X=726130 $Y=685290
X1143 280 9 268 1 2 284 MUX2X1 $T=730480 701360 1 0 $X=730050 $Y=696805
X1144 273 15 283 1 2 287 MUX2X1 $T=732720 615120 1 0 $X=732290 $Y=610565
X1145 27 8 286 1 2 289 MUX2X1 $T=733280 685680 0 0 $X=732850 $Y=685290
X1146 283 12 268 1 2 290 MUX2X1 $T=733840 630800 0 0 $X=733410 $Y=630410
X1147 288 9 261 1 2 282 MUX2X1 $T=740000 670000 1 180 $X=733970 $Y=669610
X1148 29 8 291 1 2 292 MUX2X1 $T=734960 701360 0 0 $X=734530 $Y=700970
X1149 294 15 273 1 2 285 MUX2X1 $T=742800 630800 0 180 $X=736770 $Y=626245
X1150 33 8 295 1 2 132 MUX2X1 $T=738880 724880 1 0 $X=738450 $Y=720325
X1151 283 15 298 1 2 299 MUX2X1 $T=741120 615120 1 0 $X=740690 $Y=610565
X1152 298 12 291 1 2 296 MUX2X1 $T=748960 630800 1 180 $X=742930 $Y=630410
X1153 28 8 300 1 2 302 MUX2X1 $T=747840 717040 1 0 $X=747410 $Y=712485
X1154 303 9 265 1 2 301 MUX2X1 $T=757360 654320 1 180 $X=751330 $Y=653930
X1155 266 15 310 1 2 314 MUX2X1 $T=757360 599440 0 0 $X=756930 $Y=599050
X1156 298 15 311 1 2 315 MUX2X1 $T=757920 615120 1 0 $X=757490 $Y=610565
X1157 312 12 300 1 2 304 MUX2X1 $T=763520 662160 0 180 $X=757490 $Y=657605
X1158 313 9 300 1 2 305 MUX2X1 $T=763520 677840 0 180 $X=757490 $Y=673285
X1159 294 12 34 1 2 306 MUX2X1 $T=763520 693520 1 180 $X=757490 $Y=693130
X1160 311 12 286 1 2 308 MUX2X1 $T=765200 638640 1 180 $X=759170 $Y=638250
X1161 316 9 34 1 2 309 MUX2X1 $T=765200 709200 1 180 $X=759170 $Y=708810
X1162 310 15 312 1 2 317 MUX2X1 $T=771920 615120 0 180 $X=765890 $Y=610565
X1163 311 15 307 1 2 319 MUX2X1 $T=766320 638640 1 0 $X=765890 $Y=634085
X1164 312 15 323 1 2 321 MUX2X1 $T=782000 693520 1 180 $X=775970 $Y=693130
X1165 323 12 37 1 2 133 MUX2X1 $T=776400 724880 1 0 $X=775970 $Y=720325
X1166 323 15 36 1 2 322 MUX2X1 $T=782560 709200 1 180 $X=776530 $Y=708810
X1167 330 15 294 1 2 324 MUX2X1 $T=785360 630800 0 180 $X=779330 $Y=626245
X1168 334 9 30 1 2 325 MUX2X1 $T=785920 677840 0 180 $X=779890 $Y=673285
X1169 331 9 286 1 2 328 MUX2X1 $T=788160 662160 0 180 $X=782130 $Y=657605
X1170 320 9 291 1 2 329 MUX2X1 $T=788720 654320 1 180 $X=782690 $Y=653930
X1171 330 12 335 1 2 333 MUX2X1 $T=789840 630800 1 180 $X=783810 $Y=630410
X1172 310 12 340 1 2 342 MUX2X1 $T=784800 615120 1 0 $X=784370 $Y=610565
X1173 307 12 295 1 2 337 MUX2X1 $T=792080 677840 0 180 $X=786050 $Y=673285
X1174 345 12 38 1 2 338 MUX2X1 $T=792640 646480 0 180 $X=786610 $Y=641925
X1175 42 15 330 1 2 346 MUX2X1 $T=796560 693520 0 180 $X=790530 $Y=688965
X1176 345 348 307 1 2 352 MUX2X1 $T=791520 630800 0 0 $X=791090 $Y=630410
X1177 363 9 340 1 2 387 MUX2X1 $T=817840 630800 0 180 $X=811810 $Y=626245
X1178 403 9 335 1 2 388 MUX2X1 $T=817840 630800 1 180 $X=811810 $Y=630410
X1179 428 75 413 1 2 435 MUX2X1 $T=827360 630800 1 0 $X=826930 $Y=626245
X1180 455 75 79 1 2 453 MUX2X1 $T=847520 630800 0 180 $X=841490 $Y=626245
X1181 440 75 71 1 2 463 MUX2X1 $T=844160 638640 0 0 $X=843730 $Y=638250
X1182 89 15 478 1 2 475 MUX2X1 $T=863200 591600 1 180 $X=857170 $Y=591210
X1183 480 9 38 1 2 476 MUX2X1 $T=863200 709200 1 180 $X=857170 $Y=708810
X1184 482 9 295 1 2 479 MUX2X1 $T=864320 685680 1 180 $X=858290 $Y=685290
X1185 466 75 77 1 2 487 MUX2X1 $T=860400 630800 0 0 $X=859970 $Y=630410
X1186 494 15 488 1 2 486 MUX2X1 $T=870480 591600 1 180 $X=864450 $Y=591210
X1187 513 75 88 1 2 505 MUX2X1 $T=882240 638640 1 180 $X=876210 $Y=638250
X1188 514 75 477 1 2 506 MUX2X1 $T=882240 654320 1 180 $X=876210 $Y=653930
X1189 516 75 62 1 2 508 MUX2X1 $T=883360 630800 0 180 $X=877330 $Y=626245
X1190 499 75 65 1 2 519 MUX2X1 $T=888960 662160 0 180 $X=882930 $Y=657605
X1191 528 15 498 1 2 536 MUX2X1 $T=894000 599440 0 0 $X=893570 $Y=599050
X1192 547 75 444 1 2 543 MUX2X1 $T=909680 646480 1 180 $X=903650 $Y=646090
X1193 549 75 502 1 2 544 MUX2X1 $T=911360 654320 1 180 $X=905330 $Y=653930
X1194 550 75 500 1 2 545 MUX2X1 $T=911920 662160 1 180 $X=905890 $Y=661770
X1195 546 75 90 1 2 553 MUX2X1 $T=906320 677840 0 0 $X=905890 $Y=677450
X1196 497 15 555 1 2 557 MUX2X1 $T=910240 607280 1 0 $X=909810 $Y=602725
X1197 560 75 91 1 2 554 MUX2X1 $T=918640 709200 0 180 $X=912610 $Y=704645
X1198 556 15 530 1 2 562 MUX2X1 $T=914160 599440 1 0 $X=913730 $Y=594885
X1199 558 15 548 1 2 563 MUX2X1 $T=914720 615120 1 0 $X=914290 $Y=610565
X1200 572 75 85 1 2 566 MUX2X1 $T=928720 693520 0 180 $X=922690 $Y=688965
X1201 561 15 567 1 2 579 MUX2X1 $T=924800 615120 1 0 $X=924370 $Y=610565
X1202 576 15 585 1 2 587 MUX2X1 $T=928160 615120 0 0 $X=927730 $Y=614730
X1203 565 75 99 1 2 592 MUX2X1 $T=931520 670000 1 0 $X=931090 $Y=665445
X1204 589 75 501 1 2 583 MUX2X1 $T=937120 677840 1 180 $X=931090 $Y=677450
X1205 590 75 95 1 2 584 MUX2X1 $T=937120 685680 1 180 $X=931090 $Y=685290
X1206 588 15 591 1 2 594 MUX2X1 $T=932640 638640 1 0 $X=932210 $Y=634085
X1207 601 75 97 1 2 598 MUX2X1 $T=949440 701360 1 180 $X=943410 $Y=700970
X1208 608 15 599 1 2 603 MUX2X1 $T=955040 630800 1 180 $X=949010 $Y=630410
X1209 611 75 120 1 2 606 MUX2X1 $T=957280 709200 1 180 $X=951250 $Y=708810
X1210 612 15 570 1 2 616 MUX2X1 $T=957840 638640 1 0 $X=957410 $Y=634085
X1211 613 15 615 1 2 617 MUX2X1 $T=957840 646480 0 0 $X=957410 $Y=646090
X1212 619 15 620 1 2 622 MUX2X1 $T=968480 654320 1 0 $X=968050 $Y=649765
X1213 629 15 623 1 2 624 MUX2X1 $T=980800 677840 0 180 $X=974770 $Y=673285
X1214 630 15 627 1 2 625 MUX2X1 $T=980800 693520 0 180 $X=974770 $Y=688965
X1215 628 15 621 1 2 631 MUX2X1 $T=975760 654320 0 0 $X=975330 $Y=653930
X1216 632 15 633 1 2 635 MUX2X1 $T=983600 701360 1 0 $X=983170 $Y=696805
X1217 126 15 634 1 2 637 MUX2X1 $T=999840 701360 0 0 $X=999410 $Y=700970
X1218 638 15 128 1 2 639 MUX2X1 $T=1012160 717040 1 180 $X=1006130 $Y=716650
X1219 1 2 218 226 141 235 ICV_118 $T=628000 709200 0 0 $X=627570 $Y=708810
X1220 1 2 134 144 141 235 ICV_118 $T=647040 724880 1 0 $X=646610 $Y=720325
X1221 1 2 232 231 141 35 ICV_118 $T=647600 693520 1 0 $X=647170 $Y=688965
X1222 1 2 240 246 141 35 ICV_118 $T=678400 654320 1 0 $X=677970 $Y=649765
X1223 1 2 250 244 141 147 ICV_118 $T=678400 693520 0 0 $X=677970 $Y=693130
X1224 1 2 266 264 141 35 ICV_118 $T=703040 607280 0 0 $X=702610 $Y=606890
X1225 1 2 279 276 141 281 ICV_118 $T=722080 693520 0 0 $X=721650 $Y=693130
X1226 1 2 311 315 141 35 ICV_118 $T=747840 607280 1 0 $X=747410 $Y=602725
X1227 1 2 323 321 141 35 ICV_118 $T=758480 701360 0 0 $X=758050 $Y=700970
X1228 1 2 295 337 141 35 ICV_118 $T=789280 677840 0 0 $X=788850 $Y=677450
X1229 1 2 62 400 141 349 ICV_118 $T=804960 670000 1 0 $X=804530 $Y=665445
X1230 1 2 65 415 141 349 ICV_118 $T=822880 685680 1 0 $X=822450 $Y=681125
X1231 1 2 428 435 141 467 ICV_118 $T=832960 622960 1 0 $X=832530 $Y=618405
X1232 1 2 444 446 141 474 ICV_118 $T=835200 654320 1 0 $X=834770 $Y=649765
X1233 1 2 135 150 141 149 ICV_118 $T=846960 724880 1 0 $X=846530 $Y=720325
X1234 1 2 494 475 141 151 ICV_118 $T=855360 591600 1 0 $X=854930 $Y=587045
X1235 1 2 567 535 141 540 ICV_118 $T=899040 622960 1 0 $X=898610 $Y=618405
X1236 1 2 601 598 141 582 ICV_118 $T=933200 693520 1 0 $X=932770 $Y=688965
X1237 1 2 620 596 141 582 ICV_118 $T=944960 654320 0 0 $X=944530 $Y=653930
X1238 1 2 621 610 141 582 ICV_118 $T=945520 662160 0 0 $X=945090 $Y=661770
X1239 1 2 615 614 141 582 ICV_118 $T=947200 670000 0 0 $X=946770 $Y=669610
X1240 1 2 627 607 141 582 ICV_118 $T=950560 685680 0 0 $X=950130 $Y=685290
X1241 1 2 611 606 141 154 ICV_118 $T=961760 709200 0 0 $X=961330 $Y=708810
X1242 1 2 633 626 141 154 ICV_118 $T=962320 693520 0 0 $X=961890 $Y=693130
X1243 1 2 632 594 141 151 ICV_118 $T=965120 662160 1 0 $X=964690 $Y=657605
X1244 1 2 629 625 141 151 ICV_118 $T=968480 685680 1 0 $X=968050 $Y=681125
X1245 1 2 638 635 141 151 ICV_118 $T=980800 693520 1 0 $X=980370 $Y=688965
X1246 211 217 205 1 2 223 NAND3X1 $T=635840 662160 0 0 $X=635410 $Y=661770
X1247 214 187 202 1 2 217 NAND3X1 $T=639760 670000 0 180 $X=635410 $Y=665445
X1248 343 347 348 1 2 327 NAND3X1 $T=794880 599440 0 0 $X=794450 $Y=599050
X1249 362 51 368 1 2 371 NAND3X1 $T=803280 717040 1 0 $X=802850 $Y=712485
X1250 374 370 357 1 2 367 NAND3X1 $T=808320 662160 1 180 $X=803970 $Y=661770
X1251 376 375 356 1 2 372 NAND3X1 $T=810000 662160 0 180 $X=805650 $Y=657605
X1252 397 392 58 1 2 391 NAND3X1 $T=815600 717040 1 180 $X=811250 $Y=716650
X1253 382 393 68 1 2 406 NAND3X1 $T=814480 701360 0 0 $X=814050 $Y=700970
X1254 60 63 390 1 2 411 NAND3X1 $T=816160 724880 1 0 $X=815730 $Y=720325
X1255 417 70 401 1 2 412 NAND3X1 $T=824000 693520 1 180 $X=819650 $Y=693130
X1256 63 52 72 1 2 422 NAND3X1 $T=820080 709200 0 0 $X=819650 $Y=708810
X1257 418 69 72 1 2 423 NAND3X1 $T=821200 717040 0 0 $X=820770 $Y=716650
X1258 430 426 422 1 2 421 NAND3X1 $T=829600 701360 1 180 $X=825250 $Y=700970
X1259 418 53 67 1 2 433 NAND3X1 $T=826800 709200 0 0 $X=826370 $Y=708810
X1260 418 49 80 1 2 431 NAND3X1 $T=826800 717040 0 0 $X=826370 $Y=716650
X1261 439 434 422 1 2 437 NAND3X1 $T=835760 701360 1 180 $X=831410 $Y=700970
X1262 50 81 49 1 2 441 NAND3X1 $T=832400 724880 1 0 $X=831970 $Y=720325
X1263 436 81 53 1 2 443 NAND3X1 $T=832960 717040 1 0 $X=832530 $Y=712485
X1264 447 450 404 1 2 446 NAND3X1 $T=841920 654320 1 180 $X=837570 $Y=653930
X1265 454 445 441 1 2 452 NAND3X1 $T=844720 717040 1 180 $X=840370 $Y=716650
X1266 464 459 396 1 2 461 NAND3X1 $T=850320 662160 1 180 $X=845970 $Y=661770
X1267 473 470 424 1 2 469 NAND3X1 $T=855360 670000 0 180 $X=851010 $Y=665445
X1268 484 483 366 1 2 481 NAND3X1 $T=865440 654320 1 180 $X=861090 $Y=653930
X1269 515 511 373 1 2 510 NAND3X1 $T=881680 677840 0 180 $X=877330 $Y=673285
X1270 523 518 503 1 2 522 NAND3X1 $T=886720 685680 1 180 $X=882370 $Y=685290
X1271 524 521 496 1 2 520 NAND3X1 $T=886720 701360 0 180 $X=882370 $Y=696805
X1272 541 538 512 1 2 539 NAND3X1 $T=903520 693520 1 180 $X=899170 $Y=693130
X1273 568 103 573 1 2 504 NAND3X1 $T=923680 709200 0 0 $X=923250 $Y=708810
X1274 106 581 575 1 2 551 NAND3X1 $T=932640 717040 0 180 $X=928290 $Y=712485
X1275 107 105 577 1 2 580 NAND3X1 $T=933200 724880 0 180 $X=928850 $Y=720325
X1276 595 109 110 1 2 577 NAND3X1 $T=938800 724880 0 180 $X=934450 $Y=720325
X1277 114 597 116 1 2 571 NAND3X1 $T=941600 717040 0 0 $X=941170 $Y=716650
X1278 117 112 118 1 2 602 NAND3X1 $T=946080 724880 1 0 $X=945650 $Y=720325
X1279 119 111 109 1 2 604 NAND3X1 $T=951680 717040 1 180 $X=947330 $Y=716650
X1280 16 1 2 235 BUFX1 $T=675600 724880 0 180 $X=672370 $Y=720325
X1281 17 1 2 236 BUFX1 $T=677280 709200 0 180 $X=674050 $Y=704645
X1282 31 1 2 281 BUFX1 $T=735520 693520 0 180 $X=732290 $Y=688965
X1283 32 1 2 31 BUFX1 $T=738320 701360 1 0 $X=737890 $Y=696805
X1284 31 1 2 293 BUFX1 $T=738880 685680 0 0 $X=738450 $Y=685290
X1285 31 1 2 297 BUFX1 $T=746720 717040 0 180 $X=743490 $Y=712485
X1286 350 1 2 349 BUFX1 $T=795440 677840 0 180 $X=792210 $Y=673285
X1287 32 1 2 350 BUFX1 $T=843600 677840 1 180 $X=840370 $Y=677450
X1288 32 1 2 462 BUFX1 $T=845280 646480 0 0 $X=844850 $Y=646090
X1289 462 1 2 467 BUFX1 $T=849760 615120 0 0 $X=849330 $Y=614730
X1290 462 1 2 468 BUFX1 $T=849760 638640 0 0 $X=849330 $Y=638250
X1291 468 1 2 474 BUFX1 $T=853680 638640 0 0 $X=853250 $Y=638250
X1292 462 1 2 495 BUFX1 $T=867680 638640 0 0 $X=867250 $Y=638250
X1293 462 1 2 540 BUFX1 $T=899600 638640 0 0 $X=899170 $Y=638250
X1294 98 1 2 542 BUFX1 $T=906320 685680 0 180 $X=903090 $Y=681125
X1295 98 1 2 100 BUFX1 $T=913040 724880 1 0 $X=912610 $Y=720325
X1296 98 1 2 582 BUFX1 $T=928720 685680 0 0 $X=928290 $Y=685290
X1313 1 35 ANTENNA $T=759040 591600 1 0 $X=758610 $Y=587045
X1314 1 35 ANTENNA $T=759040 599440 1 0 $X=758610 $Y=594885
X1315 50 359 1 2 364 AND2X1 $T=801600 709200 1 0 $X=801170 $Y=704645
X1316 355 53 1 2 136 AND2X1 $T=804960 724880 1 0 $X=804530 $Y=720325
X1317 54 359 1 2 377 AND2X1 $T=806640 709200 1 0 $X=806210 $Y=704645
X1318 395 348 1 2 386 AND2X1 $T=815040 599440 1 180 $X=811250 $Y=599050
X1319 427 431 1 2 430 AND2X1 $T=826800 717040 1 0 $X=826370 $Y=712485
X1320 438 433 1 2 434 AND2X1 $T=834640 709200 0 180 $X=830850 $Y=704645
X1321 411 443 1 2 445 AND2X1 $T=835200 717040 0 0 $X=834770 $Y=716650
X1322 83 43 1 2 451 AND2X1 $T=837440 709200 1 0 $X=837010 $Y=704645
X1323 449 423 1 2 454 AND2X1 $T=839680 717040 1 0 $X=839250 $Y=712485
X1324 10 440 1 2 458 AND2X1 $T=849200 630800 1 180 $X=845410 $Y=630410
X1325 10 455 1 2 460 AND2X1 $T=849760 615120 1 180 $X=845970 $Y=614730
X1326 465 15 1 2 84 AND2X1 $T=850880 591600 1 180 $X=847090 $Y=591210
X1327 10 466 1 2 471 AND2X1 $T=856480 615120 1 180 $X=852690 $Y=614730
X1328 10 428 1 2 489 AND2X1 $T=864320 615120 0 0 $X=863890 $Y=614730
X1329 10 514 1 2 529 AND2X1 $T=892880 630800 0 180 $X=889090 $Y=626245
X1330 10 516 1 2 534 AND2X1 $T=897360 630800 0 180 $X=893570 $Y=626245
X1331 10 499 1 2 535 AND2X1 $T=895680 630800 0 0 $X=895250 $Y=630410
X1332 10 513 1 2 537 AND2X1 $T=897920 638640 1 0 $X=897490 $Y=634085
X1333 10 546 1 2 552 AND2X1 $T=914160 662160 0 180 $X=910370 $Y=657605
X1334 10 550 1 2 559 AND2X1 $T=914160 646480 0 0 $X=913730 $Y=646090
X1335 564 104 1 2 569 AND2X1 $T=924240 724880 1 0 $X=923810 $Y=720325
X1336 10 547 1 2 574 AND2X1 $T=930400 646480 0 180 $X=926610 $Y=641925
X1337 10 549 1 2 578 AND2X1 $T=932640 654320 1 180 $X=928850 $Y=653930
X1338 10 565 1 2 596 AND2X1 $T=937120 654320 0 0 $X=936690 $Y=653930
X1339 10 572 1 2 605 AND2X1 $T=953360 685680 0 180 $X=949570 $Y=681125
X1340 10 590 1 2 607 AND2X1 $T=955600 693520 1 180 $X=951810 $Y=693130
X1341 10 589 1 2 610 AND2X1 $T=957840 670000 0 180 $X=954050 $Y=665445
X1342 10 601 1 2 614 AND2X1 $T=958400 685680 1 0 $X=957970 $Y=681125
X1343 10 560 1 2 618 AND2X1 $T=967920 709200 0 180 $X=964130 $Y=704645
X1344 10 611 1 2 626 AND2X1 $T=978560 709200 0 180 $X=974770 $Y=704645
X1345 636 348 1 2 125 AND2X1 $T=990880 646480 1 0 $X=990450 $Y=641925
.ENDS
***************************************
.SUBCKT ICV_63
** N=19 EP=0 IP=22 FDC=0
.ENDS
***************************************
.SUBCKT ICV_111
** N=7 EP=0 IP=10 FDC=0
.ENDS
***************************************
.SUBCKT ICV_43
** N=4 EP=0 IP=8 FDC=0
.ENDS
***************************************
.SUBCKT ICV_65
** N=4 EP=0 IP=8 FDC=0
.ENDS
***************************************
.SUBCKT ICV_41
** N=4 EP=0 IP=8 FDC=0
.ENDS
***************************************
.SUBCKT ICV_108 1 2 3 4 5
** N=7 EP=5 IP=11 FDC=4
X1 3 4 1 2 5 NOR2X1 $T=0 0 0 0 $X=-430 $Y=-390
.ENDS
***************************************
.SUBCKT ICV_59 1 2 3 4 5
** N=7 EP=5 IP=11 FDC=4
X1 3 5 1 2 4 NAND2X1 $T=560 0 0 0 $X=130 $Y=-390
.ENDS
***************************************
.SUBCKT ICV_85 1 2 3 4 5
** N=7 EP=5 IP=11 FDC=4
X0 3 5 1 2 4 NAND2X1 $T=5600 0 1 180 $X=2370 $Y=-390
.ENDS
***************************************
.SUBCKT ICV_55 1 2 3 4 5
** N=7 EP=5 IP=11 FDC=4
X0 3 5 1 2 4 NAND2X1 $T=2800 0 0 0 $X=2370 $Y=-390
.ENDS
***************************************
.SUBCKT ICV_93 1 2 3 4 5
** N=7 EP=5 IP=11 FDC=4
X0 2 4 1 3 5 NOR2X1 $T=0 0 0 0 $X=-430 $Y=-390
.ENDS
***************************************
.SUBCKT ICV_58 1 2 3 4 5
** N=7 EP=5 IP=11 FDC=4
X1 3 5 1 2 4 NAND2X1 $T=0 0 0 0 $X=-430 $Y=-390
.ENDS
***************************************
.SUBCKT ICV_94 1 2 3 4 5
** N=7 EP=5 IP=11 FDC=6
X1 3 4 1 2 5 OR2X1 $T=0 0 0 0 $X=-430 $Y=-390
.ENDS
***************************************
.SUBCKT ICV_88 1 2 3 4 5
** N=7 EP=5 IP=11 FDC=4
X0 3 5 1 2 4 NAND2X1 $T=0 0 0 0 $X=-430 $Y=-390
.ENDS
***************************************
.SUBCKT ICV_87 1 2 3 4 5 6
** N=8 EP=6 IP=12 FDC=6
X1 3 4 6 1 2 5 NAND3X1 $T=0 0 0 0 $X=-430 $Y=-390
.ENDS
***************************************
.SUBCKT ICV_97 1 2 3 4 5
** N=7 EP=5 IP=11 FDC=4
X0 2 4 1 3 5 NOR2X1 $T=0 0 0 0 $X=-430 $Y=-390
.ENDS
***************************************
.SUBCKT ICV_80 1 2 3 4 5
** N=7 EP=5 IP=11 FDC=4
X1 3 5 1 2 4 NAND2X1 $T=4480 0 1 180 $X=1250 $Y=-390
.ENDS
***************************************
.SUBCKT ICV_105 1 2 3 4 5
** N=7 EP=5 IP=11 FDC=4
X1 3 5 1 2 4 NAND2X1 $T=2240 0 0 0 $X=1810 $Y=-390
.ENDS
***************************************
.SUBCKT ICV_61 1 2 3 4 5
** N=7 EP=5 IP=11 FDC=4
X1 3 5 1 2 4 NAND2X1 $T=0 0 0 0 $X=-430 $Y=-390
.ENDS
***************************************
.SUBCKT ICV_90 1 2 3 4 5
** N=7 EP=5 IP=11 FDC=4
X1 3 5 1 2 4 NAND2X1 $T=1680 0 0 0 $X=1250 $Y=-390
.ENDS
***************************************
.SUBCKT ICV_91 1 2 3 4 5 6
** N=8 EP=6 IP=12 FDC=6
X1 3 4 6 1 2 5 NAND3X1 $T=2240 0 0 0 $X=1810 $Y=-390
.ENDS
***************************************
.SUBCKT ICV_62 1 2 3 4 5
** N=7 EP=5 IP=11 FDC=4
X1 3 5 1 2 4 NAND2X1 $T=0 0 0 0 $X=-430 $Y=-390
.ENDS
***************************************
.SUBCKT ICV_106 1 2 3 4 5 6
** N=8 EP=6 IP=12 FDC=6
X1 3 4 6 1 2 5 NAND3X1 $T=1680 0 0 0 $X=1250 $Y=-390
.ENDS
***************************************
.SUBCKT ICV_56 1 2 3 4 5
** N=7 EP=5 IP=11 FDC=4
X1 3 5 1 2 4 NAND2X1 $T=0 0 0 0 $X=-430 $Y=-390
.ENDS
***************************************
.SUBCKT ICV_92 1 2 3 4 5 6
** N=8 EP=6 IP=12 FDC=6
X1 3 4 6 1 2 5 NAND3X1 $T=0 0 0 0 $X=-430 $Y=-390
.ENDS
***************************************
.SUBCKT ICV_98 1 2 3 4 5 6
** N=8 EP=6 IP=12 FDC=6
X1 3 4 6 1 2 5 NAND3X1 $T=1120 0 0 0 $X=690 $Y=-390
.ENDS
***************************************
.SUBCKT ICV_83 1 2 3 4 5
** N=7 EP=5 IP=11 FDC=4
X1 3 5 1 2 4 NAND2X1 $T=5040 0 1 180 $X=1810 $Y=-390
.ENDS
***************************************
.SUBCKT ICV_78
** N=4 EP=0 IP=8 FDC=0
.ENDS
***************************************
.SUBCKT ICV_100 1 2 3 4 5 6
** N=8 EP=6 IP=12 FDC=6
X1 3 4 6 1 2 5 NAND3X1 $T=0 0 0 0 $X=-430 $Y=-390
.ENDS
***************************************
.SUBCKT ICV_84 1 2 3 4 5 6
** N=8 EP=6 IP=12 FDC=6
X1 3 4 6 1 2 5 NAND3X1 $T=2800 0 0 0 $X=2370 $Y=-390
.ENDS
***************************************
.SUBCKT ICV_60 1 2 3 4 5
** N=7 EP=5 IP=11 FDC=4
X1 3 5 1 2 4 NAND2X1 $T=0 0 0 0 $X=-430 $Y=-390
.ENDS
***************************************
.SUBCKT ICV_89 1 2 3 4 5
** N=7 EP=5 IP=11 FDC=4
X1 3 5 1 2 4 NAND2X1 $T=0 0 0 0 $X=-430 $Y=-390
.ENDS
***************************************
.SUBCKT ICV_81 1 2 3 4 5
** N=7 EP=5 IP=11 FDC=4
X1 3 4 1 2 5 NOR2X1 $T=0 0 0 0 $X=-430 $Y=-390
.ENDS
***************************************
.SUBCKT ICV_110 1 2 3 4 5 6 7 8
** N=10 EP=8 IP=14 FDC=8
X0 1 2 3 4 5 ICV_61 $T=0 0 0 0 $X=-430 $Y=-390
X1 1 2 6 7 8 ICV_61 $T=4480 0 0 0 $X=4050 $Y=-390
.ENDS
***************************************
.SUBCKT ICV_99 1 2 3 4 5
** N=7 EP=5 IP=11 FDC=4
X1 3 5 1 2 4 NAND2X1 $T=3360 0 1 180 $X=130 $Y=-390
.ENDS
***************************************
.SUBCKT ICV_104 1 2 3 4 5
** N=7 EP=5 IP=11 FDC=4
X1 3 5 1 2 4 NAND2X1 $T=1120 0 0 0 $X=690 $Y=-390
.ENDS
***************************************
.SUBCKT ICV_103 1 2 3 4 5 6
** N=8 EP=6 IP=12 FDC=6
X1 3 4 6 1 2 5 NAND3X1 $T=0 0 0 0 $X=-430 $Y=-390
.ENDS
***************************************
.SUBCKT ICV_86 1 2 3 4 5
** N=7 EP=5 IP=11 FDC=4
X1 1 2 3 4 5 ICV_62 $T=1680 0 0 0 $X=1250 $Y=-390
.ENDS
***************************************
.SUBCKT ICV_101 1 2 3 4 5
** N=7 EP=5 IP=11 FDC=4
X1 1 2 3 4 5 ICV_60 $T=4480 0 1 180 $X=1250 $Y=-390
.ENDS
***************************************
.SUBCKT ICV_95 1 2 3 4 5
** N=7 EP=5 IP=11 FDC=4
X0 3 5 1 2 4 NAND2X1 $T=0 0 0 0 $X=-430 $Y=-390
.ENDS
***************************************
.SUBCKT ICV_79 1 2 3 4 5
** N=7 EP=5 IP=11 FDC=4
X1 3 5 1 2 4 NAND2X1 $T=3920 0 1 180 $X=690 $Y=-390
.ENDS
***************************************
.SUBCKT ICV_82 1 2 3 4 5 6
** N=8 EP=6 IP=12 FDC=6
X1 3 4 6 1 2 5 NAND3X1 $T=6720 0 1 180 $X=2370 $Y=-390
.ENDS
***************************************
.SUBCKT ICV_109 1 2 3 4 5
** N=7 EP=5 IP=11 FDC=4
X1 3 4 1 2 5 NOR2X1 $T=0 0 0 0 $X=-430 $Y=-390
.ENDS
***************************************
.SUBCKT ICV_102 1 2 3 4 5 6 7 8
** N=10 EP=8 IP=14 FDC=8
X0 1 2 3 4 5 ICV_58 $T=0 0 0 0 $X=-430 $Y=-390
X1 1 2 6 7 8 ICV_56 $T=7840 0 1 180 $X=4610 $Y=-390
.ENDS
***************************************
.SUBCKT INVX4 A VSS VDD Z
** N=6 EP=4 IP=0 FDC=4
M0 Z A VSS VSS N L=1.8e-07 W=4.4e-07 $X=670 $Y=760 $D=0
M1 VSS A Z VSS N L=1.8e-07 W=4.4e-07 $X=1390 $Y=760 $D=0
M2 Z A VDD VDD P L=1.8e-07 W=8.8e-07 $X=670 $Y=2300 $D=16
M3 VDD A Z VDD P L=1.8e-07 W=8.8e-07 $X=1390 $Y=2300 $D=16
.ENDS
***************************************
.SUBCKT ICV_107 1 2 3 4 5 6 7 8
** N=10 EP=8 IP=14 FDC=8
X0 1 2 3 4 5 ICV_62 $T=0 0 0 0 $X=-430 $Y=-390
X1 1 2 6 7 8 ICV_62 $T=3920 0 0 0 $X=3490 $Y=-390
.ENDS
***************************************
.SUBCKT ICV_96 1 2 3 4 5 6
** N=8 EP=6 IP=12 FDC=6
X1 3 4 6 1 2 5 NAND3X1 $T=3360 0 0 0 $X=2930 $Y=-390
.ENDS
***************************************
.SUBCKT ICV_66
** N=4 EP=0 IP=8 FDC=0
.ENDS
***************************************
.SUBCKT ICV_48
** N=4 EP=0 IP=8 FDC=0
.ENDS
***************************************
.SUBCKT ICV_73
** N=5 EP=0 IP=8 FDC=0
.ENDS
***************************************
.SUBCKT ICV_74
** N=5 EP=0 IP=10 FDC=0
.ENDS
***************************************
.SUBCKT ICV_68
** N=5 EP=0 IP=8 FDC=0
.ENDS
***************************************
.SUBCKT ICV_77
** N=5 EP=0 IP=10 FDC=0
.ENDS
***************************************
.SUBCKT ICV_69
** N=5 EP=0 IP=8 FDC=0
.ENDS
***************************************
.SUBCKT ICV_70
** N=5 EP=0 IP=10 FDC=0
.ENDS
***************************************
.SUBCKT ICV_71
** N=5 EP=0 IP=8 FDC=0
.ENDS
***************************************
.SUBCKT ICV_72
** N=5 EP=0 IP=10 FDC=0
.ENDS
***************************************
.SUBCKT ICV_75
** N=5 EP=0 IP=8 FDC=0
.ENDS
***************************************
.SUBCKT ICV_76
** N=5 EP=0 IP=10 FDC=0
.ENDS
***************************************
.SUBCKT ICV_112 1 2 3 4 5 6 7 8 9 10 11 12 13 14 15 16 17 18 19 20
+ 21 22 23 24 25 26 27 28 29 30 31 32 33 34 35 36 37 38 39 40
+ 41 42 43 44 45 46 47 48 49 50 51 52 53 54 55 56 57 58 59 60
+ 61 62 63 64 65 66 67 68 69 70 71 72 73 74 75 76 77 78 79 80
+ 81 82 83 84 85 86 87 88 89 90 91 92 93 94 95 96 97 98 99 100
+ 101 102 103 104 105 106 107 108 109 110 111 112 113 114 115 116 117 118 119 120
+ 121 122 123 124 125 126 127 128 129 130 131 132 133 134 135 136 137 138 139 140
+ 141 142 143 144 145 146 147 148 149 150 151 152 153 154 155 156 157 158 159 160
+ 161 162 163 164 165 166 167 168 169 170 171 172 173 174 175 176 177 178 179 180
+ 181 182 183 184 185 186 187 188 189 190 191 192 193 194 195 196 197 198 199 200
+ 201 202 203 204 205 206 207 208 209 210 211 212 213 214 215 216 217 218 219 220
+ 221 222 223 224 225 226 227 228 229 230 231 232 233 234 235 236 237 238 239 240
+ 241 242 243 244 245 246 247 248 249 250 251 252 253 254 255 256 257 258 259 260
+ 261 262 263 264 265 266 267 268 269 270 271 272 273 274 275 276 277 278 279 280
+ 281 282 283 284 285 286 287 288 289 290 291 292 293 294 295 296 297 298 299 300
+ 301 302 303 304 305 306 307 308 309 310 311 312 313 314 315 316 317 318 319 320
+ 321 322 323 324 325 326 327 328 329 330 331 332 333 334 335 336 337 338 339 340
+ 341 342 343 344 345 346 347 348 349 350 351 352 353 354 355 356 357 358 359 360
+ 361 362 363 364 365 366 367 368 369 370 371 372 373 374 375 376 377 378 379 380
+ 381 382 383 384 385 386 387 388 389 390 391 392 393 394 395 396 397 398 399 400
+ 401 402 403 404 405 406 407 408 409 410 411 412 413 414 415 416 417 419 420 421
+ 422 423 424 425 426
** N=2672 EP=425 IP=24770 FDC=17602
X993 799 1391 419 2 1 2 545 DFFQSRX1 $T=626320 779760 1 180 $X=600690 $Y=779370
X994 665 68 419 2 1 2 501 DFFQSRX1 $T=602800 740560 0 0 $X=602370 $Y=740170
X995 898 68 419 2 1 2 82 DFFQSRX1 $T=603360 732720 1 0 $X=602930 $Y=728165
X996 887 1391 419 2 1 2 53 DFFQSRX1 $T=625760 818960 0 0 $X=625330 $Y=818570
X997 957 1391 419 2 1 2 37 DFFQSRX1 $T=642000 756240 0 0 $X=641570 $Y=755850
X998 1480 197 419 2 1 2 1482 DFFQSRX1 $T=684000 732720 1 0 $X=683570 $Y=728165
X999 1473 1391 419 2 1 2 1445 DFFQSRX1 $T=684000 756240 0 0 $X=683570 $Y=755850
X1000 1401 197 419 2 1 2 182 DFFQSRX1 $T=686240 748400 1 0 $X=685810 $Y=743845
X1001 324 1645 419 2 1 2 937 DFFQSRX1 $T=727680 740560 1 180 $X=702050 $Y=740170
X1002 1631 1645 419 2 1 2 1483 DFFQSRX1 $T=731040 787600 0 180 $X=705410 $Y=783045
X1003 264 1645 419 2 1 2 251 DFFQSRX1 $T=752880 732720 0 180 $X=727250 $Y=728165
X1004 1642 1645 419 2 1 2 1452 DFFQSRX1 $T=754000 740560 0 180 $X=728370 $Y=736005
X1005 1643 1645 419 2 1 2 1532 DFFQSRX1 $T=754000 748400 1 180 $X=728370 $Y=748010
X1006 1644 1645 419 2 1 2 1478 DFFQSRX1 $T=754560 764080 0 180 $X=728930 $Y=759525
X1007 1650 1648 419 2 1 2 1549 DFFQSRX1 $T=765760 771920 0 180 $X=740130 $Y=767365
X1008 1652 1648 419 2 1 2 1507 DFFQSRX1 $T=766320 787600 0 180 $X=740690 $Y=783045
X1009 1653 1648 419 2 1 2 1576 DFFQSRX1 $T=767440 795440 1 180 $X=741810 $Y=795050
X1010 1657 1648 419 2 1 2 1553 DFFQSRX1 $T=768000 811120 0 180 $X=742370 $Y=806565
X1011 1658 1648 419 2 1 2 1581 DFFQSRX1 $T=768000 818960 0 180 $X=742370 $Y=814405
X1012 1659 1648 419 2 1 2 236 DFFQSRX1 $T=768000 834640 0 180 $X=742370 $Y=830085
X1013 1664 1648 419 2 1 2 1525 DFFQSRX1 $T=769120 834640 1 180 $X=743490 $Y=834250
X1014 1665 420 419 2 1 2 1514 DFFQSRX1 $T=770240 850320 1 180 $X=744610 $Y=849930
X1015 1663 420 419 2 1 2 1527 DFFQSRX1 $T=770800 858160 1 180 $X=745170 $Y=857770
X1016 1676 420 419 2 1 2 1508 DFFQSRX1 $T=773600 873840 0 180 $X=747970 $Y=869285
X1017 1668 420 419 2 1 2 226 DFFQSRX1 $T=774160 881680 0 180 $X=748530 $Y=877125
X1018 1669 420 419 2 1 2 1526 DFFQSRX1 $T=774160 889520 0 180 $X=748530 $Y=884965
X1019 1670 420 419 2 1 2 1546 DFFQSRX1 $T=774720 905200 0 180 $X=749090 $Y=900645
X1020 1671 420 419 2 1 2 1575 DFFQSRX1 $T=775280 913040 0 180 $X=749650 $Y=908485
X1021 1673 421 419 2 1 2 1518 DFFQSRX1 $T=775840 920880 1 180 $X=750210 $Y=920490
X1022 1675 421 419 2 1 2 1429 DFFQSRX1 $T=775840 944400 1 180 $X=750210 $Y=944010
X1023 1674 421 419 2 1 2 1438 DFFQSRX1 $T=776400 936560 0 180 $X=750770 $Y=932005
X1024 1678 343 419 2 1 2 1677 DFFQSRX1 $T=759040 748400 1 0 $X=758610 $Y=743845
X1025 1682 343 419 2 1 2 1656 DFFQSRX1 $T=784240 748400 1 180 $X=758610 $Y=748010
X1026 1687 343 419 2 1 2 280 DFFQSRX1 $T=759040 764080 0 0 $X=758610 $Y=763690
X1027 1680 343 419 2 1 2 1649 DFFQSRX1 $T=759040 779760 1 0 $X=758610 $Y=775205
X1028 1688 343 419 2 1 2 1662 DFFQSRX1 $T=784240 826800 0 180 $X=758610 $Y=822245
X1029 1686 343 419 2 1 2 1661 DFFQSRX1 $T=784240 842480 1 180 $X=758610 $Y=842090
X1030 277 343 419 2 1 2 265 DFFQSRX1 $T=792080 724880 1 180 $X=766450 $Y=724490
X1031 1679 343 419 2 1 2 1641 DFFQSRX1 $T=792640 732720 0 180 $X=767010 $Y=728165
X1032 1696 343 419 2 1 2 1685 DFFQSRX1 $T=811680 905200 0 180 $X=786050 $Y=900645
X1033 1695 343 419 2 1 2 1647 DFFQSRX1 $T=789840 787600 1 0 $X=789410 $Y=783045
X1034 1689 343 419 2 1 2 1651 DFFQSRX1 $T=789840 795440 1 0 $X=789410 $Y=790885
X1035 1693 343 419 2 1 2 1692 DFFQSRX1 $T=789840 818960 1 0 $X=789410 $Y=814405
X1036 1690 343 419 2 1 2 1683 DFFQSRX1 $T=789840 834640 0 0 $X=789410 $Y=834250
X1037 1699 343 419 2 1 2 1660 DFFQSRX1 $T=789840 850320 0 0 $X=789410 $Y=849930
X1038 1708 343 419 2 1 2 284 DFFQSRX1 $T=789840 866000 0 0 $X=789410 $Y=865610
X1039 1691 343 419 2 1 2 268 DFFQSRX1 $T=789840 881680 1 0 $X=789410 $Y=877125
X1040 1694 343 419 2 1 2 283 DFFQSRX1 $T=789840 889520 0 0 $X=789410 $Y=889130
X1041 1697 343 419 2 1 2 270 DFFQSRX1 $T=789840 913040 0 0 $X=789410 $Y=912650
X1042 1734 343 419 2 1 2 1667 DFFQSRX1 $T=789840 928720 0 0 $X=789410 $Y=928330
X1043 1681 343 419 2 1 2 269 DFFQSRX1 $T=789840 944400 0 0 $X=789410 $Y=944010
X1044 1724 343 419 2 1 2 1718 DFFQSRX1 $T=793200 771920 1 0 $X=792770 $Y=767365
X1045 1715 343 419 2 1 2 1655 DFFQSRX1 $T=794320 779760 0 0 $X=793890 $Y=779370
X1046 1729 343 419 2 1 2 1720 DFFQSRX1 $T=794880 803280 1 0 $X=794450 $Y=798725
X1047 1716 343 419 2 1 2 1654 DFFQSRX1 $T=794880 811120 1 0 $X=794450 $Y=806565
X1048 1756 343 419 2 1 2 1705 DFFQSRX1 $T=795440 936560 0 0 $X=795010 $Y=936170
X1049 1735 343 419 2 1 2 1700 DFFQSRX1 $T=823440 858160 1 180 $X=797810 $Y=857770
X1050 1741 343 419 2 1 2 1703 DFFQSRX1 $T=825120 826800 0 180 $X=799490 $Y=822245
X1051 1712 343 419 2 1 2 1666 DFFQSRX1 $T=800480 842480 1 0 $X=800050 $Y=837925
X1052 1738 343 419 2 1 2 1672 DFFQSRX1 $T=826240 842480 1 180 $X=800610 $Y=842090
X1053 1748 1853 419 2 1 2 1727 DFFQSRX1 $T=833520 787600 1 180 $X=807890 $Y=787210
X1054 1809 422 419 2 1 2 1833 DFFQSRX1 $T=820640 944400 1 0 $X=820210 $Y=939845
X1055 1815 1858 419 2 1 2 1840 DFFQSRX1 $T=822880 858160 1 0 $X=822450 $Y=853605
X1056 1831 1853 419 2 1 2 1856 DFFQSRX1 $T=824000 795440 1 0 $X=823570 $Y=790885
X1057 1837 1858 419 2 1 2 1773 DFFQSRX1 $T=849200 818960 1 180 $X=823570 $Y=818570
X1058 1824 1858 419 2 1 2 1849 DFFQSRX1 $T=824000 850320 1 0 $X=823570 $Y=845765
X1059 1823 1858 419 2 1 2 1848 DFFQSRX1 $T=824560 834640 1 0 $X=824130 $Y=830085
X1060 1865 1853 419 2 1 2 1883 DFFQSRX1 $T=829040 787600 1 0 $X=828610 $Y=783045
X1061 1867 1853 419 2 1 2 1890 DFFQSRX1 $T=830720 779760 1 0 $X=830290 $Y=775205
X1062 1872 1835 419 2 1 2 1898 DFFQSRX1 $T=831840 771920 1 0 $X=831410 $Y=767365
X1063 1877 1835 419 2 1 2 1902 DFFQSRX1 $T=833520 764080 1 0 $X=833090 $Y=759525
X1064 1944 1858 419 2 1 2 316 DFFQSRX1 $T=843040 811120 0 0 $X=842610 $Y=810730
X1065 1954 1835 419 2 1 2 322 DFFQSRX1 $T=869360 740560 0 180 $X=843730 $Y=736005
X1066 1897 1835 419 2 1 2 1913 DFFQSRX1 $T=844160 748400 1 0 $X=843730 $Y=743845
X1067 1957 1835 419 2 1 2 305 DFFQSRX1 $T=869360 756240 0 180 $X=843730 $Y=751685
X1068 1973 1853 419 2 1 2 1761 DFFQSRX1 $T=849200 803280 1 0 $X=848770 $Y=798725
X1069 423 422 419 2 1 2 350 DFFQSRX1 $T=858160 944400 0 0 $X=857730 $Y=944010
X1070 2089 2189 419 2 1 2 1964 DFFQSRX1 $T=885040 795440 0 180 $X=859410 $Y=790885
X1071 1998 422 419 2 1 2 2025 DFFQSRX1 $T=860400 936560 1 0 $X=859970 $Y=932005
X1072 1988 1853 419 2 1 2 2042 DFFQSRX1 $T=860960 787600 1 0 $X=860530 $Y=783045
X1073 2056 2189 419 2 1 2 2006 DFFQSRX1 $T=895680 764080 1 180 $X=870050 $Y=763690
X1074 2155 2189 419 2 1 2 347 DFFQSRX1 $T=895680 779760 1 180 $X=870050 $Y=779370
X1075 2007 2189 419 2 1 2 1956 DFFQSRX1 $T=895680 787600 1 180 $X=870050 $Y=787210
X1076 2140 424 419 2 1 2 2077 DFFQSRX1 $T=908000 732720 0 180 $X=882370 $Y=728165
X1077 2076 424 419 2 1 2 349 DFFQSRX1 $T=910800 724880 1 180 $X=885170 $Y=724490
X1078 2084 2189 419 2 1 2 2095 DFFQSRX1 $T=901280 756240 0 0 $X=900850 $Y=755850
X1079 2391 2472 419 2 1 2 321 DFFQSRX1 $T=943280 873840 0 180 $X=917650 $Y=869285
X1080 2444 2434 419 2 1 2 2494 DFFQSRX1 $T=933200 944400 1 0 $X=932770 $Y=939845
X1081 2428 2434 419 2 1 2 1753 DFFQSRX1 $T=934320 936560 1 0 $X=933890 $Y=932005
X1082 2443 2539 419 2 1 2 2497 DFFQSRX1 $T=935440 858160 1 0 $X=935010 $Y=853605
X1083 2460 2472 419 2 1 2 1940 DFFQSRX1 $T=936000 866000 0 0 $X=935570 $Y=865610
X1084 2512 2472 419 2 1 2 2527 DFFQSRX1 $T=942160 905200 0 0 $X=941730 $Y=904810
X1085 2510 2472 419 2 1 2 2525 DFFQSRX1 $T=942720 881680 1 0 $X=942290 $Y=877125
X1086 2511 2472 419 2 1 2 2526 DFFQSRX1 $T=942720 889520 0 0 $X=942290 $Y=889130
X1087 2493 2472 419 2 1 2 313 DFFQSRX1 $T=942720 897360 0 0 $X=942290 $Y=896970
X1088 2513 2434 419 2 1 2 2528 DFFQSRX1 $T=953360 920880 1 0 $X=952930 $Y=916325
X1089 2551 2539 419 2 1 2 2565 DFFQSRX1 $T=961200 842480 1 0 $X=960770 $Y=837925
X1090 2538 2539 419 2 1 2 2548 DFFQSRX1 $T=961200 866000 1 0 $X=960770 $Y=861445
X1091 2540 2535 419 2 1 2 2550 DFFQSRX1 $T=961760 826800 1 0 $X=961330 $Y=822245
X1092 2489 2434 419 2 1 2 2463 DFFQSRX1 $T=962320 913040 0 0 $X=961890 $Y=912650
X1093 2541 2535 419 2 1 2 2552 DFFQSRX1 $T=962880 795440 1 0 $X=962450 $Y=790885
X1094 2542 2535 419 2 1 2 2553 DFFQSRX1 $T=962880 811120 1 0 $X=962450 $Y=806565
X1095 2543 2535 419 2 1 2 2554 DFFQSRX1 $T=963440 787600 1 0 $X=963010 $Y=783045
X1096 2537 2434 419 2 1 2 2546 DFFQSRX1 $T=964000 928720 1 0 $X=963570 $Y=924165
X1097 2544 2434 419 2 1 2 406 DFFQSRX1 $T=964000 944400 1 0 $X=963570 $Y=939845
X1098 2545 2536 419 2 1 2 2555 DFFQSRX1 $T=964560 771920 0 0 $X=964130 $Y=771530
X1099 2547 403 419 2 1 2 2563 DFFQSRX1 $T=965120 748400 0 0 $X=964690 $Y=748010
X1100 2549 403 419 2 1 2 2564 DFFQSRX1 $T=967360 740560 1 0 $X=966930 $Y=736005
X1101 2560 2539 419 2 1 2 2577 DFFQSRX1 $T=970160 858160 1 0 $X=969730 $Y=853605
X1102 2559 2539 419 2 1 2 2579 DFFQSRX1 $T=970720 850320 1 0 $X=970290 $Y=845765
X1103 2568 2472 419 2 1 2 2580 DFFQSRX1 $T=971280 881680 1 0 $X=970850 $Y=877125
X1104 2561 2472 419 2 1 2 2581 DFFQSRX1 $T=971280 889520 1 0 $X=970850 $Y=884965
X1105 2556 2434 419 2 1 2 2582 DFFQSRX1 $T=971280 905200 0 0 $X=970850 $Y=904810
X1106 2558 2539 419 2 1 2 2585 DFFQSRX1 $T=971840 834640 1 0 $X=971410 $Y=830085
X1107 2569 2536 419 2 1 2 2586 DFFQSRX1 $T=974080 764080 0 0 $X=973650 $Y=763690
X1108 2557 2536 419 2 1 2 2587 DFFQSRX1 $T=974640 756240 0 0 $X=974210 $Y=755850
X1109 2570 2536 419 2 1 2 2598 DFFQSRX1 $T=981360 748400 1 0 $X=980930 $Y=743845
X1110 2590 344 419 2 1 2 2602 DFFQSRX1 $T=981360 756240 1 0 $X=980930 $Y=751685
X1111 2592 344 419 2 1 2 2603 DFFQSRX1 $T=981360 771920 1 0 $X=980930 $Y=767365
X1112 2613 344 419 2 1 2 2604 DFFQSRX1 $T=981360 779760 0 0 $X=980930 $Y=779370
X1113 2575 2535 419 2 1 2 2600 DFFQSRX1 $T=981360 787600 0 0 $X=980930 $Y=787210
X1114 2572 2535 419 2 1 2 2584 DFFQSRX1 $T=981360 795440 0 0 $X=980930 $Y=795050
X1115 2583 2535 419 2 1 2 2599 DFFQSRX1 $T=981360 803280 0 0 $X=980930 $Y=802890
X1116 2578 344 419 2 1 2 2605 DFFQSRX1 $T=981360 818960 1 0 $X=980930 $Y=814405
X1117 2597 344 419 2 1 2 2606 DFFQSRX1 $T=981360 818960 0 0 $X=980930 $Y=818570
X1118 2594 344 419 2 1 2 2588 DFFQSRX1 $T=981360 834640 0 0 $X=980930 $Y=834250
X1119 2596 344 419 2 1 2 2607 DFFQSRX1 $T=981360 850320 0 0 $X=980930 $Y=849930
X1120 2595 344 419 2 1 2 2608 DFFQSRX1 $T=981360 858160 0 0 $X=980930 $Y=857770
X1121 425 344 419 2 1 2 2609 DFFQSRX1 $T=981360 873840 1 0 $X=980930 $Y=869285
X1122 2593 344 419 2 1 2 409 DFFQSRX1 $T=1006560 881680 1 180 $X=980930 $Y=881290
X1123 2614 344 419 2 1 2 2566 DFFQSRX1 $T=1006560 889520 1 180 $X=980930 $Y=889130
X1124 2589 344 419 2 1 2 410 DFFQSRX1 $T=1006560 897360 1 180 $X=980930 $Y=896970
X1125 2616 344 419 2 1 2 2567 DFFQSRX1 $T=1006560 913040 0 180 $X=980930 $Y=908485
X1126 2562 426 419 2 1 2 2610 DFFQSRX1 $T=981360 920880 1 0 $X=980930 $Y=916325
X1127 2576 426 419 2 1 2 2611 DFFQSRX1 $T=981360 920880 0 0 $X=980930 $Y=920490
X1128 2574 426 419 2 1 2 2612 DFFQSRX1 $T=981360 936560 1 0 $X=980930 $Y=932005
X1129 2573 426 419 2 1 2 414 DFFQSRX1 $T=981360 936560 0 0 $X=980930 $Y=936170
X1130 2571 2536 419 2 1 2 411 DFFQSRX1 $T=1017760 732720 0 180 $X=992130 $Y=728165
X1131 2591 344 419 2 1 2 412 DFFQSRX1 $T=1018320 724880 1 180 $X=992690 $Y=724490
X1132 2615 344 419 2 1 2 2601 DFFQSRX1 $T=1012160 936560 0 0 $X=1011730 $Y=936170
X1133 455 452 1 2 460 NOR2X1 $T=591040 889520 0 0 $X=590610 $Y=889130
X1134 476 441 1 2 470 NOR2X1 $T=595520 803280 0 180 $X=592290 $Y=798725
X1135 4 465 1 2 472 NOR2X1 $T=595520 842480 1 180 $X=592290 $Y=842090
X1136 6 482 1 2 480 NOR2X1 $T=593280 842480 1 0 $X=592850 $Y=837925
X1137 456 489 1 2 484 NOR2X1 $T=593840 873840 0 0 $X=593410 $Y=873450
X1138 472 480 1 2 488 NOR2X1 $T=594400 834640 0 0 $X=593970 $Y=834250
X1139 490 497 1 2 489 NOR2X1 $T=594960 889520 1 0 $X=594530 $Y=884965
X1140 492 511 1 2 16 NOR2X1 $T=596640 787600 1 0 $X=596210 $Y=783045
X1141 505 497 1 2 444 NOR2X1 $T=596640 795440 1 0 $X=596210 $Y=790885
X1142 580 515 1 2 574 NOR2X1 $T=605040 866000 0 180 $X=601810 $Y=861445
X1143 568 583 1 2 584 NOR2X1 $T=602240 897360 0 0 $X=601810 $Y=896970
X1144 548 27 1 2 568 NOR2X1 $T=602240 905200 1 0 $X=601810 $Y=900645
X1145 593 599 1 2 583 NOR2X1 $T=603920 944400 1 0 $X=603490 $Y=939845
X1146 578 590 1 2 603 NOR2X1 $T=605600 826800 0 0 $X=605170 $Y=826410
X1147 28 38 1 2 40 NOR2X1 $T=610640 944400 1 180 $X=607410 $Y=944010
X1148 38 648 1 2 599 NOR2X1 $T=608400 944400 1 0 $X=607970 $Y=939845
X1149 605 658 1 2 657 NOR2X1 $T=610080 913040 0 0 $X=609650 $Y=912650
X1150 654 670 1 2 658 NOR2X1 $T=610080 928720 1 0 $X=609650 $Y=924165
X1151 638 624 1 2 45 NOR2X1 $T=614000 803280 0 180 $X=610770 $Y=798725
X1152 706 678 1 2 694 NOR2X1 $T=616800 756240 1 180 $X=613570 $Y=755850
X1153 54 59 1 2 57 NOR2X1 $T=616240 724880 0 0 $X=615810 $Y=724490
X1154 54 728 1 2 677 NOR2X1 $T=616240 740560 1 0 $X=615810 $Y=736005
X1155 53 55 1 2 648 NOR2X1 $T=619040 944400 0 180 $X=615810 $Y=939845
X1156 53 11 1 2 697 NOR2X1 $T=619600 944400 1 180 $X=616370 $Y=944010
X1157 501 740 1 2 3 NOR2X1 $T=617920 787600 1 0 $X=617490 $Y=783045
X1158 525 740 1 2 30 NOR2X1 $T=621280 795440 0 180 $X=618050 $Y=790885
X1159 70 700 1 2 783 NOR2X1 $T=624640 858160 1 180 $X=621410 $Y=857770
X1160 545 77 1 2 517 NOR2X1 $T=622960 920880 0 0 $X=622530 $Y=920490
X1161 70 48 1 2 67 NOR2X1 $T=627440 881680 1 0 $X=627010 $Y=877125
X1162 86 738 1 2 801 NOR2X1 $T=630800 889520 0 180 $X=627570 $Y=884965
X1163 840 857 1 2 813 NOR2X1 $T=629120 873840 0 0 $X=628690 $Y=873450
X1164 871 555 1 2 89 NOR2X1 $T=633040 897360 0 180 $X=629810 $Y=892805
X1165 37 840 1 2 738 NOR2X1 $T=631920 873840 1 0 $X=631490 $Y=869285
X1166 501 840 1 2 926 NOR2X1 $T=639200 866000 1 180 $X=635970 $Y=865610
X1167 53 895 1 2 953 NOR2X1 $T=638640 795440 0 0 $X=638210 $Y=795050
X1168 53 104 1 2 971 NOR2X1 $T=640320 818960 1 0 $X=639890 $Y=814405
X1169 1001 935 1 2 991 NOR2X1 $T=644240 936560 1 180 $X=641010 $Y=936170
X1170 548 116 1 2 1001 NOR2X1 $T=645920 913040 1 180 $X=642690 $Y=912650
X1171 38 971 1 2 1014 NOR2X1 $T=646480 818960 0 180 $X=643250 $Y=814405
X1172 38 1038 1 2 1034 NOR2X1 $T=645920 858160 1 0 $X=645490 $Y=853605
X1173 131 621 1 2 1054 NOR2X1 $T=650960 748400 1 180 $X=647730 $Y=748010
X1174 1048 1063 1 2 1059 NOR2X1 $T=648160 779760 1 0 $X=647730 $Y=775205
X1175 1075 738 1 2 1048 NOR2X1 $T=652080 803280 1 180 $X=648850 $Y=802890
X1176 1067 1080 1 2 1074 NOR2X1 $T=649840 764080 0 0 $X=649410 $Y=763690
X1177 52 1037 1 2 1097 NOR2X1 $T=654880 803280 0 180 $X=651650 $Y=798725
X1178 28 142 1 2 1057 NOR2X1 $T=652080 842480 0 0 $X=651650 $Y=842090
X1179 1097 953 1 2 1102 NOR2X1 $T=655440 795440 1 180 $X=652210 $Y=795050
X1180 1089 1050 1 2 1119 NOR2X1 $T=656560 834640 0 180 $X=653330 $Y=830085
X1181 1142 1134 1 2 1141 NOR2X1 $T=658800 779760 0 180 $X=655570 $Y=775205
X1182 912 52 1 2 154 NOR2X1 $T=661040 811120 1 180 $X=657810 $Y=810730
X1183 1207 1156 1 2 1201 NOR2X1 $T=664960 897360 0 180 $X=661730 $Y=892805
X1184 457 1246 1 2 1238 NOR2X1 $T=667200 795440 0 0 $X=666770 $Y=795050
X1185 1243 579 1 2 1251 NOR2X1 $T=668320 756240 0 0 $X=667890 $Y=755850
X1186 1292 1073 1 2 1291 NOR2X1 $T=675040 866000 1 180 $X=671810 $Y=865610
X1187 1302 1179 1 2 1297 NOR2X1 $T=675600 771920 0 180 $X=672370 $Y=767365
X1188 1333 49 1 2 1341 NOR2X1 $T=677280 873840 1 0 $X=676850 $Y=869285
X1189 1358 187 1 2 1354 NOR2X1 $T=681200 889520 1 180 $X=677970 $Y=889130
X1190 1361 1296 1 2 1359 NOR2X1 $T=681760 740560 1 180 $X=678530 $Y=740170
X1191 1415 1374 1 2 1413 NOR2X1 $T=687920 866000 0 180 $X=684690 $Y=861445
X1192 1423 1327 1 2 1416 NOR2X1 $T=689040 873840 1 180 $X=685810 $Y=873450
X1193 1433 1383 1 2 1427 NOR2X1 $T=689600 795440 0 180 $X=686370 $Y=790885
X1194 1469 1209 1 2 1459 NOR2X1 $T=694080 771920 1 180 $X=690850 $Y=771530
X1195 1422 1470 1 2 1466 NOR2X1 $T=691280 842480 0 0 $X=690850 $Y=842090
X1196 182 48 1 2 1502 NOR2X1 $T=698000 881680 1 0 $X=697570 $Y=877125
X1197 1511 1503 1 2 1513 NOR2X1 $T=701360 756240 1 0 $X=700930 $Y=751685
X1198 182 37 1 2 237 NOR2X1 $T=701920 866000 0 0 $X=701490 $Y=865610
X1199 1567 1266 1 2 1573 NOR2X1 $T=713120 764080 0 0 $X=712690 $Y=763690
X1200 1579 1447 1 2 1614 NOR2X1 $T=718720 764080 0 0 $X=718290 $Y=763690
X1201 1582 1610 1 2 1615 NOR2X1 $T=719280 842480 1 0 $X=718850 $Y=837925
X1202 1601 1506 1 2 1632 NOR2X1 $T=723200 850320 0 0 $X=722770 $Y=849930
X1203 267 1529 1 2 1646 NOR2X1 $T=751760 928720 1 0 $X=751330 $Y=924165
X1204 1731 1717 1 2 309 NOR2X1 $T=812800 748400 0 0 $X=812370 $Y=748010
X1205 1731 306 1 2 1740 NOR2X1 $T=814480 740560 0 0 $X=814050 $Y=740170
X1206 1731 307 1 2 293 NOR2X1 $T=817840 732720 1 180 $X=814610 $Y=732330
X1207 314 1768 1 2 302 NOR2X1 $T=826800 732720 0 0 $X=826370 $Y=732330
X1208 1755 1750 1 2 1795 NOR2X1 $T=828480 905200 0 0 $X=828050 $Y=904810
X1209 1744 1828 1 2 1836 NOR2X1 $T=834080 913040 1 0 $X=833650 $Y=908485
X1210 1776 1796 1 2 1841 NOR2X1 $T=838000 873840 1 180 $X=834770 $Y=873450
X1211 1800 1817 1 2 1845 NOR2X1 $T=835760 905200 0 0 $X=835330 $Y=904810
X1212 1818 1798 1 2 328 NOR2X1 $T=837440 732720 1 0 $X=837010 $Y=728165
X1213 1784 1817 1 2 1869 NOR2X1 $T=841920 928720 1 180 $X=838690 $Y=928330
X1214 1733 1846 1 2 1900 NOR2X1 $T=847520 897360 0 180 $X=844290 $Y=892805
X1215 1733 1884 1 2 1905 NOR2X1 $T=846400 905200 0 0 $X=845970 $Y=904810
X1216 1887 1829 1 2 1911 NOR2X1 $T=850320 920880 0 180 $X=847090 $Y=916325
X1217 1886 1905 1 2 1929 NOR2X1 $T=853680 913040 1 180 $X=850450 $Y=912650
X1218 1934 1927 1 2 1931 NOR2X1 $T=854800 889520 1 180 $X=851570 $Y=889130
X1219 1911 1836 1 2 1938 NOR2X1 $T=853120 920880 1 0 $X=852690 $Y=916325
X1220 1847 1935 1 2 1925 NOR2X1 $T=854240 936560 0 0 $X=853810 $Y=936170
X1221 1965 1952 1 2 1962 NOR2X1 $T=860960 881680 0 180 $X=857730 $Y=877125
X1222 1737 1750 1 2 1892 NOR2X1 $T=858720 920880 1 0 $X=858290 $Y=916325
X1223 1760 1830 1 2 1966 NOR2X1 $T=862080 913040 0 180 $X=858850 $Y=908485
X1224 1966 1972 1 2 1961 NOR2X1 $T=860400 897360 0 0 $X=859970 $Y=896970
X1225 1999 1979 1 2 1992 NOR2X1 $T=870480 779760 1 180 $X=867250 $Y=779370
X1226 1994 1975 1 2 2000 NOR2X1 $T=871040 858160 0 180 $X=867810 $Y=853605
X1227 1994 2010 1 2 1989 NOR2X1 $T=869360 826800 0 0 $X=868930 $Y=826410
X1228 2000 2005 1 2 1990 NOR2X1 $T=872160 850320 0 180 $X=868930 $Y=845765
X1229 2042 333 1 2 1999 NOR2X1 $T=879440 779760 0 180 $X=876210 $Y=775205
X1230 2043 2040 1 2 2057 NOR2X1 $T=882240 866000 0 180 $X=879010 $Y=861445
X1231 2049 2064 1 2 2048 NOR2X1 $T=879440 905200 0 0 $X=879010 $Y=904810
X1232 1994 2038 1 2 2070 NOR2X1 $T=880560 850320 0 0 $X=880130 $Y=849930
X1233 1903 2043 1 2 2029 NOR2X1 $T=886160 826800 0 180 $X=882930 $Y=822245
X1234 2098 2073 1 2 2093 NOR2X1 $T=887280 873840 0 180 $X=884050 $Y=869285
X1235 2059 2109 1 2 2104 NOR2X1 $T=885600 881680 0 0 $X=885170 $Y=881290
X1236 2126 2118 1 2 2121 NOR2X1 $T=891760 826800 1 180 $X=888530 $Y=826410
X1237 2133 2116 1 2 2139 NOR2X1 $T=891760 928720 1 0 $X=891330 $Y=924165
X1238 1753 333 1 2 2143 NOR2X1 $T=894000 936560 0 0 $X=893570 $Y=936170
X1239 2043 2132 1 2 2126 NOR2X1 $T=895120 866000 1 0 $X=894690 $Y=861445
X1240 1967 2151 1 2 2192 NOR2X1 $T=905200 850320 0 180 $X=901970 $Y=845765
X1241 2170 2207 1 2 2202 NOR2X1 $T=903520 881680 0 0 $X=903090 $Y=881290
X1242 1722 2206 1 2 2136 NOR2X1 $T=904640 913040 0 0 $X=904210 $Y=912650
X1243 2225 2193 1 2 365 NOR2X1 $T=909120 873840 0 180 $X=905890 $Y=869285
X1244 2191 2234 1 2 2122 NOR2X1 $T=907440 834640 1 0 $X=907010 $Y=830085
X1245 2197 2235 1 2 2228 NOR2X1 $T=907440 842480 0 0 $X=907010 $Y=842090
X1246 2175 2252 1 2 2226 NOR2X1 $T=910240 897360 0 0 $X=909810 $Y=896970
X1247 1763 2175 1 2 2254 NOR2X1 $T=914160 905200 0 180 $X=910930 $Y=900645
X1248 2254 2112 1 2 2261 NOR2X1 $T=916960 905200 1 180 $X=913730 $Y=904810
X1249 2261 2270 1 2 2267 NOR2X1 $T=914720 897360 0 0 $X=914290 $Y=896970
X1250 2285 2277 1 2 2282 NOR2X1 $T=919760 811120 1 180 $X=916530 $Y=810730
X1251 2294 2273 1 2 2314 NOR2X1 $T=922560 826800 1 0 $X=922130 $Y=822245
X1252 2324 2317 1 2 2321 NOR2X1 $T=925920 842480 1 180 $X=922690 $Y=842090
X1253 2308 2328 1 2 2293 NOR2X1 $T=923680 779760 0 0 $X=923250 $Y=779370
X1254 2278 2321 1 2 2326 NOR2X1 $T=926480 850320 1 180 $X=923250 $Y=849930
X1255 2314 2354 1 2 2347 NOR2X1 $T=925920 826800 1 0 $X=925490 $Y=822245
X1256 2257 2200 1 2 2353 NOR2X1 $T=929280 803280 1 180 $X=926050 $Y=802890
X1257 131 2288 1 2 2360 NOR2X1 $T=929840 928720 1 180 $X=926610 $Y=928330
X1258 2368 2379 1 2 2369 NOR2X1 $T=928720 842480 1 0 $X=928290 $Y=837925
X1259 2326 2387 1 2 2359 NOR2X1 $T=929280 850320 0 0 $X=928850 $Y=849930
X1260 131 2388 1 2 2376 NOR2X1 $T=929280 866000 1 0 $X=928850 $Y=861445
X1261 2209 2258 1 2 2377 NOR2X1 $T=929840 803280 1 0 $X=929410 $Y=798725
X1262 2363 2399 1 2 2341 NOR2X1 $T=931520 905200 0 0 $X=931090 $Y=904810
X1263 2208 2362 1 2 2371 NOR2X1 $T=932080 795440 1 0 $X=931650 $Y=790885
X1264 2374 2377 1 2 2315 NOR2X1 $T=932640 826800 1 0 $X=932210 $Y=822245
X1265 2477 2438 1 2 2478 NOR2X1 $T=946640 842480 1 180 $X=943410 $Y=842090
X1266 2039 2276 1 2 2462 NOR2X1 $T=950560 732720 0 0 $X=950130 $Y=732330
X1267 398 2356 1 2 2508 NOR2X1 $T=953360 771920 1 180 $X=950130 $Y=771530
X1268 2425 2259 1 2 2365 NOR2X1 $T=950560 811120 1 0 $X=950130 $Y=806565
X1269 2278 2259 1 2 2440 NOR2X1 $T=953920 834640 0 180 $X=950690 $Y=830085
X1270 2521 2506 1 2 2516 NOR2X1 $T=956160 803280 1 180 $X=952930 $Y=802890
X1271 372 2531 1 2 401 NOR2X1 $T=956720 724880 0 0 $X=956290 $Y=724490
X1272 2529 2532 1 2 2531 NOR2X1 $T=956720 732720 0 0 $X=956290 $Y=732330
X1273 399 2533 1 2 402 NOR2X1 $T=958960 732720 1 0 $X=958530 $Y=728165
X1452 276 278 2 1 1684 XOR2X1 $T=780320 920880 1 0 $X=779890 $Y=916325
X1453 1404 292 2 1 295 XOR2X1 $T=801600 756240 0 0 $X=801170 $Y=755850
X1454 1646 292 2 1 1722 XOR2X1 $T=801600 920880 0 0 $X=801170 $Y=920490
X1455 1443 297 2 1 1733 XOR2X1 $T=805520 889520 1 0 $X=805090 $Y=884965
X1456 1450 305 2 1 1742 XOR2X1 $T=810000 897360 1 0 $X=809570 $Y=892805
X1457 592 304 2 1 1737 XOR2X1 $T=810000 905200 0 0 $X=809570 $Y=904810
X1458 1616 310 2 1 294 XOR2X1 $T=812800 764080 1 0 $X=812370 $Y=759525
X1459 1733 1737 2 1 1744 XOR2X1 $T=812800 913040 1 0 $X=812370 $Y=908485
X1460 1239 311 2 1 314 XOR2X1 $T=813360 771920 0 0 $X=812930 $Y=771530
X1461 634 311 2 1 1763 XOR2X1 $T=815600 873840 0 0 $X=815170 $Y=873450
X1462 1387 313 2 1 1765 XOR2X1 $T=816160 928720 0 0 $X=815730 $Y=928330
X1463 1398 316 2 1 1770 XOR2X1 $T=817840 897360 1 0 $X=817410 $Y=892805
X1464 1632 1753 2 1 307 XOR2X1 $T=818400 850320 0 0 $X=817970 $Y=849930
X1465 1303 1761 2 1 319 XOR2X1 $T=819520 779760 1 0 $X=819090 $Y=775205
X1466 1750 1776 2 1 1751 XOR2X1 $T=825680 905200 0 180 $X=819090 $Y=900645
X1467 294 319 2 1 1714 XOR2X1 $T=826240 764080 0 180 $X=819650 $Y=759525
X1468 1442 321 2 1 1731 XOR2X1 $T=827360 771920 1 180 $X=820770 $Y=771530
X1469 1394 320 2 1 1784 XOR2X1 $T=824000 936560 1 0 $X=823570 $Y=932005
X1470 1362 322 2 1 1804 XOR2X1 $T=824560 811120 0 0 $X=824130 $Y=810730
X1471 513 332 2 1 1903 XOR2X1 $T=841360 826800 1 0 $X=840930 $Y=822245
X1472 1943 337 2 1 1926 XOR2X1 $T=858160 771920 1 180 $X=851570 $Y=771530
X1473 1880 1956 2 1 1930 XOR2X1 $T=859280 787600 1 180 $X=852690 $Y=787210
X1474 1629 336 2 1 1967 XOR2X1 $T=854800 842480 1 0 $X=854370 $Y=837925
X1475 128 338 2 1 1971 XOR2X1 $T=855360 834640 0 0 $X=854930 $Y=834250
X1476 1462 1940 2 1 1975 XOR2X1 $T=857600 858160 0 0 $X=857170 $Y=857770
X1477 1633 345 2 1 1996 XOR2X1 $T=862080 928720 1 0 $X=861650 $Y=924165
X1478 2001 346 2 1 1981 XOR2X1 $T=870480 771920 0 180 $X=863890 $Y=767365
X1479 1955 1964 2 1 1982 XOR2X1 $T=870480 818960 0 180 $X=863890 $Y=814405
X1480 1917 2006 2 1 2003 XOR2X1 $T=876080 771920 1 180 $X=869490 $Y=771530
X1481 1639 348 2 1 2039 XOR2X1 $T=872160 756240 0 0 $X=871730 $Y=755850
X1482 1971 2030 2 1 2047 XOR2X1 $T=874960 834640 1 0 $X=874530 $Y=830085
X1483 1874 349 2 1 2067 XOR2X1 $T=876080 732720 0 0 $X=875650 $Y=732330
X1484 1996 1722 2 1 2116 XOR2X1 $T=882800 928720 1 0 $X=882370 $Y=924165
X1485 1640 352 2 1 2125 XOR2X1 $T=885040 936560 0 0 $X=884610 $Y=936170
X1486 1638 353 2 1 2135 XOR2X1 $T=886720 779760 1 0 $X=886290 $Y=775205
X1487 1500 347 2 1 2133 XOR2X1 $T=891200 881680 0 0 $X=890770 $Y=881290
X1488 1628 338 2 1 2200 XOR2X1 $T=898480 795440 0 0 $X=898050 $Y=795050
X1489 1551 348 2 1 2208 XOR2X1 $T=899600 764080 0 0 $X=899170 $Y=763690
X1490 33 357 2 1 2209 XOR2X1 $T=899600 811120 1 0 $X=899170 $Y=806565
X1491 1584 362 2 1 2043 XOR2X1 $T=905760 818960 0 180 $X=899170 $Y=814405
X1492 2216 364 2 1 2182 XOR2X1 $T=907440 748400 0 180 $X=900850 $Y=743845
X1493 1504 2095 2 1 2250 XOR2X1 $T=905760 756240 1 0 $X=905330 $Y=751685
X1494 2266 2077 2 1 2213 XOR2X1 $T=916400 779760 0 180 $X=909810 $Y=775205
X1495 1624 2042 2 1 2258 XOR2X1 $T=911360 795440 0 0 $X=910930 $Y=795050
X1496 1620 336 2 1 2259 XOR2X1 $T=911360 850320 1 0 $X=910930 $Y=845765
X1497 1432 357 2 1 2276 XOR2X1 $T=911920 764080 0 0 $X=911490 $Y=763690
X1498 1392 367 2 1 2278 XOR2X1 $T=915280 850320 0 0 $X=914850 $Y=849930
X1499 1340 1761 2 1 2302 XOR2X1 $T=915840 771920 0 0 $X=915410 $Y=771530
X1500 2305 2276 2 1 2268 XOR2X1 $T=922560 748400 1 180 $X=915970 $Y=748010
X1501 1634 321 2 1 2305 XOR2X1 $T=916400 771920 1 0 $X=915970 $Y=767365
X1502 2333 374 2 1 2300 XOR2X1 $T=927600 936560 0 180 $X=921010 $Y=932005
X1503 2359 381 2 1 2388 XOR2X1 $T=927600 858160 0 0 $X=927170 $Y=857770
X1504 2499 396 2 1 2476 XOR2X1 $T=950560 881680 1 180 $X=943970 $Y=881290
X1505 2250 372 2 1 2473 XOR2X1 $T=952800 764080 1 180 $X=946210 $Y=763690
X1506 2305 372 2 1 400 XOR2X1 $T=948880 724880 0 0 $X=948450 $Y=724490
X1507 2520 2494 2 1 397 XOR2X1 $T=957840 944400 1 180 $X=951250 $Y=944010
X1508 2524 2497 2 1 2509 XOR2X1 $T=958400 858160 1 180 $X=951810 $Y=857770
X1509 448 442 1 2 430 NAND2X1 $T=591600 834640 0 180 $X=588370 $Y=830085
X1510 536 19 1 2 527 NAND2X1 $T=600560 944400 1 180 $X=597330 $Y=944010
X1511 521 587 1 2 558 NAND2X1 $T=602240 826800 1 0 $X=601810 $Y=822245
X1512 595 571 1 2 565 NAND2X1 $T=606720 787600 1 180 $X=603490 $Y=787210
X1513 600 611 1 2 35 NAND2X1 $T=605600 920880 1 0 $X=605170 $Y=916325
X1514 659 676 1 2 536 NAND2X1 $T=610640 944400 0 0 $X=610210 $Y=944010
X1515 691 38 1 2 737 NAND2X1 $T=620160 834640 0 180 $X=616930 $Y=830085
X1516 61 762 1 2 735 NAND2X1 $T=619040 944400 1 0 $X=618610 $Y=939845
X1517 72 48 1 2 762 NAND2X1 $T=624640 944400 0 180 $X=621410 $Y=939845
X1518 793 59 1 2 766 NAND2X1 $T=625200 732720 1 180 $X=621970 $Y=732330
X1519 36 38 1 2 805 NAND2X1 $T=626320 905200 0 180 $X=623090 $Y=900645
X1520 810 765 1 2 799 NAND2X1 $T=626880 787600 1 180 $X=623650 $Y=787210
X1521 55 37 1 2 774 NAND2X1 $T=624640 944400 1 0 $X=624210 $Y=939845
X1522 83 67 1 2 659 NAND2X1 $T=629120 944400 1 180 $X=625890 $Y=944010
X1523 838 719 1 2 823 NAND2X1 $T=629680 795440 0 180 $X=626450 $Y=790885
X1524 84 48 1 2 792 NAND2X1 $T=628000 936560 0 0 $X=627570 $Y=936170
X1525 836 890 1 2 855 NAND2X1 $T=632480 756240 0 0 $X=632050 $Y=755850
X1526 940 955 1 2 917 NAND2X1 $T=638080 850320 0 0 $X=637650 $Y=849930
X1527 908 501 1 2 109 NAND2X1 $T=638080 897360 0 0 $X=637650 $Y=896970
X1528 984 538 1 2 981 NAND2X1 $T=643680 764080 0 180 $X=640450 $Y=759525
X1529 121 538 1 2 931 NAND2X1 $T=646480 928720 1 180 $X=643250 $Y=928330
X1530 973 501 1 2 1039 NAND2X1 $T=645920 920880 0 0 $X=645490 $Y=920490
X1531 1042 947 1 2 1040 NAND2X1 $T=649280 928720 1 180 $X=646050 $Y=928330
X1532 1114 141 1 2 1107 NAND2X1 $T=655440 928720 1 180 $X=652210 $Y=928330
X1533 886 12 1 2 1113 NAND2X1 $T=656000 834640 1 180 $X=652770 $Y=834250
X1534 1139 1132 1 2 1127 NAND2X1 $T=658240 756240 0 180 $X=655010 $Y=751685
X1535 1040 525 1 2 1114 NAND2X1 $T=655440 928720 0 0 $X=655010 $Y=928330
X1536 67 19 1 2 1190 NAND2X1 $T=663840 889520 0 180 $X=660610 $Y=884965
X1537 1240 525 1 2 1235 NAND2X1 $T=667760 858160 0 0 $X=667330 $Y=857770
X1538 173 538 1 2 962 NAND2X1 $T=670560 928720 0 180 $X=667330 $Y=924165
X1539 1255 172 1 2 1071 NAND2X1 $T=670560 928720 1 180 $X=667330 $Y=928330
X1540 167 176 1 2 963 NAND2X1 $T=671120 944400 0 180 $X=667890 $Y=939845
X1541 1264 1065 1 2 1021 NAND2X1 $T=669440 897360 0 0 $X=669010 $Y=896970
X1542 3 1225 1 2 1256 NAND2X1 $T=674480 748400 1 180 $X=671250 $Y=748010
X1543 1304 178 1 2 1037 NAND2X1 $T=675600 811120 0 180 $X=672370 $Y=806565
X1544 1278 1311 1 2 1237 NAND2X1 $T=677280 803280 1 180 $X=674050 $Y=802890
X1545 1364 1337 1 2 850 NAND2X1 $T=681760 811120 0 180 $X=678530 $Y=806565
X1546 1365 1356 1 2 66 NAND2X1 $T=681760 920880 1 180 $X=678530 $Y=920490
X1547 1357 1370 1 2 1154 NAND2X1 $T=679520 826800 1 0 $X=679090 $Y=822245
X1548 30 968 1 2 1366 NAND2X1 $T=682320 866000 1 180 $X=679090 $Y=865610
X1549 155 1261 1 2 1373 NAND2X1 $T=680640 803280 0 0 $X=680210 $Y=802890
X1550 188 1295 1 2 98 NAND2X1 $T=680640 905200 1 0 $X=680210 $Y=900645
X1551 1306 1381 1 2 13 NAND2X1 $T=680640 920880 1 0 $X=680210 $Y=916325
X1552 1324 50 1 2 1371 NAND2X1 $T=684000 756240 0 180 $X=680770 $Y=751685
X1553 1363 1370 1 2 1081 NAND2X1 $T=684000 834640 0 180 $X=680770 $Y=830085
X1554 1365 194 1 2 193 NAND2X1 $T=682320 944400 1 0 $X=681890 $Y=939845
X1555 1399 192 1 2 46 NAND2X1 $T=685120 944400 1 180 $X=681890 $Y=944010
X1556 1414 1407 1 2 1116 NAND2X1 $T=687920 811120 0 180 $X=684690 $Y=806565
X1557 1399 203 1 2 156 NAND2X1 $T=685120 944400 0 0 $X=684690 $Y=944010
X1558 1300 50 1 2 1431 NAND2X1 $T=687360 873840 1 0 $X=686930 $Y=869285
X1559 207 1314 1 2 76 NAND2X1 $T=689040 944400 1 0 $X=688610 $Y=939845
X1560 1386 1468 1 2 909 NAND2X1 $T=697440 905200 1 180 $X=694210 $Y=904810
X1561 182 204 1 2 170 NAND2X1 $T=697440 936560 1 180 $X=694210 $Y=936170
X1562 182 1445 1 2 1468 NAND2X1 $T=698000 913040 0 180 $X=694770 $Y=908485
X1563 201 217 1 2 207 NAND2X1 $T=698000 944400 1 180 $X=694770 $Y=944010
X1564 1484 1486 1 2 1245 NAND2X1 $T=695760 787600 0 0 $X=695330 $Y=787210
X1565 1363 1330 1 2 1076 NAND2X1 $T=695760 834640 0 0 $X=695330 $Y=834250
X1566 182 224 1 2 1408 NAND2X1 $T=695760 897360 0 0 $X=695330 $Y=896970
X1567 163 1261 1 2 1498 NAND2X1 $T=697440 842480 1 0 $X=697010 $Y=837925
X1568 231 3 1 2 1331 NAND2X1 $T=701920 944400 0 180 $X=698690 $Y=939845
X1569 182 234 1 2 1400 NAND2X1 $T=699680 928720 1 0 $X=699250 $Y=924165
X1570 1412 1381 1 2 116 NAND2X1 $T=703040 920880 1 180 $X=699810 $Y=920490
X1571 201 236 1 2 1430 NAND2X1 $T=700240 928720 0 0 $X=699810 $Y=928330
X1572 201 240 1 2 164 NAND2X1 $T=701360 944400 0 0 $X=700930 $Y=944010
X1573 1520 1457 1 2 130 NAND2X1 $T=705840 826800 0 180 $X=702610 $Y=822245
X1574 1375 48 1 2 1523 NAND2X1 $T=703040 913040 0 0 $X=702610 $Y=912650
X1575 154 149 1 2 1522 NAND2X1 $T=708080 764080 1 180 $X=704850 $Y=763690
X1576 201 1518 1 2 1484 NAND2X1 $T=705840 818960 0 0 $X=705410 $Y=818570
X1577 201 1553 1 2 1409 NAND2X1 $T=708640 803280 1 0 $X=708210 $Y=798725
X1578 154 130 1 2 1548 NAND2X1 $T=711440 842480 1 180 $X=708210 $Y=842090
X1579 1552 50 1 2 1434 NAND2X1 $T=711440 850320 0 180 $X=708210 $Y=845765
X1580 1290 50 1 2 1550 NAND2X1 $T=711440 850320 1 180 $X=708210 $Y=849930
X1581 182 1553 1 2 139 NAND2X1 $T=710320 779760 0 0 $X=709890 $Y=779370
X1582 182 232 1 2 172 NAND2X1 $T=710880 928720 1 0 $X=710450 $Y=924165
X1583 201 1576 1 2 1520 NAND2X1 $T=712000 818960 1 0 $X=711570 $Y=814405
X1584 201 1581 1 2 1547 NAND2X1 $T=713680 834640 1 0 $X=713250 $Y=830085
X1585 182 1526 1 2 1565 NAND2X1 $T=713680 834640 0 0 $X=713250 $Y=834250
X1586 949 3 1 2 1585 NAND2X1 $T=717600 756240 0 180 $X=714370 $Y=751685
X1587 154 1076 1 2 1593 NAND2X1 $T=716480 811120 0 0 $X=716050 $Y=810730
X1588 241 1429 1 2 1595 NAND2X1 $T=717600 873840 1 0 $X=717170 $Y=869285
X1589 1544 1609 1 2 107 NAND2X1 $T=717600 936560 0 0 $X=717170 $Y=936170
X1590 161 1604 1 2 1610 NAND2X1 $T=718720 834640 0 0 $X=718290 $Y=834250
X1591 1463 3 1 2 1608 NAND2X1 $T=721520 858160 0 180 $X=718290 $Y=853605
X1592 1562 1587 1 2 1618 NAND2X1 $T=723200 889520 1 180 $X=719970 $Y=889130
X1593 49 1200 1 2 1625 NAND2X1 $T=722640 811120 0 0 $X=722210 $Y=810730
X1594 7 1282 1 2 1623 NAND2X1 $T=725440 826800 1 180 $X=722210 $Y=826410
X1595 7 116 1 2 1627 NAND2X1 $T=725440 936560 0 180 $X=722210 $Y=932005
X1596 7 1200 1 2 1630 NAND2X1 $T=726000 818960 1 180 $X=722770 $Y=818570
X1597 237 1526 1 2 1637 NAND2X1 $T=727120 866000 1 0 $X=726690 $Y=861445
X1598 1783 1747 1 2 1785 NAND2X1 $T=824560 881680 0 0 $X=824130 $Y=881290
X1599 324 1772 1 2 1806 NAND2X1 $T=831840 803280 1 180 $X=828610 $Y=802890
X1600 1733 1800 1 2 1826 NAND2X1 $T=837440 897360 0 180 $X=834210 $Y=892805
X1601 1821 1852 1 2 1851 NAND2X1 $T=835760 897360 0 0 $X=835330 $Y=896970
X1602 1851 1832 1 2 1866 NAND2X1 $T=841360 897360 1 180 $X=838130 $Y=896970
X1603 1780 1850 1 2 1868 NAND2X1 $T=841920 897360 0 180 $X=838690 $Y=892805
X1604 1884 1802 1 2 1879 NAND2X1 $T=846400 905200 1 180 $X=843170 $Y=904810
X1605 1792 1854 1 2 1844 NAND2X1 $T=846960 873840 0 180 $X=843730 $Y=869285
X1606 131 316 1 2 1860 NAND2X1 $T=850880 803280 1 180 $X=847650 $Y=802890
X1607 1888 1909 1 2 1916 NAND2X1 $T=848080 866000 1 0 $X=847650 $Y=861445
X1608 333 1849 1 2 1924 NAND2X1 $T=853120 850320 1 180 $X=849890 $Y=849930
X1609 1928 1941 1 2 1934 NAND2X1 $T=852560 905200 1 0 $X=852130 $Y=900645
X1610 1930 88 1 2 1945 NAND2X1 $T=854240 795440 0 0 $X=853810 $Y=795050
X1611 1959 339 1 2 1957 NAND2X1 $T=859280 756240 1 180 $X=856050 $Y=755850
X1612 1949 1795 1 2 1968 NAND2X1 $T=862080 897360 0 180 $X=858850 $Y=892805
X1613 325 1956 1 2 2017 NAND2X1 $T=873840 803280 1 180 $X=870610 $Y=802890
X1614 2024 2041 1 2 2040 NAND2X1 $T=876640 866000 1 0 $X=876210 $Y=861445
X1615 88 2042 1 2 2055 NAND2X1 $T=879440 779760 1 0 $X=879010 $Y=775205
X1616 2127 2117 1 2 2123 NAND2X1 $T=891760 881680 0 180 $X=888530 $Y=877125
X1617 325 2077 1 2 2150 NAND2X1 $T=894000 756240 1 0 $X=893570 $Y=751685
X1618 88 347 1 2 2147 NAND2X1 $T=896240 748400 0 0 $X=895810 $Y=748010
X1619 325 347 1 2 2161 NAND2X1 $T=896240 771920 0 0 $X=895810 $Y=771530
X1620 2165 2043 1 2 2185 NAND2X1 $T=903520 858160 1 180 $X=900290 $Y=857770
X1621 2213 88 1 2 2168 NAND2X1 $T=906880 779760 0 180 $X=903650 $Y=775205
X1622 2230 2242 1 2 2217 NAND2X1 $T=908000 913040 1 0 $X=907570 $Y=908485
X1623 1967 2070 1 2 2222 NAND2X1 $T=909680 850320 0 0 $X=909250 $Y=849930
X1624 2251 2160 1 2 2241 NAND2X1 $T=912480 881680 1 180 $X=909250 $Y=881290
X1625 131 362 1 2 2240 NAND2X1 $T=915840 944400 1 180 $X=912610 $Y=944010
X1626 88 1753 1 2 369 NAND2X1 $T=919200 944400 0 0 $X=918770 $Y=944010
X1627 88 362 1 2 377 NAND2X1 $T=925360 944400 0 0 $X=924930 $Y=944010
X1628 2309 2325 1 2 2375 NAND2X1 $T=931520 913040 0 180 $X=928290 $Y=908485
X1629 2393 2318 1 2 2383 NAND2X1 $T=933200 811120 1 180 $X=929970 $Y=810730
X1630 2405 2058 1 2 2414 NAND2X1 $T=936000 913040 1 180 $X=932770 $Y=912650
X1631 2353 2209 1 2 2400 NAND2X1 $T=937680 826800 1 180 $X=934450 $Y=826410
X1632 2374 2208 1 2 2464 NAND2X1 $T=944960 818960 0 180 $X=941730 $Y=814405
X1633 88 1940 1 2 2448 NAND2X1 $T=948880 866000 0 180 $X=945650 $Y=861445
X1634 2476 88 1 2 2490 NAND2X1 $T=946080 897360 1 0 $X=945650 $Y=892805
X1635 2259 2425 1 2 2454 NAND2X1 $T=953360 803280 0 180 $X=950130 $Y=798725
X1636 387 2276 1 2 399 NAND2X1 $T=955600 732720 0 180 $X=952370 $Y=728165
X1637 2469 2534 1 2 2530 NAND2X1 $T=958960 771920 1 0 $X=958530 $Y=767365
X1638 452 1 2 7 INVX2 $T=592160 866000 1 180 $X=590050 $Y=865610
X1639 8 1 2 455 INVX2 $T=592720 928720 1 180 $X=590610 $Y=928330
X1640 462 1 2 451 INVX2 $T=593280 826800 1 180 $X=591170 $Y=826410
X1641 466 1 2 468 INVX2 $T=595520 881680 0 180 $X=593410 $Y=877125
X1642 17 1 2 4 INVX2 $T=598880 873840 0 180 $X=596770 $Y=869285
X1643 517 1 2 443 INVX2 $T=607280 866000 1 180 $X=605170 $Y=865610
X1644 602 1 2 537 INVX2 $T=607280 913040 0 180 $X=605170 $Y=908485
X1645 672 1 2 708 INVX2 $T=615120 858160 1 0 $X=614690 $Y=853605
X1646 28 1 2 52 INVX2 $T=615120 866000 1 0 $X=614690 $Y=861445
X1647 545 1 2 663 INVX2 $T=615680 873840 1 0 $X=615250 $Y=869285
X1648 19 1 2 700 INVX2 $T=620160 873840 1 0 $X=619730 $Y=869285
X1649 501 1 2 525 INVX2 $T=623520 748400 1 180 $X=621410 $Y=748010
X1650 740 1 2 538 INVX2 $T=627440 764080 1 180 $X=625330 $Y=763690
X1651 67 1 2 548 INVX2 $T=628560 897360 1 180 $X=626450 $Y=896970
X1652 793 1 2 832 INVX2 $T=628560 732720 0 0 $X=628130 $Y=732330
X1653 719 1 2 840 INVX2 $T=629120 873840 1 0 $X=628690 $Y=869285
X1654 587 1 2 862 INVX2 $T=634160 866000 0 180 $X=632050 $Y=861445
X1655 53 1 2 70 INVX2 $T=633600 866000 0 0 $X=633170 $Y=865610
X1656 912 1 2 6 INVX2 $T=637520 826800 0 0 $X=637090 $Y=826410
X1657 937 1 2 938 INVX2 $T=639200 732720 0 0 $X=638770 $Y=732330
X1658 907 1 2 621 INVX2 $T=640880 858160 0 180 $X=638770 $Y=853605
X1659 878 1 2 945 INVX2 $T=641440 756240 0 180 $X=639330 $Y=751685
X1660 1012 1 2 1025 INVX2 $T=645360 779760 1 0 $X=644930 $Y=775205
X1661 1061 1 2 1017 INVX2 $T=650400 732720 1 180 $X=648290 $Y=732330
X1662 1104 1 2 1152 INVX2 $T=657120 873840 1 0 $X=656690 $Y=869285
X1663 118 1 2 1126 INVX2 $T=657680 724880 0 0 $X=657250 $Y=724490
X1664 1144 1 2 1161 INVX2 $T=658240 858160 0 0 $X=657810 $Y=857770
X1665 1121 1 2 152 INVX2 $T=660480 850320 1 0 $X=660050 $Y=845765
X1666 145 1 2 1016 INVX2 $T=663280 724880 1 180 $X=661170 $Y=724490
X1667 1190 1 2 163 INVX2 $T=661600 889520 0 0 $X=661170 $Y=889130
X1668 1198 1 2 497 INVX2 $T=663840 873840 1 0 $X=663410 $Y=869285
X1669 1053 1 2 49 INVX2 $T=677840 873840 0 0 $X=677410 $Y=873450
X1670 870 1 2 23 INVX2 $T=682320 873840 1 180 $X=680210 $Y=873450
X1671 1446 1 2 1406 INVX2 $T=690160 889520 0 180 $X=688050 $Y=884965
X1672 1197 1 2 1530 INVX2 $T=705840 748400 0 0 $X=705410 $Y=748010
X1673 182 1 2 201 INVX2 $T=705840 787600 0 0 $X=705410 $Y=787210
X1674 115 1 2 250 INVX2 $T=708080 944400 0 0 $X=707650 $Y=944010
X1675 1521 1 2 1562 INVX2 $T=711440 889520 0 0 $X=711010 $Y=889130
X1676 241 1 2 1570 INVX2 $T=714800 936560 0 180 $X=712690 $Y=932005
X1677 1704 1 2 1719 INVX2 $T=804400 732720 0 0 $X=803970 $Y=732330
X1678 1710 1 2 298 INVX2 $T=806080 740560 0 0 $X=805650 $Y=740170
X1679 307 1 2 1717 INVX2 $T=816720 756240 0 180 $X=814610 $Y=751685
X1680 1684 1 2 1750 INVX2 $T=818400 913040 0 0 $X=817970 $Y=912650
X1681 1737 1 2 1755 INVX2 $T=818960 905200 0 0 $X=818530 $Y=904810
X1682 1714 1 2 1757 INVX2 $T=819520 756240 1 0 $X=819090 $Y=751685
X1683 1733 1 2 1762 INVX2 $T=821200 913040 1 0 $X=820770 $Y=908485
X1684 294 1 2 1768 INVX2 $T=822320 732720 0 0 $X=821890 $Y=732330
X1685 1742 1 2 1776 INVX2 $T=823440 897360 0 0 $X=823010 $Y=896970
X1686 319 1 2 306 INVX2 $T=829040 724880 1 180 $X=826930 $Y=724490
X1687 1795 1 2 1783 INVX2 $T=829040 889520 0 180 $X=826930 $Y=884965
X1688 1765 1 2 1800 INVX2 $T=827920 913040 0 0 $X=827490 $Y=912650
X1689 325 1 2 324 INVX2 $T=832400 811120 0 180 $X=830290 $Y=806565
X1690 314 1 2 290 INVX2 $T=833520 756240 0 180 $X=831410 $Y=751685
X1691 1805 1 2 1819 INVX2 $T=831840 889520 1 0 $X=831410 $Y=884965
X1692 1790 1 2 1787 INVX2 $T=835200 928720 1 0 $X=834770 $Y=924165
X1693 1771 1 2 1843 INVX2 $T=835760 748400 0 0 $X=835330 $Y=748010
X1694 1818 1 2 327 INVX2 $T=838000 724880 1 180 $X=835890 $Y=724490
X1695 1747 1 2 1814 INVX2 $T=837440 881680 0 0 $X=837010 $Y=881290
X1696 1826 1 2 1850 INVX2 $T=837440 897360 1 0 $X=837010 $Y=892805
X1697 1828 1 2 1842 INVX2 $T=838560 905200 0 0 $X=838130 $Y=904810
X1698 1775 1 2 1817 INVX2 $T=841360 889520 1 180 $X=839250 $Y=889130
X1699 1780 1 2 1846 INVX2 $T=841920 897360 1 0 $X=841490 $Y=892805
X1700 1784 1 2 1887 INVX2 $T=843040 928720 0 0 $X=842610 $Y=928330
X1701 1892 1 2 1901 INVX2 $T=845280 928720 0 0 $X=844850 $Y=928330
X1702 1905 1 2 1912 INVX2 $T=848080 913040 1 0 $X=847650 $Y=908485
X1703 343 1 2 344 INVX2 $T=860960 779760 1 0 $X=860530 $Y=775205
X1704 1976 1 2 1970 INVX2 $T=863200 826800 0 180 $X=861090 $Y=822245
X1705 1804 1 2 1994 INVX2 $T=866560 826800 1 0 $X=866130 $Y=822245
X1706 2004 1 2 1995 INVX2 $T=871040 834640 1 180 $X=868930 $Y=834250
X1707 2000 1 2 2028 INVX2 $T=873280 850320 0 0 $X=872850 $Y=849930
X1708 1903 1 2 2030 INVX2 $T=873840 834640 0 0 $X=873410 $Y=834250
X1709 1967 1 2 2035 INVX2 $T=874960 850320 1 0 $X=874530 $Y=845765
X1710 1975 1 2 2038 INVX2 $T=876080 858160 1 0 $X=875650 $Y=853605
X1711 2041 1 2 2022 INVX2 $T=878880 858160 1 180 $X=876770 $Y=857770
X1712 2040 1 2 2046 INVX2 $T=878320 866000 0 0 $X=877890 $Y=865610
X1713 2032 1 2 2050 INVX2 $T=878880 873840 0 0 $X=878450 $Y=873450
X1714 2051 1 2 2045 INVX2 $T=880560 897360 0 180 $X=878450 $Y=892805
X1715 2047 1 2 2083 INVX2 $T=882800 834640 1 0 $X=882370 $Y=830085
X1716 2029 1 2 2088 INVX2 $T=883920 842480 0 0 $X=883490 $Y=842090
X1717 2099 1 2 2106 INVX2 $T=886160 897360 0 0 $X=885730 $Y=896970
X1718 2092 1 2 2110 INVX2 $T=889520 850320 1 180 $X=887410 $Y=849930
X1719 2091 1 2 1986 INVX2 $T=894560 834640 0 180 $X=892450 $Y=830085
X1720 2043 1 2 2012 INVX2 $T=894560 834640 1 180 $X=892450 $Y=834250
X1721 2133 1 2 2142 INVX2 $T=898480 889520 1 0 $X=898050 $Y=884965
X1722 1770 1 2 2175 INVX2 $T=898480 897360 1 0 $X=898050 $Y=892805
X1723 2116 1 2 2176 INVX2 $T=898480 928720 0 0 $X=898050 $Y=928330
X1724 160 1 2 333 INVX2 $T=901280 936560 1 180 $X=899170 $Y=936170
X1725 2103 1 2 2019 INVX2 $T=904080 818960 1 180 $X=901970 $Y=818570
X1726 2166 1 2 2219 INVX2 $T=905200 905200 1 0 $X=904770 $Y=900645
X1727 2227 1 2 2237 INVX2 $T=908560 936560 1 0 $X=908130 $Y=932005
X1728 2070 1 2 2246 INVX2 $T=911360 866000 1 0 $X=910930 $Y=861445
X1729 2125 1 2 2206 INVX2 $T=913040 920880 0 180 $X=910930 $Y=916325
X1730 2230 1 2 2255 INVX2 $T=911920 928720 1 0 $X=911490 $Y=924165
X1731 2208 1 2 2257 INVX2 $T=914720 818960 0 180 $X=912610 $Y=814405
X1732 1996 1 2 2247 INVX2 $T=915840 905200 1 0 $X=915410 $Y=900645
X1733 2254 1 2 2275 INVX2 $T=916400 913040 1 0 $X=915970 $Y=908485
X1734 2210 1 2 2270 INVX2 $T=918080 897360 0 0 $X=917650 $Y=896970
X1735 2294 1 2 2291 INVX2 $T=920320 818960 1 180 $X=918210 $Y=818570
X1736 2296 1 2 2256 INVX2 $T=920880 913040 1 180 $X=918770 $Y=912650
X1737 2268 1 2 2292 INVX2 $T=921440 732720 1 180 $X=919330 $Y=732330
X1738 2209 1 2 2318 INVX2 $T=923680 795440 0 0 $X=923250 $Y=795050
X1739 2327 1 2 2335 INVX2 $T=924800 764080 0 0 $X=924370 $Y=763690
X1740 2200 1 2 2362 INVX2 $T=927600 795440 0 0 $X=927170 $Y=795050
X1741 2302 1 2 370 INVX2 $T=928720 732720 1 0 $X=928290 $Y=728165
X1742 2243 1 2 2252 INVX2 $T=928720 897360 1 0 $X=928290 $Y=892805
X1743 2304 1 2 2390 INVX2 $T=930400 756240 1 0 $X=929970 $Y=751685
X1744 2407 1 2 2412 INVX2 $T=933200 928720 1 0 $X=932770 $Y=924165
X1745 2039 1 2 372 INVX2 $T=935440 732720 0 180 $X=933330 $Y=728165
X1746 2377 1 2 2364 INVX2 $T=935440 787600 1 180 $X=933330 $Y=787210
X1747 383 1 2 2381 INVX2 $T=936000 764080 1 180 $X=933890 $Y=763690
X1748 2135 1 2 373 INVX2 $T=936000 740560 0 0 $X=935570 $Y=740170
X1749 2421 1 2 2284 INVX2 $T=936000 834640 1 0 $X=935570 $Y=830085
X1750 2305 1 2 2361 INVX2 $T=939360 756240 1 180 $X=937250 $Y=755850
X1751 2353 1 2 2429 INVX2 $T=942720 811120 0 180 $X=940610 $Y=806565
X1752 2348 1 2 2466 INVX2 $T=942720 756240 0 0 $X=942290 $Y=755850
X1753 2276 1 2 2419 INVX2 $T=944960 740560 1 180 $X=942850 $Y=740170
X1754 2473 1 2 2441 INVX2 $T=944960 771920 0 180 $X=942850 $Y=767365
X1755 2365 1 2 2286 INVX2 $T=947200 811120 0 180 $X=945090 $Y=806565
X1756 378 1 2 2456 INVX2 $T=947200 928720 0 180 $X=945090 $Y=924165
X1757 2250 1 2 2424 INVX2 $T=948320 740560 0 180 $X=946210 $Y=736005
X1758 2467 1 2 379 INVX2 $T=946640 740560 0 0 $X=946210 $Y=740170
X1759 2418 1 2 2482 INVX2 $T=946640 748400 1 0 $X=946210 $Y=743845
X1760 2259 1 2 2437 INVX2 $T=948320 795440 1 180 $X=946210 $Y=795050
X1761 2454 1 2 2420 INVX2 $T=951120 803280 1 180 $X=949010 $Y=802890
X1762 2278 1 2 2425 INVX2 $T=952800 811120 1 180 $X=950690 $Y=810730
X1763 2505 1 2 2457 INVX2 $T=958400 748400 0 180 $X=956290 $Y=743845
X1764 2533 1 2 2469 INVX2 $T=961200 756240 1 180 $X=959090 $Y=755850
X1765 2523 1 2 2534 INVX2 $T=960080 764080 0 0 $X=959650 $Y=763690
X2097 8 497 1 2 496 OR2X1 $T=594960 928720 0 0 $X=594530 $Y=928330
X2098 531 497 1 2 502 OR2X1 $T=600000 811120 0 180 $X=596210 $Y=806565
X2099 15 497 1 2 526 OR2X1 $T=597200 764080 0 0 $X=596770 $Y=763690
X2100 4 518 1 2 485 OR2X1 $T=597200 897360 1 0 $X=596770 $Y=892805
X2101 22 517 1 2 483 OR2X1 $T=600560 936560 0 180 $X=596770 $Y=932005
X2102 542 443 1 2 529 OR2X1 $T=602240 881680 0 180 $X=598450 $Y=877125
X2103 458 621 1 2 575 OR2X1 $T=610080 834640 0 180 $X=606290 $Y=830085
X2104 623 497 1 2 613 OR2X1 $T=610640 787600 0 180 $X=606850 $Y=783045
X2105 667 517 1 2 631 OR2X1 $T=612320 787600 1 180 $X=608530 $Y=787210
X2106 687 677 1 2 665 OR2X1 $T=614560 740560 0 180 $X=610770 $Y=736005
X2107 688 497 1 2 642 OR2X1 $T=614560 764080 1 180 $X=610770 $Y=763690
X2108 38 697 1 2 710 OR2X1 $T=613440 944400 0 0 $X=613010 $Y=944010
X2109 28 47 1 2 713 OR2X1 $T=614000 936560 0 0 $X=613570 $Y=936170
X2110 53 690 1 2 705 OR2X1 $T=618480 811120 0 180 $X=614690 $Y=806565
X2111 38 688 1 2 727 OR2X1 $T=615120 826800 0 0 $X=614690 $Y=826410
X2112 674 738 1 2 683 OR2X1 $T=617360 842480 1 0 $X=616930 $Y=837925
X2113 28 18 1 2 726 OR2X1 $T=620720 858160 0 180 $X=616930 $Y=853605
X2114 64 738 1 2 643 OR2X1 $T=621280 881680 1 180 $X=617490 $Y=881290
X2115 719 688 1 2 718 OR2X1 $T=621840 803280 0 180 $X=618050 $Y=798725
X2116 67 46 1 2 62 OR2X1 $T=622960 944400 1 180 $X=619170 $Y=944010
X2117 53 769 1 2 751 OR2X1 $T=620160 928720 0 0 $X=619730 $Y=928330
X2118 67 20 1 2 761 OR2X1 $T=624080 826800 1 180 $X=620290 $Y=826410
X2119 776 497 1 2 767 OR2X1 $T=624640 764080 1 180 $X=620850 $Y=763690
X2120 70 776 1 2 760 OR2X1 $T=624640 811120 1 180 $X=620850 $Y=810730
X2121 67 75 1 2 775 OR2X1 $T=626320 944400 1 180 $X=622530 $Y=944010
X2122 12 660 1 2 777 OR2X1 $T=629120 834640 0 180 $X=625330 $Y=830085
X2123 70 769 1 2 834 OR2X1 $T=625760 936560 1 0 $X=625330 $Y=932005
X2124 85 497 1 2 588 OR2X1 $T=629680 779760 1 180 $X=625890 $Y=779370
X2125 52 822 1 2 744 OR2X1 $T=629680 897360 0 180 $X=625890 $Y=892805
X2126 850 517 1 2 786 OR2X1 $T=630800 787600 1 180 $X=627010 $Y=787210
X2127 525 859 1 2 814 OR2X1 $T=633040 740560 1 180 $X=629250 $Y=740170
X2128 879 517 1 2 848 OR2X1 $T=634160 787600 1 180 $X=630370 $Y=787210
X2129 886 497 1 2 867 OR2X1 $T=634720 803280 1 180 $X=630930 $Y=802890
X2130 80 738 1 2 894 OR2X1 $T=631920 889520 1 0 $X=631490 $Y=884965
X2131 886 738 1 2 607 OR2X1 $T=636400 842480 0 180 $X=632610 $Y=837925
X2132 914 100 1 2 96 OR2X1 $T=637520 724880 1 180 $X=633730 $Y=724490
X2133 501 859 1 2 903 OR2X1 $T=634160 740560 0 0 $X=633730 $Y=740170
X2134 53 911 1 2 890 OR2X1 $T=638080 764080 1 180 $X=634290 $Y=763690
X2135 868 936 1 2 934 OR2X1 $T=636960 889520 0 0 $X=636530 $Y=889130
X2136 12 97 1 2 948 OR2X1 $T=636960 944400 1 0 $X=636530 $Y=939845
X2137 938 876 1 2 951 OR2X1 $T=638640 740560 1 0 $X=638210 $Y=736005
X2138 963 738 1 2 943 OR2X1 $T=645360 873840 1 180 $X=641570 $Y=873450
X2139 52 126 1 2 1035 OR2X1 $T=646480 905200 1 0 $X=646050 $Y=900645
X2140 938 921 1 2 131 OR2X1 $T=648160 732720 1 0 $X=647730 $Y=728165
X2141 52 1084 1 2 1036 OR2X1 $T=650400 944400 1 0 $X=649970 $Y=939845
X2142 28 136 1 2 134 OR2X1 $T=653760 944400 1 180 $X=649970 $Y=944010
X2143 548 458 1 2 1099 OR2X1 $T=656560 811120 1 180 $X=652770 $Y=810730
X2144 38 1124 1 2 956 OR2X1 $T=657120 850320 1 180 $X=653330 $Y=849930
X2145 548 148 1 2 1129 OR2X1 $T=659360 787600 0 180 $X=655570 $Y=783045
X2146 130 517 1 2 1147 OR2X1 $T=660480 842480 0 180 $X=656690 $Y=837925
X2147 548 861 1 2 1159 OR2X1 $T=657680 803280 1 0 $X=657250 $Y=798725
X2148 158 38 1 2 1108 OR2X1 $T=662160 936560 1 180 $X=658370 $Y=936170
X2149 1195 517 1 2 1165 OR2X1 $T=662720 913040 1 180 $X=658930 $Y=912650
X2150 162 497 1 2 1164 OR2X1 $T=662720 944400 1 180 $X=658930 $Y=944010
X2151 17 1104 1 2 1196 OR2X1 $T=659920 818960 0 0 $X=659490 $Y=818570
X2152 811 155 1 2 1205 OR2X1 $T=661040 818960 1 0 $X=660610 $Y=814405
X2153 1200 497 1 2 1219 OR2X1 $T=663280 850320 1 0 $X=662850 $Y=845765
X2154 1177 1198 1 2 1150 OR2X1 $T=666640 866000 0 180 $X=662850 $Y=861445
X2155 542 1190 1 2 1228 OR2X1 $T=664400 889520 1 0 $X=663970 $Y=884965
X2156 104 123 1 2 1233 OR2X1 $T=664960 818960 1 0 $X=664530 $Y=814405
X2157 1261 497 1 2 1166 OR2X1 $T=670560 842480 0 180 $X=666770 $Y=837925
X2158 1124 517 1 2 1230 OR2X1 $T=671120 850320 0 180 $X=667330 $Y=845765
X2159 839 123 1 2 1280 OR2X1 $T=669440 842480 0 0 $X=669010 $Y=842090
X2160 732 155 1 2 1308 OR2X1 $T=672240 850320 1 0 $X=671810 $Y=845765
X2161 1274 1140 1 2 1324 OR2X1 $T=673920 764080 1 0 $X=673490 $Y=759525
X2162 542 1053 1 2 1368 OR2X1 $T=678400 889520 1 0 $X=677970 $Y=884965
X2163 48 1177 1 2 1519 OR2X1 $T=701360 866000 1 0 $X=700930 $Y=861445
X2164 242 1502 1 2 247 OR2X1 $T=704720 944400 0 0 $X=704290 $Y=944010
X2165 248 1521 1 2 252 OR2X1 $T=707520 897360 1 0 $X=707090 $Y=892805
X2166 222 237 1 2 1561 OR2X1 $T=709760 858160 0 0 $X=709330 $Y=857770
X2167 239 1502 1 2 1569 OR2X1 $T=710880 889520 1 0 $X=710450 $Y=884965
X2168 48 254 1 2 1577 OR2X1 $T=711440 920880 1 0 $X=711010 $Y=916325
X2169 1525 1502 1 2 1599 OR2X1 $T=715920 881680 1 0 $X=715490 $Y=877125
X2170 217 1502 1 2 1600 OR2X1 $T=715920 920880 1 0 $X=715490 $Y=916325
X2171 209 1502 1 2 1602 OR2X1 $T=716480 913040 1 0 $X=716050 $Y=908485
X2172 1478 237 1 2 1571 OR2X1 $T=716480 928720 0 0 $X=716050 $Y=928330
X2173 236 237 1 2 1558 OR2X1 $T=725440 897360 1 180 $X=721650 $Y=896970
X2174 1740 293 1 2 1730 OR2X1 $T=816720 740560 0 180 $X=812930 $Y=736005
X2175 1762 1760 1 2 1745 OR2X1 $T=823440 920880 1 180 $X=819650 $Y=920490
X2176 307 1714 1 2 1769 OR2X1 $T=820640 756240 0 0 $X=820210 $Y=755850
X2177 1792 1787 1 2 1774 OR2X1 $T=827920 873840 1 180 $X=824130 $Y=873450
X2178 308 1757 1 2 1793 OR2X1 $T=825120 748400 0 0 $X=824690 $Y=748010
X2179 1807 1813 1 2 1820 OR2X1 $T=830720 873840 1 0 $X=830290 $Y=869285
X2180 1800 1784 1 2 1802 OR2X1 $T=830720 913040 1 0 $X=830290 $Y=908485
X2181 1800 1760 1 2 1827 OR2X1 $T=831280 920880 1 0 $X=830850 $Y=916325
X2182 1773 325 1 2 1838 OR2X1 $T=833520 811120 0 0 $X=833090 $Y=810730
X2183 1841 1854 1 2 1859 OR2X1 $T=836320 866000 0 0 $X=835890 $Y=865610
X2184 1747 1863 1 2 1873 OR2X1 $T=839120 936560 0 0 $X=838690 $Y=936170
X2185 1840 325 1 2 1888 OR2X1 $T=841360 858160 0 0 $X=840930 $Y=857770
X2186 1766 1846 1 2 1889 OR2X1 $T=841360 881680 0 0 $X=840930 $Y=881290
X2187 1775 1802 1 2 1893 OR2X1 $T=841920 913040 1 0 $X=841490 $Y=908485
X2188 1761 333 1 2 1896 OR2X1 $T=843600 795440 0 0 $X=843170 $Y=795050
X2189 1901 1906 1 2 1915 OR2X1 $T=846960 936560 1 0 $X=846530 $Y=932005
X2190 1869 1900 1 2 1920 OR2X1 $T=848080 928720 0 0 $X=847650 $Y=928330
X2191 1833 325 1 2 1953 OR2X1 $T=854240 944400 1 0 $X=853810 $Y=939845
X2192 1750 1938 1 2 1950 OR2X1 $T=859840 920880 1 180 $X=856050 $Y=920490
X2193 1975 1969 1 2 1960 OR2X1 $T=862640 858160 0 180 $X=858850 $Y=853605
X2194 2087 2080 1 2 2071 OR2X1 $T=885040 889520 1 180 $X=881250 $Y=889130
X2195 2088 2044 1 2 1984 OR2X1 $T=887280 850320 0 180 $X=883490 $Y=845765
X2196 2014 2103 1 2 2113 OR2X1 $T=885600 811120 0 0 $X=885170 $Y=810730
X2197 2112 2105 1 2 2097 OR2X1 $T=888960 913040 1 180 $X=885170 $Y=912650
X2198 1994 1971 1 2 2128 OR2X1 $T=888400 842480 1 0 $X=887970 $Y=837925
X2199 2082 2053 1 2 2117 OR2X1 $T=891760 873840 0 180 $X=887970 $Y=869285
X2200 1763 2125 1 2 2079 OR2X1 $T=892320 920880 0 180 $X=888530 $Y=916325
X2201 2136 2106 1 2 2120 OR2X1 $T=892880 905200 0 180 $X=889090 $Y=900645
X2202 2082 2033 1 2 2148 OR2X1 $T=891760 873840 1 0 $X=891330 $Y=869285
X2203 2143 356 1 2 2154 OR2X1 $T=893440 944400 1 0 $X=893010 $Y=939845
X2204 2160 2152 1 2 2085 OR2X1 $T=897360 920880 0 180 $X=893570 $Y=916325
X2205 2167 2157 1 2 2138 OR2X1 $T=898480 905200 1 180 $X=894690 $Y=904810
X2206 2019 2145 1 2 2173 OR2X1 $T=899040 818960 0 0 $X=898610 $Y=818570
X2207 1763 2243 1 2 2195 OR2X1 $T=911920 897360 0 180 $X=908130 $Y=892805
X2208 2246 2228 1 2 2229 OR2X1 $T=914160 866000 1 180 $X=910370 $Y=865610
X2209 2272 2280 1 2 2289 OR2X1 $T=916400 795440 1 0 $X=915970 $Y=790885
X2210 2273 2284 1 2 2295 OR2X1 $T=916960 826800 0 0 $X=916530 $Y=826410
X2211 2250 368 1 2 2298 OR2X1 $T=918080 748400 1 0 $X=917650 $Y=743845
X2212 2200 2258 1 2 2297 OR2X1 $T=923680 803280 0 180 $X=919890 $Y=798725
X2213 2258 2294 1 2 2322 OR2X1 $T=922000 803280 0 0 $X=921570 $Y=802890
X2214 2058 2336 1 2 2334 OR2X1 $T=928720 920880 0 180 $X=924930 $Y=916325
X2215 2257 2273 1 2 2339 OR2X1 $T=929280 818960 0 180 $X=925490 $Y=814405
X2216 2329 2203 1 2 2363 OR2X1 $T=925920 905200 0 0 $X=925490 $Y=904810
X2217 2080 2355 1 2 2350 OR2X1 $T=926480 889520 0 0 $X=926050 $Y=889130
X2218 380 2376 1 2 2391 OR2X1 $T=928720 866000 0 0 $X=928290 $Y=865610
X2219 2349 2381 1 2 2373 OR2X1 $T=932640 764080 0 180 $X=928850 $Y=759525
X2220 383 2382 1 2 2351 OR2X1 $T=932640 764080 1 180 $X=928850 $Y=763690
X2221 2366 2360 1 2 2408 OR2X1 $T=930960 936560 0 0 $X=930530 $Y=936170
X2222 1763 2252 1 2 2411 OR2X1 $T=931520 889520 1 0 $X=931090 $Y=884965
X2223 2415 2315 1 2 2396 OR2X1 $T=935440 834640 0 180 $X=931650 $Y=830085
X2224 2496 2484 1 2 393 OR2X1 $T=948880 779760 1 180 $X=945090 $Y=779370
X2225 2466 395 1 2 2479 OR2X1 $T=946640 771920 1 0 $X=946210 $Y=767365
X2226 2259 2284 1 2 2488 OR2X1 $T=951680 834640 1 180 $X=947890 $Y=834250
X2227 2467 2401 1 2 2519 OR2X1 $T=953920 740560 0 0 $X=953490 $Y=740170
X2246 488 501 552 1 2 33 MUX2X1 $T=601120 818960 0 0 $X=600690 $Y=818570
X2247 39 37 477 1 2 573 MUX2X1 $T=610640 818960 0 180 $X=604610 $Y=814405
X2248 477 37 9 1 2 690 MUX2X1 $T=608960 818960 0 0 $X=608530 $Y=818570
X2249 46 48 36 1 2 570 MUX2X1 $T=615120 913040 0 180 $X=609090 $Y=908485
X2250 47 37 10 1 2 569 MUX2X1 $T=615120 920880 1 180 $X=609090 $Y=920490
X2251 730 37 660 1 2 572 MUX2X1 $T=619600 811120 1 180 $X=613570 $Y=810730
X2252 691 37 531 1 2 741 MUX2X1 $T=624640 811120 0 180 $X=618610 $Y=806565
X2253 66 37 74 1 2 769 MUX2X1 $T=620720 928720 1 0 $X=620290 $Y=924165
X2254 680 37 730 1 2 436 MUX2X1 $T=627440 826800 0 180 $X=621410 $Y=822245
X2255 811 37 69 1 2 521 MUX2X1 $T=628000 818960 0 180 $X=621970 $Y=814405
X2256 20 37 811 1 2 546 MUX2X1 $T=630240 803280 1 180 $X=624210 $Y=802890
X2257 39 37 623 1 2 795 MUX2X1 $T=630240 811120 0 180 $X=624210 $Y=806565
X2258 661 48 79 1 2 804 MUX2X1 $T=630800 811120 1 180 $X=624770 $Y=810730
X2259 691 37 680 1 2 557 MUX2X1 $T=630800 826800 1 180 $X=624770 $Y=826410
X2260 788 37 79 1 2 625 MUX2X1 $T=626320 858160 1 0 $X=625890 $Y=853605
X2261 850 37 839 1 2 746 MUX2X1 $T=633040 803280 0 180 $X=627010 $Y=798725
X2262 864 37 822 1 2 44 MUX2X1 $T=633040 913040 0 180 $X=627010 $Y=908485
X2263 696 37 32 1 2 90 MUX2X1 $T=627440 944400 1 0 $X=627010 $Y=939845
X2264 69 37 788 1 2 800 MUX2X1 $T=628560 834640 0 0 $X=628130 $Y=834250
X2265 92 48 72 1 2 754 MUX2X1 $T=634720 944400 1 180 $X=628690 $Y=944010
X2266 667 48 856 1 2 729 MUX2X1 $T=635280 787600 0 180 $X=629250 $Y=783045
X2267 660 37 781 1 2 820 MUX2X1 $T=629680 834640 1 0 $X=629250 $Y=830085
X2268 505 48 856 1 2 837 MUX2X1 $T=635840 795440 0 180 $X=629810 $Y=790885
X2269 850 37 721 1 2 895 MUX2X1 $T=630240 811120 1 0 $X=629810 $Y=806565
X2270 27 37 80 1 2 896 MUX2X1 $T=630240 905200 1 0 $X=629810 $Y=900645
X2271 97 48 84 1 2 21 MUX2X1 $T=636400 936560 1 180 $X=630370 $Y=936170
X2272 864 48 909 1 2 582 MUX2X1 $T=640320 905200 1 180 $X=634290 $Y=904810
X2273 88 37 945 1 2 957 MUX2X1 $T=635280 756240 0 0 $X=634850 $Y=755850
X2274 732 48 79 1 2 968 MUX2X1 $T=635840 866000 1 0 $X=635410 $Y=861445
X2275 622 48 819 1 2 901 MUX2X1 $T=636400 787600 1 0 $X=635970 $Y=783045
X2276 112 48 869 1 2 689 MUX2X1 $T=642000 787600 1 180 $X=635970 $Y=787210
X2277 958 48 661 1 2 885 MUX2X1 $T=642000 795440 0 180 $X=635970 $Y=790885
X2278 104 48 959 1 2 970 MUX2X1 $T=636400 811120 0 0 $X=635970 $Y=810730
X2279 622 37 856 1 2 939 MUX2X1 $T=644240 779760 0 180 $X=638210 $Y=775205
X2280 985 37 110 1 2 808 MUX2X1 $T=644240 779760 1 180 $X=638210 $Y=779370
X2281 977 48 781 1 2 780 MUX2X1 $T=640880 826800 0 0 $X=640450 $Y=826410
X2282 76 37 978 1 2 81 MUX2X1 $T=646480 913040 0 180 $X=640450 $Y=908485
X2283 122 48 959 1 2 695 MUX2X1 $T=647600 787600 1 180 $X=641570 $Y=787210
X2284 1037 37 985 1 2 849 MUX2X1 $T=649280 764080 1 180 $X=643250 $Y=763690
X2285 879 37 1037 1 2 984 MUX2X1 $T=644240 764080 1 0 $X=643810 $Y=759525
X2286 1151 48 978 1 2 518 MUX2X1 $T=659360 905200 1 180 $X=653330 $Y=904810
X2287 477 37 5 1 2 1082 MUX2X1 $T=664960 858160 0 180 $X=658930 $Y=853605
X2288 51 48 169 1 2 610 MUX2X1 $T=662160 928720 1 0 $X=661730 $Y=924165
X2289 1202 48 1195 1 2 171 MUX2X1 $T=662160 928720 0 0 $X=661730 $Y=928330
X2290 1234 37 1211 1 2 1168 MUX2X1 $T=669440 764080 0 180 $X=663410 $Y=759525
X2291 99 48 1210 1 2 883 MUX2X1 $T=669440 905200 0 180 $X=663410 $Y=900645
X2292 158 48 1202 1 2 173 MUX2X1 $T=663840 936560 0 0 $X=663410 $Y=936170
X2293 142 37 1234 1 2 1252 MUX2X1 $T=664400 771920 0 0 $X=663970 $Y=771530
X2294 1154 48 1237 1 2 1225 MUX2X1 $T=664400 787600 0 0 $X=663970 $Y=787210
X2295 958 37 879 1 2 911 MUX2X1 $T=664960 764080 0 0 $X=664530 $Y=763690
X2296 667 37 959 1 2 1258 MUX2X1 $T=664960 771920 1 0 $X=664530 $Y=767365
X2297 1245 37 674 1 2 1193 MUX2X1 $T=670560 779760 0 180 $X=664530 $Y=775205
X2298 958 48 721 1 2 1259 MUX2X1 $T=664960 787600 1 0 $X=664530 $Y=783045
X2299 1282 48 1237 1 2 838 MUX2X1 $T=673920 795440 0 180 $X=667890 $Y=790885
X2300 1211 37 133 1 2 1265 MUX2X1 $T=671680 756240 0 0 $X=671250 $Y=755850
X2301 1244 37 1321 1 2 821 MUX2X1 $T=680640 858160 0 180 $X=674610 $Y=853605
X2302 133 37 1350 1 2 1208 MUX2X1 $T=675600 756240 1 0 $X=675170 $Y=751685
X2303 932 37 1345 1 2 1186 MUX2X1 $T=683440 764080 1 180 $X=677410 $Y=763690
X2304 1054 182 1013 1 2 1401 MUX2X1 $T=679520 748400 0 0 $X=679090 $Y=748010
X2305 1321 37 1005 1 2 1290 MUX2X1 $T=680640 858160 1 0 $X=680210 $Y=853605
X2306 1405 37 1128 1 2 547 MUX2X1 $T=686800 858160 1 180 $X=680770 $Y=857770
X2307 148 37 1372 1 2 949 MUX2X1 $T=682880 771920 1 0 $X=682450 $Y=767365
X2308 1345 37 149 1 2 1030 MUX2X1 $T=689040 764080 1 180 $X=683010 $Y=763690
X2309 206 208 200 1 2 198 MUX2X1 $T=691280 724880 1 180 $X=685250 $Y=724490
X2310 1350 37 1245 1 2 1309 MUX2X1 $T=693520 764080 0 180 $X=687490 $Y=759525
X2311 204 182 1445 1 2 158 MUX2X1 $T=697440 936560 0 180 $X=691410 $Y=932005
X2312 1445 208 214 1 2 1473 MUX2X1 $T=699120 764080 0 180 $X=693090 $Y=759525
X2313 1482 208 215 1 2 1480 MUX2X1 $T=699680 724880 1 180 $X=693650 $Y=724490
X2314 1326 37 1405 1 2 1491 MUX2X1 $T=694640 866000 1 0 $X=694210 $Y=861445
X2315 99 37 221 1 2 1300 MUX2X1 $T=701360 897360 0 180 $X=695330 $Y=892805
X2316 1460 37 932 1 2 1448 MUX2X1 $T=704720 764080 0 180 $X=698690 $Y=759525
X2317 184 37 235 1 2 1335 MUX2X1 $T=706400 920880 0 180 $X=700370 $Y=916325
X2318 221 37 1375 1 2 1501 MUX2X1 $T=701360 897360 1 0 $X=700930 $Y=892805
X2319 239 208 255 1 2 256 MUX2X1 $T=712000 724880 0 0 $X=711570 $Y=724490
X2320 1483 208 260 1 2 1631 MUX2X1 $T=719840 787600 0 0 $X=719410 $Y=787210
X2321 1452 208 263 1 2 1642 MUX2X1 $T=738880 724880 0 0 $X=738450 $Y=724490
X2322 1532 208 1641 1 2 1643 MUX2X1 $T=739440 748400 1 0 $X=739010 $Y=743845
X2323 1478 208 265 1 2 1644 MUX2X1 $T=740560 756240 0 0 $X=740130 $Y=755850
X2324 1549 208 1647 1 2 1650 MUX2X1 $T=751200 779760 1 0 $X=750770 $Y=775205
X2325 1507 208 1649 1 2 1652 MUX2X1 $T=751760 787600 0 0 $X=751330 $Y=787210
X2326 1576 208 1651 1 2 1653 MUX2X1 $T=752320 803280 1 0 $X=751890 $Y=798725
X2327 1553 208 1654 1 2 1657 MUX2X1 $T=753440 803280 0 0 $X=753010 $Y=802890
X2328 1581 208 1655 1 2 1658 MUX2X1 $T=753440 818960 0 0 $X=753010 $Y=818570
X2329 236 208 1656 1 2 1659 MUX2X1 $T=753440 826800 1 0 $X=753010 $Y=822245
X2330 1527 208 1660 1 2 1663 MUX2X1 $T=754560 866000 1 0 $X=754130 $Y=861445
X2331 1525 208 1662 1 2 1664 MUX2X1 $T=755680 826800 0 0 $X=755250 $Y=826410
X2332 1514 208 268 1 2 1665 MUX2X1 $T=755680 850320 1 0 $X=755250 $Y=845765
X2333 226 208 1666 1 2 1668 MUX2X1 $T=759600 873840 0 0 $X=759170 $Y=873450
X2334 1526 208 1667 1 2 1669 MUX2X1 $T=759600 897360 1 0 $X=759170 $Y=892805
X2335 1546 208 269 1 2 1670 MUX2X1 $T=759600 905200 0 0 $X=759170 $Y=904810
X2336 1575 208 270 1 2 1671 MUX2X1 $T=759600 913040 0 0 $X=759170 $Y=912650
X2337 1518 208 271 1 2 1673 MUX2X1 $T=761840 920880 1 0 $X=761410 $Y=916325
X2338 1438 208 272 1 2 1674 MUX2X1 $T=761840 936560 0 0 $X=761410 $Y=936170
X2339 1429 208 273 1 2 1675 MUX2X1 $T=761840 944400 1 0 $X=761410 $Y=939845
X2340 1508 208 1672 1 2 1676 MUX2X1 $T=762400 866000 1 0 $X=761970 $Y=861445
X2341 1677 274 1641 1 2 1679 MUX2X1 $T=777520 740560 1 0 $X=777090 $Y=736005
X2342 275 279 1677 1 2 1678 MUX2X1 $T=784240 740560 1 180 $X=778210 $Y=740170
X2343 275 274 1656 1 2 1682 MUX2X1 $T=778640 756240 1 0 $X=778210 $Y=751685
X2344 1661 279 280 1 2 1687 MUX2X1 $T=782560 764080 1 0 $X=782130 $Y=759525
X2345 280 274 1649 1 2 1680 MUX2X1 $T=788160 771920 1 180 $X=782130 $Y=771530
X2346 1683 274 1662 1 2 1688 MUX2X1 $T=782560 826800 0 0 $X=782130 $Y=826410
X2347 281 274 269 1 2 1681 MUX2X1 $T=788160 936560 1 180 $X=782130 $Y=936170
X2348 1661 274 1651 1 2 1689 MUX2X1 $T=783680 803280 1 0 $X=783250 $Y=798725
X2349 1685 279 1661 1 2 1686 MUX2X1 $T=792640 866000 0 180 $X=786610 $Y=861445
X2350 1683 279 283 1 2 1694 MUX2X1 $T=790400 889520 1 0 $X=789970 $Y=884965
X2351 1692 274 1647 1 2 1695 MUX2X1 $T=790960 803280 0 0 $X=790530 $Y=802890
X2352 282 279 1685 1 2 1696 MUX2X1 $T=790960 905200 0 0 $X=790530 $Y=904810
X2353 1692 279 1683 1 2 1690 MUX2X1 $T=797120 826800 1 180 $X=791090 $Y=826410
X2354 1685 274 268 1 2 1691 MUX2X1 $T=797120 873840 1 180 $X=791090 $Y=873450
X2355 283 274 270 1 2 1697 MUX2X1 $T=791520 920880 0 0 $X=791090 $Y=920490
X2356 284 274 1660 1 2 1699 MUX2X1 $T=793200 858160 1 0 $X=792770 $Y=853605
X2357 1703 279 1692 1 2 1693 MUX2X1 $T=801040 818960 1 180 $X=795010 $Y=818570
X2358 1705 274 287 1 2 285 MUX2X1 $T=802720 944400 0 180 $X=796690 $Y=939845
X2359 1720 279 284 1 2 1708 MUX2X1 $T=807200 858160 0 180 $X=801170 $Y=853605
X2360 1677 279 1718 1 2 1724 MUX2X1 $T=802720 764080 1 0 $X=802290 $Y=759525
X2361 1703 274 1666 1 2 1712 MUX2X1 $T=808320 834640 0 180 $X=802290 $Y=830085
X2362 1718 274 1655 1 2 1715 MUX2X1 $T=809440 771920 1 180 $X=803410 $Y=771530
X2363 1718 279 1720 1 2 1729 MUX2X1 $T=803840 795440 0 0 $X=803410 $Y=795050
X2364 1720 274 1654 1 2 1716 MUX2X1 $T=809440 818960 1 180 $X=803410 $Y=818570
X2365 299 274 1667 1 2 1734 MUX2X1 $T=806080 944400 1 0 $X=805650 $Y=939845
X2366 1705 279 1700 1 2 1735 MUX2X1 $T=807760 866000 1 0 $X=807330 $Y=861445
X2367 1700 274 1672 1 2 1738 MUX2X1 $T=810000 858160 1 0 $X=809570 $Y=853605
X2368 1700 279 1703 1 2 1741 MUX2X1 $T=810560 834640 1 0 $X=810130 $Y=830085
X2369 312 279 1705 1 2 1756 MUX2X1 $T=815040 944400 0 0 $X=814610 $Y=944010
X2370 309 294 308 1 2 1754 MUX2X1 $T=815600 748400 1 0 $X=815170 $Y=743845
X2371 1727 318 1662 1 2 1748 MUX2X1 $T=824000 795440 1 180 $X=817970 $Y=795050
X2372 1765 1776 1802 1 2 1805 MUX2X1 $T=825120 913040 1 0 $X=824690 $Y=908485
X2373 1793 290 1771 1 2 1767 MUX2X1 $T=826800 748400 1 0 $X=826370 $Y=743845
X2374 1833 318 1667 1 2 1809 MUX2X1 $T=836320 944400 1 180 $X=830290 $Y=944010
X2375 1840 318 1660 1 2 1815 MUX2X1 $T=838000 858160 1 180 $X=831970 $Y=857770
X2376 1848 318 1672 1 2 1823 MUX2X1 $T=839120 834640 1 180 $X=833090 $Y=834250
X2377 1849 318 1654 1 2 1824 MUX2X1 $T=839120 842480 0 180 $X=833090 $Y=837925
X2378 1856 318 1647 1 2 1831 MUX2X1 $T=840240 795440 1 180 $X=834210 $Y=795050
X2379 1773 318 1666 1 2 1837 MUX2X1 $T=841360 826800 0 180 $X=835330 $Y=822245
X2380 1846 1762 1863 1 2 1870 MUX2X1 $T=835760 920880 1 0 $X=835330 $Y=916325
X2381 1794 290 1843 1 2 331 MUX2X1 $T=837440 748400 1 0 $X=837010 $Y=743845
X2382 1883 318 1651 1 2 1865 MUX2X1 $T=845280 787600 1 180 $X=839250 $Y=787210
X2383 1890 318 1649 1 2 1867 MUX2X1 $T=845840 779760 1 180 $X=839810 $Y=779370
X2384 1898 318 1655 1 2 1872 MUX2X1 $T=846960 771920 1 180 $X=840930 $Y=771530
X2385 1902 318 1656 1 2 1877 MUX2X1 $T=848080 748400 1 180 $X=842050 $Y=748010
X2386 1913 318 265 1 2 1897 MUX2X1 $T=850880 740560 1 180 $X=844850 $Y=740170
X2387 342 318 1641 1 2 335 MUX2X1 $T=860960 732720 0 180 $X=854930 $Y=728165
X2388 1993 1903 1983 1 2 1978 MUX2X1 $T=868800 842480 0 180 $X=862770 $Y=837925
X2389 2003 131 1992 1 2 1988 MUX2X1 $T=871600 779760 0 180 $X=865570 $Y=775205
X2390 2025 318 271 1 2 1998 MUX2X1 $T=874400 936560 1 180 $X=868370 $Y=936170
X2391 2004 1971 2043 1 2 2145 MUX2X1 $T=888960 826800 1 0 $X=888530 $Y=822245
X2392 2092 2083 2028 1 2 2151 MUX2X1 $T=890080 850320 0 0 $X=889650 $Y=849930
X2393 2033 2009 2024 1 2 2115 MUX2X1 $T=896240 858160 0 180 $X=890210 $Y=853605
X2394 2130 2166 2105 1 2 2159 MUX2X1 $T=902400 913040 1 180 $X=896370 $Y=912650
X2395 2154 88 378 1 2 2366 MUX2X1 $T=923680 944400 1 0 $X=923250 $Y=939845
X2396 379 2039 373 1 2 2323 MUX2X1 $T=930400 740560 1 180 $X=924370 $Y=740170
X2397 2243 1763 2130 1 2 2380 MUX2X1 $T=925360 897360 0 0 $X=924930 $Y=896970
X2398 2272 2404 2417 1 2 2393 MUX2X1 $T=939920 811120 0 180 $X=933890 $Y=806565
X2399 2419 2361 2348 1 2 2468 MUX2X1 $T=938800 756240 1 0 $X=938370 $Y=751685
X2400 2463 100 378 1 2 2489 MUX2X1 $T=942160 920880 1 0 $X=941730 $Y=916325
X2401 2525 100 2497 1 2 2510 MUX2X1 $T=957840 873840 1 180 $X=951810 $Y=873450
X2402 2526 100 396 1 2 2511 MUX2X1 $T=957840 889520 0 180 $X=951810 $Y=884965
X2403 2527 100 367 1 2 2512 MUX2X1 $T=957840 913040 0 180 $X=951810 $Y=908485
X2404 2528 100 1753 1 2 2513 MUX2X1 $T=957840 920880 1 180 $X=951810 $Y=920490
X2405 2546 100 374 1 2 2537 MUX2X1 $T=975200 936560 0 180 $X=969170 $Y=932005
X2406 2548 100 1940 1 2 2538 MUX2X1 $T=976320 858160 1 180 $X=970290 $Y=857770
X2407 2550 100 1964 1 2 2540 MUX2X1 $T=976880 818960 0 180 $X=970850 $Y=814405
X2408 2552 100 2042 1 2 2541 MUX2X1 $T=978000 795440 1 180 $X=971970 $Y=795050
X2409 2553 100 1956 1 2 2542 MUX2X1 $T=978000 803280 0 180 $X=971970 $Y=798725
X2410 405 100 349 1 2 404 MUX2X1 $T=978560 724880 1 180 $X=972530 $Y=724490
X2411 2554 100 1761 1 2 2543 MUX2X1 $T=978560 787600 1 180 $X=972530 $Y=787210
X2412 406 100 2494 1 2 2544 MUX2X1 $T=978560 944400 1 180 $X=972530 $Y=944010
X2413 2555 100 2006 1 2 2545 MUX2X1 $T=979120 771920 0 180 $X=973090 $Y=767365
X2414 2563 100 2095 1 2 2547 MUX2X1 $T=980240 748400 0 180 $X=974210 $Y=743845
X2415 2564 100 2077 1 2 2549 MUX2X1 $T=980800 732720 1 180 $X=974770 $Y=732330
X2416 2565 100 316 1 2 2551 MUX2X1 $T=981360 834640 1 180 $X=975330 $Y=834250
X2417 2588 279 2584 1 2 2578 MUX2X1 $T=1000960 811120 1 180 $X=994930 $Y=810730
X2418 2608 279 2580 1 2 2589 MUX2X1 $T=1007680 873840 1 180 $X=1001650 $Y=873450
X2419 415 279 2598 1 2 2590 MUX2X1 $T=1008240 740560 0 180 $X=1002210 $Y=736005
X2420 2603 279 2586 1 2 2591 MUX2X1 $T=1008240 764080 0 180 $X=1002210 $Y=759525
X2421 2609 279 2599 1 2 2592 MUX2X1 $T=1008240 811120 0 180 $X=1002210 $Y=806565
X2422 2606 279 2585 1 2 2593 MUX2X1 $T=1008240 834640 0 180 $X=1002210 $Y=830085
X2423 2607 279 2579 1 2 2594 MUX2X1 $T=1008240 850320 0 180 $X=1002210 $Y=845765
X2424 2604 279 2577 1 2 2595 MUX2X1 $T=1008240 858160 0 180 $X=1002210 $Y=853605
X2425 2566 279 2581 1 2 2596 MUX2X1 $T=1008240 881680 0 180 $X=1002210 $Y=877125
X2426 2567 279 2582 1 2 2614 MUX2X1 $T=1002640 905200 1 0 $X=1002210 $Y=900645
X2427 2605 279 2600 1 2 2597 MUX2X1 $T=1008800 811120 1 180 $X=1002770 $Y=810730
X2428 2601 279 2610 1 2 417 MUX2X1 $T=1004320 928720 0 0 $X=1003890 $Y=928330
X2429 413 279 2612 1 2 2615 MUX2X1 $T=1004320 944400 0 0 $X=1003890 $Y=944010
X2430 2602 279 2587 1 2 2613 MUX2X1 $T=1012160 771920 0 180 $X=1006130 $Y=767365
X2431 416 279 2611 1 2 2616 MUX2X1 $T=1006560 920880 0 0 $X=1006130 $Y=920490
X2432 494 481 466 1 2 473 NAND3X1 $T=597200 858160 1 180 $X=592850 $Y=857770
X2433 516 576 31 1 2 592 NAND3X1 $T=601680 905200 0 0 $X=601250 $Y=904810
X2434 596 588 466 1 2 571 NAND3X1 $T=606720 795440 0 180 $X=602370 $Y=790885
X2435 577 614 633 1 2 624 NAND3X1 $T=605600 811120 1 0 $X=605170 $Y=806565
X2436 631 613 466 1 2 617 NAND3X1 $T=610080 779760 0 180 $X=605730 $Y=775205
X2437 494 712 30 1 2 723 NAND3X1 $T=614560 850320 0 0 $X=614130 $Y=849930
X2438 736 725 699 1 2 731 NAND3X1 $T=620160 818960 1 180 $X=615810 $Y=818570
X2439 751 735 545 1 2 717 NAND3X1 $T=620720 928720 0 180 $X=616370 $Y=924165
X2440 734 745 753 1 2 755 NAND3X1 $T=617360 897360 1 0 $X=616930 $Y=892805
X2441 761 727 37 1 2 736 NAND3X1 $T=621840 826800 0 180 $X=617490 $Y=822245
X2442 758 757 739 1 2 759 NAND3X1 $T=622960 771920 1 180 $X=618610 $Y=771530
X2443 772 737 747 1 2 722 NAND3X1 $T=623520 842480 1 180 $X=619170 $Y=842090
X2444 773 752 748 1 2 647 NAND3X1 $T=623520 866000 1 180 $X=619170 $Y=865610
X2445 775 713 53 1 2 562 NAND3X1 $T=623520 936560 1 180 $X=619170 $Y=936170
X2446 781 48 719 1 2 594 NAND3X1 $T=624080 834640 1 180 $X=619730 $Y=834250
X2447 726 777 48 1 2 772 NAND3X1 $T=620720 834640 1 0 $X=620290 $Y=830085
X2448 74 38 663 1 2 742 NAND3X1 $T=625200 920880 0 180 $X=620850 $Y=916325
X2449 852 841 805 1 2 702 NAND3X1 $T=631360 905200 1 180 $X=627010 $Y=904810
X2450 853 826 806 1 2 609 NAND3X1 $T=631360 928720 1 180 $X=627010 $Y=928330
X2451 855 639 828 1 2 835 NAND3X1 $T=631920 756240 0 180 $X=627570 $Y=751685
X2452 88 37 663 1 2 810 NAND3X1 $T=631920 795440 1 180 $X=627570 $Y=795050
X2453 825 851 882 1 2 465 NAND3X1 $T=630240 850320 1 0 $X=629810 $Y=845765
X2454 834 877 663 1 2 884 NAND3X1 $T=630800 928720 1 0 $X=630370 $Y=924165
X2455 88 876 70 1 2 881 NAND3X1 $T=636400 826800 1 180 $X=632050 $Y=826410
X2456 923 906 960 1 2 482 NAND3X1 $T=636960 842480 1 0 $X=636530 $Y=837925
X2457 944 919 979 1 2 973 NAND3X1 $T=638640 920880 0 0 $X=638210 $Y=920490
X2458 962 975 1000 1 2 989 NAND3X1 $T=639760 928720 1 0 $X=639330 $Y=924165
X2459 948 983 48 1 2 852 NAND3X1 $T=640320 905200 0 0 $X=639890 $Y=904810
X2460 1009 992 6 1 2 980 NAND3X1 $T=645360 944400 0 180 $X=641010 $Y=939845
X2461 1021 996 997 1 2 964 NAND3X1 $T=647040 897360 0 180 $X=642690 $Y=892805
X2462 965 1024 501 1 2 611 NAND3X1 $T=644240 920880 1 0 $X=643810 $Y=916325
X2463 1022 1069 1098 1 2 1093 NAND3X1 $T=649840 866000 0 0 $X=649410 $Y=865610
X2464 1074 1088 1100 1 2 1095 NAND3X1 $T=650400 764080 1 0 $X=649970 $Y=759525
X2465 584 1035 4 1 2 1087 NAND3X1 $T=654320 897360 1 180 $X=649970 $Y=896970
X2466 135 1090 1108 1 2 1079 NAND3X1 $T=650400 936560 1 0 $X=649970 $Y=932005
X2467 1065 136 37 1 2 1125 NAND3X1 $T=657120 913040 0 180 $X=652770 $Y=908485
X2468 1113 1149 525 1 2 1162 NAND3X1 $T=656560 834640 0 0 $X=656130 $Y=834250
X2469 1135 19 70 1 2 1171 NAND3X1 $T=662160 866000 0 180 $X=657810 $Y=861445
X2470 1165 1164 466 1 2 1160 NAND3X1 $T=662720 920880 0 180 $X=658370 $Y=916325
X2471 1218 1242 1049 1 2 1246 NAND3X1 $T=666640 803280 1 0 $X=666210 $Y=798725
X2472 1155 1247 1267 1 2 1260 NAND3X1 $T=667200 826800 1 0 $X=666770 $Y=822245
X2473 1291 1206 1018 1 2 1285 NAND3X1 $T=674480 866000 0 180 $X=670130 $Y=861445
X2474 1224 1307 1215 1 2 1316 NAND3X1 $T=672800 913040 0 0 $X=672370 $Y=912650
X2475 1297 1339 1351 1 2 1340 NAND3X1 $T=676160 771920 0 0 $X=675730 $Y=771530
X2476 1318 1366 1380 1 2 1374 NAND3X1 $T=678960 866000 1 0 $X=678530 $Y=861445
X2477 1094 1371 1378 1 2 1383 NAND3X1 $T=680080 795440 1 0 $X=679650 $Y=790885
X2478 1146 191 1389 1 2 1387 NAND3X1 $T=680080 928720 0 0 $X=679650 $Y=928330
X2479 1347 1338 1368 1 2 1394 NAND3X1 $T=680640 936560 1 0 $X=680210 $Y=932005
X2480 1416 1431 1436 1 2 1443 NAND3X1 $T=686240 881680 1 0 $X=685810 $Y=877125
X2481 844 1396 1440 1 2 1447 NAND3X1 $T=686800 740560 0 0 $X=686370 $Y=740170
X2482 1109 1479 1477 1 2 1470 NAND3X1 $T=691840 850320 1 0 $X=691410 $Y=845765
X2483 1355 137 1492 1 2 1503 NAND3X1 $T=696880 748400 0 0 $X=696450 $Y=748010
X2484 1474 1281 1496 1 2 1504 NAND3X1 $T=696880 764080 0 0 $X=696450 $Y=763690
X2485 1490 1509 1512 1 2 1467 NAND3X1 $T=698560 873840 0 0 $X=698130 $Y=873450
X2486 1062 1524 245 1 2 1529 NAND3X1 $T=703600 928720 1 0 $X=703170 $Y=924165
X2487 1393 1543 1539 1 2 63 NAND3X1 $T=714240 905200 1 180 $X=709890 $Y=904810
X2488 1578 1542 1564 1 2 1135 NAND3X1 $T=716480 866000 1 180 $X=712130 $Y=865610
X2489 1573 1426 1545 1 2 1584 NAND3X1 $T=713120 771920 0 0 $X=712690 $Y=771530
X2490 1556 1592 1577 1 2 1157 NAND3X1 $T=720400 905200 0 180 $X=716050 $Y=900645
X2491 1336 1589 1617 1 2 1628 NAND3X1 $T=721520 795440 0 0 $X=721090 $Y=795050
X2492 1343 1623 1606 1 2 1629 NAND3X1 $T=721520 834640 1 0 $X=721090 $Y=830085
X2493 1614 1622 1596 1 2 1634 NAND3X1 $T=722640 771920 1 0 $X=722210 $Y=767365
X2494 45 1593 1625 1 2 1639 NAND3X1 $T=723760 803280 0 0 $X=723330 $Y=802890
X2495 1714 1710 290 1 2 1707 NAND3X1 $T=804960 756240 0 180 $X=800610 $Y=751685
X2496 1732 1719 1726 1 2 1728 NAND3X1 $T=812240 732720 1 180 $X=807890 $Y=732330
X2497 1768 1709 308 1 2 1834 NAND3X1 $T=832400 740560 1 0 $X=831970 $Y=736005
X2498 1798 327 314 1 2 1822 NAND3X1 $T=836880 732720 1 180 $X=832530 $Y=732330
X2499 1842 1795 1817 1 2 1810 NAND3X1 $T=837440 889520 1 180 $X=833090 $Y=889130
X2500 1842 1783 1775 1 2 1862 NAND3X1 $T=836320 889520 1 0 $X=835890 $Y=884965
X2501 1862 1855 1844 1 2 1813 NAND3X1 $T=840800 873840 0 180 $X=836450 $Y=869285
X2502 1846 1814 1850 1 2 1855 NAND3X1 $T=841360 881680 0 180 $X=837010 $Y=877125
X2503 1876 1866 1885 1 2 1895 NAND3X1 $T=841920 897360 0 0 $X=841490 $Y=896970
X2504 1931 1937 1878 1 2 1943 NAND3X1 $T=852560 873840 1 0 $X=852130 $Y=869285
X2505 1908 1936 1950 1 2 1947 NAND3X1 $T=852560 928720 1 0 $X=852130 $Y=924165
X2506 1961 1889 1894 1 2 1952 NAND3X1 $T=859840 881680 1 180 $X=855490 $Y=881290
X2507 1962 1878 1921 1 2 1955 NAND3X1 $T=860960 873840 1 180 $X=856610 $Y=873450
X2508 1987 1984 1977 1 2 1976 NAND3X1 $T=867120 834640 0 180 $X=862770 $Y=830085
X2509 2054 2065 2062 1 2 2073 NAND3X1 $T=879440 873840 1 0 $X=879010 $Y=869285
X2510 2090 2078 2072 1 2 2027 NAND3X1 $T=886160 818960 0 180 $X=881810 $Y=814405
X2511 2096 2035 2043 1 2 2086 NAND3X1 $T=886720 866000 0 180 $X=882370 $Y=861445
X2512 2093 2013 2107 1 2 2109 NAND3X1 $T=884480 873840 0 0 $X=884050 $Y=873450
X2513 2091 2004 2070 1 2 2107 NAND3X1 $T=890640 866000 0 180 $X=886290 $Y=861445
X2514 2121 2113 2114 1 2 354 NAND3X1 $T=892320 811120 0 180 $X=887970 $Y=806565
X2515 2033 2029 2070 1 2 2114 NAND3X1 $T=894000 818960 1 180 $X=889650 $Y=818570
X2516 2150 2147 2016 1 2 2140 NAND3X1 $T=896800 748400 0 180 $X=892450 $Y=743845
X2517 1986 2128 2028 1 2 2158 NAND3X1 $T=899600 850320 0 180 $X=895250 $Y=845765
X2518 2180 2173 2149 1 2 2177 NAND3X1 $T=901840 826800 0 180 $X=897490 $Y=822245
X2519 2215 2141 2229 1 2 2225 NAND3X1 $T=905200 866000 0 0 $X=904770 $Y=865610
X2520 2198 2179 2238 1 2 2234 NAND3X1 $T=907440 858160 1 0 $X=907010 $Y=853605
X2521 2106 2219 2247 1 2 2249 NAND3X1 $T=914160 889520 0 180 $X=909810 $Y=884965
X2522 2243 2106 2206 1 2 2271 NAND3X1 $T=913600 920880 1 0 $X=913170 $Y=916325
X2523 2292 2265 370 1 2 2303 NAND3X1 $T=918640 740560 1 0 $X=918210 $Y=736005
X2524 2292 2302 2039 1 2 368 NAND3X1 $T=919200 740560 0 0 $X=918770 $Y=740170
X2525 2299 2295 2316 1 2 2313 NAND3X1 $T=920320 834640 0 0 $X=919890 $Y=834250
X2526 2315 2278 2208 1 2 2299 NAND3X1 $T=924800 834640 0 180 $X=920450 $Y=830085
X2527 2320 2311 2297 1 2 2312 NAND3X1 $T=925360 787600 1 180 $X=921010 $Y=787210
X2528 2341 2330 2307 1 2 2333 NAND3X1 $T=927600 928720 0 180 $X=923250 $Y=924165
X2529 2352 2339 2322 1 2 2340 NAND3X1 $T=928720 803280 0 180 $X=924370 $Y=798725
X2530 2302 2361 2039 1 2 2345 NAND3X1 $T=926480 756240 0 0 $X=926050 $Y=755850
X2531 2404 2371 2318 1 2 2385 NAND3X1 $T=934320 803280 1 180 $X=929970 $Y=802890
X2532 2414 2301 2370 1 2 2407 NAND3X1 $T=935440 920880 1 180 $X=931090 $Y=920490
X2533 2374 2291 2259 1 2 2386 NAND3X1 $T=932640 818960 0 0 $X=932210 $Y=818570
X2534 2420 2371 2258 1 2 2416 NAND3X1 $T=937120 803280 0 180 $X=932770 $Y=798725
X2535 2374 2353 2425 1 2 2346 NAND3X1 $T=933760 811120 0 0 $X=933330 $Y=810730
X2536 2439 2415 2423 1 2 2398 NAND3X1 $T=940480 787600 0 180 $X=936130 $Y=783045
X2537 2458 2448 1924 1 2 2443 NAND3X1 $T=943280 858160 1 180 $X=938930 $Y=857770
X2538 2459 388 2212 1 2 2444 NAND3X1 $T=943280 944400 1 180 $X=938930 $Y=944010
X2539 2374 2474 2425 1 2 2481 NAND3X1 $T=942720 811120 0 0 $X=942290 $Y=810730
X2540 2482 2424 2462 1 2 391 NAND3X1 $T=947200 732720 1 180 $X=942850 $Y=732330
X2541 2488 2465 2286 1 2 2475 NAND3X1 $T=948320 834640 0 180 $X=943970 $Y=830085
X2542 2457 2418 2419 1 2 2491 NAND3X1 $T=949440 748400 1 180 $X=945090 $Y=748010
X2543 2495 2449 2479 1 2 2484 NAND3X1 $T=949440 779760 0 180 $X=945090 $Y=775205
X2544 2420 2291 2209 1 2 2492 NAND3X1 $T=951120 826800 0 180 $X=946770 $Y=822245
X2545 2284 2440 2209 1 2 2279 NAND3X1 $T=953360 826800 1 180 $X=949010 $Y=826410
X2546 2515 2504 2480 1 2 2506 NAND3X1 $T=953920 795440 0 180 $X=949570 $Y=790885
X2547 2522 2452 2519 1 2 2486 NAND3X1 $T=958400 756240 0 180 $X=954050 $Y=751685
X2548 798 1 2 68 BUFX1 $T=625200 740560 0 180 $X=621970 $Y=736005
X2549 190 1 2 798 BUFX1 $T=680080 764080 0 180 $X=676850 $Y=759525
X2550 798 1 2 1391 BUFX1 $T=681200 756240 0 0 $X=680770 $Y=755850
X2551 798 1 2 197 BUFX1 $T=683440 740560 0 0 $X=683010 $Y=740170
X2552 190 1 2 196 BUFX1 $T=687920 764080 0 180 $X=684690 $Y=759525
X2553 190 1 2 262 BUFX1 $T=736080 779760 1 180 $X=732850 $Y=779370
X2554 266 1 2 1645 BUFX1 $T=749520 771920 0 0 $X=749090 $Y=771530
X2555 266 1 2 1648 BUFX1 $T=753440 771920 0 0 $X=753010 $Y=771530
X2556 1839 1 2 1835 BUFX1 $T=837440 748400 0 180 $X=834210 $Y=743845
X2557 1839 1 2 1853 BUFX1 $T=835760 787600 0 0 $X=835330 $Y=787210
X2558 190 1 2 1839 BUFX1 $T=839680 803280 0 180 $X=836450 $Y=798725
X2559 1839 1 2 1858 BUFX1 $T=836880 811120 0 0 $X=836450 $Y=810730
X2560 1839 1 2 329 BUFX1 $T=838000 724880 0 0 $X=837570 $Y=724490
X2561 363 1 2 2189 BUFX1 $T=905760 764080 0 180 $X=902530 $Y=759525
X2562 190 1 2 363 BUFX1 $T=915280 764080 0 180 $X=912050 $Y=759525
X2563 385 1 2 2434 BUFX1 $T=936560 944400 0 0 $X=936130 $Y=944010
X2564 394 1 2 2472 BUFX1 $T=946640 913040 0 180 $X=943410 $Y=908485
X2565 190 1 2 2498 BUFX1 $T=946640 826800 0 0 $X=946210 $Y=826410
X2566 2498 1 2 2535 BUFX1 $T=967920 803280 0 180 $X=964690 $Y=798725
X2567 2498 1 2 403 BUFX1 $T=969040 756240 0 180 $X=965810 $Y=751685
X2568 2498 1 2 2536 BUFX1 $T=967360 764080 0 0 $X=966930 $Y=763690
X2569 2498 1 2 2539 BUFX1 $T=969040 826800 0 0 $X=968610 $Y=826410
X2570 1 1062 ANTENNA $T=702480 928720 1 0 $X=702050 $Y=924165
X2571 1 115 ANTENNA $T=709760 944400 1 0 $X=709330 $Y=939845
X2572 1 115 ANTENNA $T=709760 944400 0 0 $X=709330 $Y=944010
X2573 1 161 ANTENNA $T=716480 834640 0 0 $X=716050 $Y=834250
X2574 1 161 ANTENNA $T=717600 834640 0 0 $X=717170 $Y=834250
X2575 1 161 ANTENNA $T=721520 834640 0 0 $X=721090 $Y=834250
X2576 1 45 ANTENNA $T=722640 803280 0 0 $X=722210 $Y=802890
X2577 1 592 ANTENNA $T=808880 905200 0 0 $X=808450 $Y=904810
X2578 1 634 ANTENNA $T=814480 873840 0 0 $X=814050 $Y=873450
X2579 1 513 ANTENNA $T=847520 826800 1 0 $X=847090 $Y=822245
X2580 443 445 1 2 435 AND2X1 $T=592160 803280 1 180 $X=588370 $Y=802890
X2581 443 449 1 2 456 AND2X1 $T=588800 873840 0 0 $X=588370 $Y=873450
X2582 453 4 1 2 434 AND2X1 $T=592160 897360 1 180 $X=588370 $Y=896970
X2583 473 498 1 2 508 AND2X1 $T=594960 850320 0 0 $X=594530 $Y=849930
X2584 495 566 1 2 577 AND2X1 $T=601120 803280 0 0 $X=600690 $Y=802890
X2585 557 538 1 2 578 AND2X1 $T=601120 826800 0 0 $X=600690 $Y=826410
X2586 26 538 1 2 533 AND2X1 $T=604480 889520 0 180 $X=600690 $Y=884965
X2587 7 623 1 2 638 AND2X1 $T=606720 803280 1 0 $X=606290 $Y=798725
X2588 620 446 1 2 645 AND2X1 $T=607280 897360 0 0 $X=606850 $Y=896970
X2589 617 640 1 2 649 AND2X1 $T=607840 771920 0 0 $X=607410 $Y=771530
X2590 46 37 1 2 692 AND2X1 $T=611760 920880 1 0 $X=611330 $Y=916325
X2591 675 635 1 2 693 AND2X1 $T=611760 936560 1 0 $X=611330 $Y=932005
X2592 704 43 1 2 591 AND2X1 $T=616240 881680 1 180 $X=612450 $Y=881290
X2593 51 37 1 2 654 AND2X1 $T=616800 928720 0 180 $X=613010 $Y=924165
X2594 756 742 1 2 734 AND2X1 $T=621280 897360 1 180 $X=617490 $Y=896970
X2595 766 525 1 2 728 AND2X1 $T=622400 740560 0 180 $X=618610 $Y=736005
X2596 621 771 1 2 778 AND2X1 $T=620160 889520 1 0 $X=619730 $Y=884965
X2597 804 719 1 2 476 AND2X1 $T=625760 803280 0 180 $X=621970 $Y=798725
X2598 791 749 1 2 807 AND2X1 $T=622960 881680 1 0 $X=622530 $Y=877125
X2599 517 802 1 2 784 AND2X1 $T=626880 913040 0 180 $X=623090 $Y=908485
X2600 832 501 1 2 687 AND2X1 $T=629120 740560 0 180 $X=625330 $Y=736005
X2601 816 719 1 2 833 AND2X1 $T=625760 920880 1 0 $X=625330 $Y=916325
X2602 842 823 1 2 818 AND2X1 $T=629680 764080 0 180 $X=625890 $Y=759525
X2603 621 858 1 2 868 AND2X1 $T=629120 889520 0 0 $X=628690 $Y=889130
X2604 99 37 1 2 593 AND2X1 $T=636400 944400 0 180 $X=632610 $Y=939845
X2605 920 904 1 2 829 AND2X1 $T=638080 756240 0 180 $X=634290 $Y=751685
X2606 892 905 1 2 757 AND2X1 $T=638080 779760 0 180 $X=634290 $Y=775205
X2607 880 915 1 2 928 AND2X1 $T=635280 795440 0 0 $X=634850 $Y=795050
X2608 910 916 1 2 923 AND2X1 $T=635280 834640 0 0 $X=634850 $Y=834250
X2609 918 931 1 2 944 AND2X1 $T=636400 928720 0 0 $X=635970 $Y=928330
X2610 964 501 1 2 871 AND2X1 $T=641440 897360 0 180 $X=637650 $Y=892805
X2611 981 987 1 2 986 AND2X1 $T=641440 803280 1 0 $X=641010 $Y=798725
X2612 1028 995 1 2 940 AND2X1 $T=648160 850320 1 180 $X=644370 $Y=849930
X2613 38 43 1 2 123 AND2X1 $T=645920 881680 0 0 $X=645490 $Y=881290
X2614 950 1044 1 2 1062 AND2X1 $T=647040 928720 1 0 $X=646610 $Y=924165
X2615 43 70 1 2 1065 AND2X1 $T=647600 881680 1 0 $X=647170 $Y=877125
X2616 123 1037 1 2 1067 AND2X1 $T=648160 795440 0 0 $X=647730 $Y=795050
X2617 135 133 1 2 1038 AND2X1 $T=652640 928720 1 180 $X=648850 $Y=928330
X2618 1004 1085 1 2 1094 AND2X1 $T=650400 795440 1 0 $X=649970 $Y=790885
X2619 1116 67 1 2 1089 AND2X1 $T=655440 842480 0 180 $X=651650 $Y=837925
X2620 1103 19 1 2 1096 AND2X1 $T=653200 803280 0 0 $X=652770 $Y=802890
X2621 1086 893 1 2 1138 AND2X1 $T=654320 881680 0 0 $X=653890 $Y=881290
X2622 1125 1136 1 2 1148 AND2X1 $T=654880 905200 1 0 $X=654450 $Y=900645
X2623 152 667 1 2 1167 AND2X1 $T=657120 764080 0 0 $X=656690 $Y=763690
X2624 12 43 1 2 155 AND2X1 $T=657680 873840 0 0 $X=657250 $Y=873450
X2625 1110 1163 1 2 1174 AND2X1 $T=657680 881680 1 0 $X=657250 $Y=877125
X2626 1175 1169 1 2 1112 AND2X1 $T=662160 748400 0 180 $X=658370 $Y=743845
X2627 1052 1213 1 2 1218 AND2X1 $T=663280 803280 1 0 $X=662850 $Y=798725
X2628 899 1220 1 2 1227 AND2X1 $T=664400 740560 0 0 $X=663970 $Y=740170
X2629 42 1151 1 2 1207 AND2X1 $T=667760 905200 1 180 $X=663970 $Y=904810
X2630 1225 50 1 2 1243 AND2X1 $T=666080 756240 1 0 $X=665650 $Y=751685
X2631 1235 1105 1 2 1257 AND2X1 $T=667200 866000 1 0 $X=666770 $Y=861445
X2632 1065 1025 1 2 1250 AND2X1 $T=672240 779760 1 180 $X=668450 $Y=779370
X2633 1265 50 1 2 1273 AND2X1 $T=673920 756240 0 180 $X=670130 $Y=751685
X2634 1245 48 1 2 1274 AND2X1 $T=673920 787600 0 180 $X=670130 $Y=783045
X2635 1238 1277 1 2 1272 AND2X1 $T=673920 795440 1 180 $X=670130 $Y=795050
X2636 1304 1311 1 2 458 AND2X1 $T=674480 811120 0 0 $X=674050 $Y=810730
X2637 1039 1269 1 2 1322 AND2X1 $T=674480 936560 0 0 $X=674050 $Y=936170
X2638 42 1076 1 2 1344 AND2X1 $T=676160 834640 0 0 $X=675730 $Y=834250
X2639 968 23 1 2 1284 AND2X1 $T=676160 858160 0 0 $X=675730 $Y=857770
X2640 1329 155 1 2 1349 AND2X1 $T=676720 803280 1 0 $X=676290 $Y=798725
X2641 42 1234 1 2 1361 AND2X1 $T=677840 748400 1 0 $X=677410 $Y=743845
X2642 926 1372 1 2 1367 AND2X1 $T=684000 771920 1 180 $X=680210 $Y=771530
X2643 926 1375 1 2 1333 AND2X1 $T=684000 873840 0 180 $X=680210 $Y=869285
X2644 1030 50 1 2 1418 AND2X1 $T=684560 756240 1 0 $X=684130 $Y=751685
X2645 1408 1403 1 2 542 AND2X1 $T=684560 913040 1 0 $X=684130 $Y=908485
X2646 1208 3 1 2 1433 AND2X1 $T=689040 748400 0 0 $X=688610 $Y=748010
X2647 1460 37 1 2 1140 AND2X1 $T=692400 764080 1 180 $X=688610 $Y=763690
X2648 1467 50 1 2 1435 AND2X1 $T=693520 873840 1 180 $X=689730 $Y=873450
X2649 30 1335 1 2 1487 AND2X1 $T=692400 897360 1 0 $X=691970 $Y=892805
X2650 1461 1488 1 2 1479 AND2X1 $T=698000 850320 1 180 $X=694210 $Y=849930
X2651 1357 1311 1 2 1177 AND2X1 $T=695200 826800 0 0 $X=694770 $Y=826410
X2652 1467 3 1 2 1423 AND2X1 $T=700240 873840 0 180 $X=696450 $Y=869285
X2653 1531 1535 1 2 1572 AND2X1 $T=710880 881680 1 0 $X=710450 $Y=877125
X2654 42 133 1 2 1579 AND2X1 $T=712000 756240 0 0 $X=711570 $Y=755850
X2655 1588 1559 1 2 1578 AND2X1 $T=717600 881680 1 180 $X=713810 $Y=881290
X2656 1528 1557 1 2 1598 AND2X1 $T=715920 764080 1 0 $X=715490 $Y=759525
X2657 1603 1619 1 2 1622 AND2X1 $T=720400 771920 0 0 $X=719970 $Y=771530
X2658 1630 1607 1 2 1636 AND2X1 $T=723760 818960 1 0 $X=723330 $Y=814405
X2659 307 1731 1 2 308 AND2X1 $T=811120 748400 1 0 $X=810690 $Y=743845
X2660 1767 317 1 2 1736 AND2X1 $T=824000 732720 0 180 $X=820210 $Y=728165
X2661 1781 1749 1 2 317 AND2X1 $T=825680 724880 1 180 $X=821890 $Y=724490
X2662 1768 1731 1 2 1782 AND2X1 $T=822320 740560 1 0 $X=821890 $Y=736005
X2663 1789 1786 1 2 1797 AND2X1 $T=825680 866000 0 0 $X=825250 $Y=865610
X2664 1845 1795 1 2 1965 AND2X1 $T=857600 889520 1 0 $X=857170 $Y=884965
X2665 1920 1892 1 2 1939 AND2X1 $T=861520 928720 1 180 $X=857730 $Y=928330
X2666 1991 1975 1 2 1980 AND2X1 $T=867120 858160 0 180 $X=863330 $Y=853605
X2667 2002 1997 1 2 2013 AND2X1 $T=868800 866000 0 0 $X=868370 $Y=865610
X2668 2024 2029 1 2 1991 AND2X1 $T=876640 842480 1 180 $X=872850 $Y=842090
X2669 2033 2030 1 2 1985 AND2X1 $T=878320 826800 1 180 $X=874530 $Y=826410
X2670 2035 1971 1 2 2024 AND2X1 $T=878320 842480 0 180 $X=874530 $Y=837925
X2671 2071 2058 1 2 2049 AND2X1 $T=882800 913040 0 180 $X=879010 $Y=908485
X2672 2105 2099 1 2 2087 AND2X1 $T=890080 889520 1 180 $X=886290 $Y=889130
X2673 2106 1722 1 2 2124 AND2X1 $T=894000 913040 0 180 $X=890210 $Y=908485
X2674 2112 2058 1 2 2131 AND2X1 $T=894560 913040 1 180 $X=890770 $Y=912650
X2675 2146 1903 1 2 2174 AND2X1 $T=896800 842480 1 0 $X=896370 $Y=837925
X2676 2106 2136 1 2 2157 AND2X1 $T=896800 913040 1 0 $X=896370 $Y=908485
X2677 2009 2092 1 2 2169 AND2X1 $T=898480 834640 0 0 $X=898050 $Y=834250
X2678 2206 1722 1 2 2058 AND2X1 $T=905760 920880 0 180 $X=901970 $Y=916325
X2679 2033 2012 1 2 2235 AND2X1 $T=906880 842480 1 0 $X=906450 $Y=837925
X2680 2112 2175 1 2 2244 AND2X1 $T=907440 905200 1 0 $X=907010 $Y=900645
X2681 2241 2249 1 2 2194 AND2X1 $T=909120 881680 1 0 $X=908690 $Y=877125
X2682 2152 2142 1 2 2080 AND2X1 $T=921440 889520 0 0 $X=921010 $Y=889130
X2683 2274 2205 1 2 2336 AND2X1 $T=923120 897360 1 0 $X=922690 $Y=892805
X2684 2350 2136 1 2 2329 AND2X1 $T=928160 905200 0 180 $X=924370 $Y=900645
X2685 2262 2334 1 2 2330 AND2X1 $T=928160 920880 1 180 $X=924370 $Y=920490
X2686 2243 1763 1 2 2355 AND2X1 $T=926480 889520 1 0 $X=926050 $Y=884965
X2687 2258 2209 1 2 2374 AND2X1 $T=927040 811120 0 0 $X=926610 $Y=810730
X2688 2374 2371 1 2 2354 AND2X1 $T=932640 818960 1 180 $X=928850 $Y=818570
X2689 2374 2272 1 2 2324 AND2X1 $T=934880 818960 0 180 $X=931090 $Y=814405
X2690 2452 2445 1 2 2382 AND2X1 $T=942720 764080 0 180 $X=938930 $Y=759525
X2691 2492 2455 1 2 2501 AND2X1 $T=947200 818960 0 0 $X=946770 $Y=818570
X2692 2487 2410 1 2 2515 AND2X1 $T=950560 795440 0 0 $X=950130 $Y=795050
X2693 2394 2278 1 2 2521 AND2X1 $T=953360 826800 0 0 $X=952930 $Y=826410
X2694 2457 2468 1 2 2529 AND2X1 $T=956160 748400 0 0 $X=955730 $Y=748010
X2695 2533 2482 1 2 2532 AND2X1 $T=961760 740560 0 180 $X=957970 $Y=736005
X2696 408 407 1 2 2556 AND2X1 $T=980800 936560 0 180 $X=977010 $Y=932005
X2697 408 405 1 2 2557 AND2X1 $T=981360 756240 0 180 $X=977570 $Y=751685
X2698 408 2550 1 2 2558 AND2X1 $T=981360 818960 1 180 $X=977570 $Y=818570
X2699 408 2565 1 2 2559 AND2X1 $T=981360 826800 1 180 $X=977570 $Y=826410
X2700 408 2548 1 2 2560 AND2X1 $T=981360 858160 1 180 $X=977570 $Y=857770
X2701 408 2526 1 2 2561 AND2X1 $T=981360 889520 1 180 $X=977570 $Y=889130
X2702 408 2527 1 2 2562 AND2X1 $T=981360 920880 1 180 $X=977570 $Y=920490
X2703 408 2525 1 2 2568 AND2X1 $T=984720 873840 1 180 $X=980930 $Y=873450
X2704 408 2564 1 2 2571 AND2X1 $T=983600 732720 1 0 $X=983170 $Y=728165
X2705 408 2563 1 2 2570 AND2X1 $T=983600 740560 0 0 $X=983170 $Y=740170
X2706 408 2528 1 2 2573 AND2X1 $T=985280 928720 0 0 $X=984850 $Y=928330
X2707 408 2555 1 2 2569 AND2X1 $T=989200 764080 0 180 $X=985410 $Y=759525
X2708 408 2553 1 2 2572 AND2X1 $T=990880 803280 0 180 $X=987090 $Y=798725
X2709 408 2463 1 2 2574 AND2X1 $T=987520 913040 0 0 $X=987090 $Y=912650
X2710 408 2554 1 2 2575 AND2X1 $T=995360 787600 0 180 $X=991570 $Y=783045
X2711 408 2546 1 2 2576 AND2X1 $T=992000 928720 1 0 $X=991570 $Y=924165
X2712 408 2552 1 2 2583 AND2X1 $T=993680 803280 1 0 $X=993250 $Y=798725
X2802 1 2 430 433 431 ICV_108 $T=586560 826800 0 0 $X=586130 $Y=826410
X2803 1 2 468 478 475 ICV_108 $T=592720 881680 0 0 $X=592290 $Y=881290
X2804 1 2 475 533 524 ICV_108 $T=597760 881680 0 0 $X=597330 $Y=881290
X2805 1 2 601 609 585 ICV_108 $T=605600 928720 0 0 $X=605170 $Y=928330
X2806 1 2 460 669 664 ICV_108 $T=610080 889520 0 0 $X=609650 $Y=889130
X2807 1 2 38 673 670 ICV_108 $T=610640 928720 0 0 $X=610210 $Y=928330
X2808 1 2 545 70 587 ICV_108 $T=622960 866000 1 0 $X=622530 $Y=861445
X2809 1 2 700 812 794 ICV_108 $T=624080 842480 0 0 $X=623650 $Y=842090
X2810 1 2 663 70 719 ICV_108 $T=624080 873840 1 0 $X=623650 $Y=869285
X2811 1 2 70 37 28 ICV_108 $T=624640 866000 0 0 $X=624210 $Y=865610
X2812 1 2 118 1017 878 ICV_108 $T=643680 732720 0 0 $X=643250 $Y=732330
X2813 1 2 1334 1376 1310 ICV_108 $T=681200 881680 1 0 $X=680770 $Y=877125
X2814 1 2 201 37 241 ICV_108 $T=707520 873840 1 0 $X=707090 $Y=869285
X2815 1 2 1762 1742 1775 ICV_108 $T=822320 889520 1 0 $X=821890 $Y=884965
X2816 1 2 1684 1744 1778 ICV_108 $T=822880 913040 0 0 $X=822450 $Y=912650
X2817 1 2 1776 1784 1780 ICV_108 $T=823440 905200 0 0 $X=823010 $Y=904810
X2818 1 2 293 1782 1798 ICV_108 $T=827360 740560 1 0 $X=826930 $Y=736005
X2819 1 2 1803 1820 1789 ICV_108 $T=831280 866000 0 0 $X=830850 $Y=865610
X2820 1 2 1733 1760 1854 ICV_108 $T=848080 881680 1 0 $X=847650 $Y=877125
X2821 1 2 1890 325 1979 ICV_108 $T=862640 779760 0 0 $X=862210 $Y=779370
X2822 1 2 1985 1989 1969 ICV_108 $T=864320 826800 0 0 $X=863890 $Y=826410
X2823 1 2 1980 1978 1987 ICV_108 $T=864320 834640 0 0 $X=863890 $Y=834250
X2824 1 2 1986 1990 1983 ICV_108 $T=864320 850320 1 0 $X=863890 $Y=845765
X2825 1 2 1804 2004 2005 ICV_108 $T=868240 842480 0 0 $X=867810 $Y=842090
X2826 1 2 2021 2027 1963 ICV_108 $T=872160 818960 1 0 $X=871730 $Y=814405
X2827 1 2 1967 2014 2021 ICV_108 $T=877200 818960 1 0 $X=876770 $Y=814405
X2828 1 2 2030 2043 2053 ICV_108 $T=878880 842480 0 0 $X=878450 $Y=842090
X2829 1 2 2092 2103 1993 ICV_108 $T=897360 842480 0 0 $X=896930 $Y=842090
X2830 1 2 2133 2175 2178 ICV_108 $T=900160 905200 1 0 $X=899730 $Y=900645
X2831 1 2 1903 2012 2009 ICV_108 $T=901840 842480 1 0 $X=901410 $Y=837925
X2832 1 2 1986 2171 2191 ICV_108 $T=902400 834640 1 0 $X=901970 $Y=830085
X2833 1 2 2053 2103 2197 ICV_108 $T=902400 842480 0 0 $X=901970 $Y=842090
X2834 1 2 2057 2192 2198 ICV_108 $T=902400 858160 1 0 $X=901970 $Y=853605
X2835 1 2 2166 2211 2203 ICV_108 $T=903520 905200 0 0 $X=903090 $Y=904810
X2836 1 2 2208 2200 2272 ICV_108 $T=918640 795440 0 0 $X=918210 $Y=795050
X2837 1 2 432 433 437 ICV_59 $T=586560 842480 0 0 $X=586130 $Y=842090
X2838 1 2 9 445 466 ICV_59 $T=591040 811120 1 0 $X=590610 $Y=806565
X2839 1 2 443 463 469 ICV_59 $T=591040 811120 0 0 $X=590610 $Y=810730
X2840 1 2 497 514 18 ICV_59 $T=596080 834640 1 0 $X=595650 $Y=830085
X2841 1 2 443 615 628 ICV_59 $T=606160 764080 1 0 $X=605730 $Y=759525
X2842 1 2 7 598 661 ICV_59 $T=608960 811120 0 0 $X=608530 $Y=810730
X2843 1 2 797 78 814 ICV_59 $T=623520 724880 0 0 $X=623090 $Y=724490
X2844 1 2 779 846 501 ICV_59 $T=628000 748400 0 0 $X=627570 $Y=748010
X2845 1 2 43 870 53 ICV_59 $T=630240 881680 1 0 $X=629810 $Y=877125
X2846 1 2 95 857 48 ICV_59 $T=633040 936560 1 0 $X=632610 $Y=932005
X2847 1 2 924 641 943 ICV_59 $T=636400 873840 0 0 $X=635970 $Y=873450
X2848 1 2 977 906 28 ICV_59 $T=640880 842480 1 0 $X=640450 $Y=837925
X2849 1 2 888 955 12 ICV_59 $T=640880 850320 0 0 $X=640450 $Y=849930
X2850 1 2 864 998 28 ICV_59 $T=640880 897360 0 0 $X=640450 $Y=896970
X2851 1 2 497 714 1117 ICV_59 $T=652080 920880 0 0 $X=651650 $Y=920490
X2852 1 2 123 1191 869 ICV_59 $T=659920 803280 0 0 $X=659490 $Y=802890
X2853 1 2 1186 1192 50 ICV_59 $T=662720 756240 1 0 $X=662290 $Y=751685
X2854 1 2 911 1281 23 ICV_59 $T=670560 764080 0 0 $X=670130 $Y=763690
X2855 1 2 155 853 179 ICV_59 $T=670560 928720 1 0 $X=670130 $Y=924165
X2856 1 2 1268 1185 1217 ICV_59 $T=670560 928720 0 0 $X=670130 $Y=928330
X2857 1 2 1286 1202 1360 ICV_59 $T=677840 928720 1 0 $X=677410 $Y=924165
X2858 1 2 1309 1396 3 ICV_59 $T=682320 748400 1 0 $X=681890 $Y=743845
X2859 1 2 1377 1358 1402 ICV_59 $T=682320 889520 0 0 $X=681890 $Y=889130
X2860 1 2 1360 864 1403 ICV_59 $T=682320 913040 0 0 $X=681890 $Y=912650
X2861 1 2 201 1399 1483 ICV_59 $T=691840 944400 1 0 $X=691410 $Y=939845
X2862 1 2 182 1356 229 ICV_59 $T=697440 905200 0 0 $X=697010 $Y=904810
X2863 1 2 182 1360 230 ICV_59 $T=697440 936560 1 0 $X=697010 $Y=932005
X2864 1 2 182 1314 1508 ICV_59 $T=697440 936560 0 0 $X=697010 $Y=936170
X2865 1 2 182 1444 228 ICV_59 $T=698560 771920 0 0 $X=698130 $Y=771530
X2866 1 2 201 1386 239 ICV_59 $T=700800 905200 0 0 $X=700370 $Y=904810
X2867 1 2 201 167 230 ICV_59 $T=701920 944400 1 0 $X=701490 $Y=939845
X2868 1 2 201 1384 243 ICV_59 $T=702480 858160 1 0 $X=702050 $Y=853605
X2869 1 2 201 153 1525 ICV_59 $T=703040 826800 0 0 $X=702610 $Y=826410
X2870 1 2 201 1363 1526 ICV_59 $T=703040 834640 0 0 $X=702610 $Y=834250
X2871 1 2 154 1528 142 ICV_59 $T=704720 764080 1 0 $X=704290 $Y=759525
X2872 1 2 1502 1531 222 ICV_59 $T=705280 881680 1 0 $X=704850 $Y=877125
X2873 1 2 182 1369 251 ICV_59 $T=707520 787600 0 0 $X=707090 $Y=787210
X2874 1 2 201 1449 251 ICV_59 $T=710880 787600 0 0 $X=710450 $Y=787210
X2875 1 2 1560 253 1571 ICV_59 $T=710880 944400 0 0 $X=710450 $Y=944010
X2876 1 2 1698 1702 289 ICV_59 $T=797120 732720 1 0 $X=796690 $Y=728165
X2877 1 2 1709 1706 293 ICV_59 $T=801040 740560 1 0 $X=800610 $Y=736005
X2878 1 2 1838 1861 1857 ICV_59 $T=836880 811120 1 0 $X=836450 $Y=806565
X2879 1 2 2050 2063 2053 ICV_59 $T=878880 881680 1 0 $X=878450 $Y=877125
X2880 1 2 88 2075 2095 ICV_59 $T=882800 740560 1 0 $X=882370 $Y=736005
X2881 1 2 2043 2004 1903 ICV_59 $T=882800 826800 0 0 $X=882370 $Y=826410
X2882 1 2 2038 2092 1994 ICV_59 $T=883360 850320 0 0 $X=882930 $Y=849930
X2883 1 2 2149 2129 2153 ICV_59 $T=893440 811120 0 0 $X=893010 $Y=810730
X2884 1 2 2158 2162 2092 ICV_59 $T=895680 850320 0 0 $X=895250 $Y=849930
X2885 1 2 2175 2172 1763 ICV_59 $T=900160 897360 1 0 $X=899730 $Y=892805
X2886 1 2 2105 2242 2254 ICV_59 $T=910800 913040 1 0 $X=910370 $Y=908485
X2887 1 2 2331 375 2302 ICV_59 $T=924240 724880 0 0 $X=923810 $Y=724490
X2888 1 2 2327 2337 2345 ICV_59 $T=924240 764080 1 0 $X=923810 $Y=759525
X2889 1 2 2313 2426 2259 ICV_59 $T=935440 850320 1 0 $X=935010 $Y=845765
X2890 1 2 2436 2449 2302 ICV_59 $T=938800 779760 1 0 $X=938370 $Y=775205
X2891 1 2 7 432 5 ICV_85 $T=586560 850320 1 0 $X=586130 $Y=845765
X2892 1 2 12 452 4 ICV_85 $T=592160 866000 0 0 $X=591730 $Y=865610
X2893 1 2 463 512 502 ICV_85 $T=594400 811120 0 0 $X=593970 $Y=810730
X2894 1 2 32 29 28 ICV_85 $T=600560 944400 0 0 $X=600130 $Y=944010
X2895 1 2 763 758 525 ICV_85 $T=616800 756240 0 0 $X=616370 $Y=755850
X2896 1 2 1127 1123 525 ICV_85 $T=650960 748400 0 0 $X=650530 $Y=748010
X2897 1 2 1131 1224 19 ICV_85 $T=662720 920880 1 0 $X=662290 $Y=916325
X2898 1 2 7 1580 839 ICV_85 $T=711440 803280 1 0 $X=711010 $Y=798725
X2899 1 2 1548 1582 1550 ICV_85 $T=711440 842480 0 0 $X=711010 $Y=842090
X2900 1 2 1591 1421 1577 ICV_85 $T=714240 905200 0 0 $X=713810 $Y=904810
X2901 1 2 49 1619 1032 ICV_85 $T=717600 779760 0 0 $X=717170 $Y=779370
X2902 1 2 237 259 1483 ICV_85 $T=719280 944400 1 0 $X=718850 $Y=939845
X2903 1 2 1599 1635 1612 ICV_85 $T=721520 873840 0 0 $X=721090 $Y=873450
X2904 1 2 294 1777 1731 ICV_85 $T=820080 764080 0 0 $X=819650 $Y=763690
X2905 1 2 1769 1794 1777 ICV_85 $T=824000 756240 0 0 $X=823570 $Y=755850
X2906 1 2 1901 1871 1733 ICV_85 $T=843040 920880 0 0 $X=842610 $Y=920490
X2907 1 2 1906 1932 1882 ICV_85 $T=849200 889520 1 0 $X=848770 $Y=884965
X2908 1 2 2023 2018 2015 ICV_85 $T=868240 826800 1 0 $X=867810 $Y=822245
X2909 1 2 2070 2100 1903 ICV_85 $T=882240 834640 0 0 $X=881810 $Y=834250
X2910 1 2 2182 2190 88 ICV_85 $T=899600 740560 1 0 $X=899170 $Y=736005
X2911 1 2 333 2212 2025 ICV_85 $T=901280 936560 0 0 $X=900850 $Y=936170
X2912 1 2 2214 2180 1903 ICV_85 $T=901840 826800 1 0 $X=901410 $Y=822245
X2913 1 2 2244 2231 2160 ICV_85 $T=905760 920880 1 0 $X=905330 $Y=916325
X2914 1 2 368 2343 2303 ICV_85 $T=922560 740560 1 0 $X=922130 $Y=736005
X2915 1 2 2409 2402 2395 ICV_85 $T=929280 771920 0 0 $X=928850 $Y=771530
X2916 1 2 2442 2413 2233 ICV_85 $T=935440 842480 1 0 $X=935010 $Y=837925
X2917 1 2 2437 2450 2362 ICV_85 $T=941600 787600 0 0 $X=941170 $Y=787210
X2918 1 2 2490 2493 2196 ICV_85 $T=943840 905200 1 0 $X=943410 $Y=900645
X2919 1 2 2431 2500 2464 ICV_85 $T=944960 818960 1 0 $X=944530 $Y=814405
X2920 1 2 2509 2461 88 ICV_85 $T=948880 866000 1 0 $X=948450 $Y=861445
X2921 1 2 447 440 454 ICV_55 $T=586560 913040 0 0 $X=586130 $Y=912650
X2922 1 2 487 495 501 ICV_55 $T=592160 803280 0 0 $X=591730 $Y=802890
X2923 1 2 565 530 501 ICV_55 $T=599440 787600 1 0 $X=599010 $Y=783045
X2924 1 2 715 720 501 ICV_55 $T=613440 748400 0 0 $X=613010 $Y=748010
X2925 1 2 7 1051 1060 ICV_55 $T=644800 889520 0 0 $X=644370 $Y=889130
X2926 1 2 937 1061 145 ICV_55 $T=650400 732720 0 0 $X=649970 $Y=732330
X2927 1 2 517 1184 159 ICV_55 $T=657120 913040 1 0 $X=656690 $Y=908485
X2928 1 2 155 1212 1116 ICV_55 $T=661040 811120 0 0 $X=660610 $Y=810730
X2929 1 2 1214 1222 1236 ICV_55 $T=663280 866000 0 0 $X=662850 $Y=865610
X2930 1 2 152 1380 1326 ICV_55 $T=682320 866000 0 0 $X=681890 $Y=865610
X2931 1 2 182 1046 1438 ICV_55 $T=684000 834640 1 0 $X=683570 $Y=830085
X2932 1 2 182 1407 1532 ICV_55 $T=702480 795440 1 0 $X=702050 $Y=790885
X2933 1 2 1270 127 172 ICV_55 $T=703040 928720 0 0 $X=702610 $Y=928330
X2934 1 2 201 1497 1532 ICV_55 $T=708080 795440 1 0 $X=707650 $Y=790885
X2935 1 2 1552 1583 3 ICV_55 $T=711440 850320 1 0 $X=711010 $Y=845765
X2936 1 2 241 1592 234 ICV_55 $T=713680 928720 1 0 $X=713250 $Y=924165
X2937 1 2 237 1613 236 ICV_55 $T=720400 897360 1 0 $X=719970 $Y=892805
X2938 1 2 1798 1791 1709 ICV_55 $T=829040 740560 0 0 $X=828610 $Y=740170
X2939 1 2 1767 326 1834 ICV_55 $T=830160 732720 1 0 $X=829730 $Y=728165
X2940 1 2 1946 1958 1892 ICV_55 $T=853680 905200 0 0 $X=853250 $Y=904810
X2941 1 2 1981 1959 88 ICV_55 $T=861520 764080 0 0 $X=861090 $Y=763690
X2942 1 2 1982 1974 88 ICV_55 $T=861520 811120 1 0 $X=861090 $Y=806565
X2943 1 2 333 2036 1898 ICV_55 $T=872160 764080 1 0 $X=871730 $Y=759525
X2944 1 2 88 2052 1761 ICV_55 $T=876080 795440 0 0 $X=875650 $Y=795050
X2945 1 2 2067 2068 88 ICV_55 $T=878320 748400 1 0 $X=877890 $Y=743845
X2946 1 2 325 2069 2006 ICV_55 $T=882800 771920 0 0 $X=882370 $Y=771530
X2947 1 2 325 2081 2095 ICV_55 $T=885040 756240 1 0 $X=884610 $Y=751685
X2948 1 2 2220 2215 2009 ICV_55 $T=902960 866000 1 0 $X=902530 $Y=861445
X2949 1 2 2233 2316 2272 ICV_55 $T=920320 818960 0 0 $X=919890 $Y=818570
X2950 1 2 2335 2338 2349 ICV_55 $T=922560 771920 1 0 $X=922130 $Y=767365
X2951 1 2 2302 2395 2349 ICV_55 $T=928160 771920 1 0 $X=927730 $Y=767365
X2952 1 2 2430 2436 2435 ICV_55 $T=934880 771920 0 0 $X=934450 $Y=771530
X2953 1 2 325 2459 2494 ICV_55 $T=943280 944400 0 0 $X=942850 $Y=944010
X2954 1 2 2312 2504 2365 ICV_55 $T=947200 787600 0 0 $X=946770 $Y=787210
X2955 1 2 2514 2517 2482 ICV_55 $T=950000 771920 1 0 $X=949570 $Y=767365
X2956 1 435 2 444 441 ICV_93 $T=588240 803280 1 0 $X=587810 $Y=798725
X2957 1 548 2 36 605 ICV_93 $T=605600 913040 0 0 $X=605170 $Y=912650
X2958 1 545 2 53 466 ICV_93 $T=615120 866000 0 0 $X=614690 $Y=865610
X2959 1 53 2 58 673 ICV_93 $T=615680 928720 0 0 $X=615250 $Y=928330
X2960 1 840 2 845 706 ICV_93 $T=628000 866000 1 0 $X=627570 $Y=861445
X2961 1 833 2 866 865 ICV_93 $T=630240 920880 1 0 $X=629810 $Y=916325
X2962 1 501 2 865 103 ICV_93 $T=634720 920880 1 0 $X=634290 $Y=916325
X2963 1 53 2 107 935 ICV_93 $T=636960 936560 0 0 $X=636530 $Y=936170
X2964 1 53 2 883 941 ICV_93 $T=637520 905200 1 0 $X=637090 $Y=900645
X2965 1 57 2 859 914 ICV_93 $T=639200 724880 0 0 $X=638770 $Y=724490
X2966 1 1059 2 1096 1092 ICV_93 $T=651520 779760 1 0 $X=651090 $Y=775205
X2967 1 52 2 149 1142 ICV_93 $T=656000 779760 0 0 $X=655570 $Y=779370
X2968 1 1181 2 1187 1188 ICV_93 $T=660480 787600 1 0 $X=660050 $Y=783045
X2969 1 525 2 1002 1276 ICV_93 $T=670000 881680 0 0 $X=669570 $Y=881290
X2970 1 1305 2 1316 1313 ICV_93 $T=673920 889520 1 0 $X=673490 $Y=884965
X2971 1 1273 2 1332 1336 ICV_93 $T=676720 787600 0 0 $X=676290 $Y=787210
X2972 1 936 2 1341 1334 ICV_93 $T=676720 881680 1 0 $X=676290 $Y=877125
X2973 1 1418 2 1475 1474 ICV_93 $T=692400 764080 0 0 $X=691970 $Y=763690
X2974 1 1421 2 101 1446 ICV_93 $T=692960 889520 0 0 $X=692530 $Y=889130
X2975 1 870 2 1446 238 ICV_93 $T=701920 889520 1 0 $X=701490 $Y=884965
X2976 1 300 2 1728 1725 ICV_93 $T=807200 732720 1 0 $X=806770 $Y=728165
X2977 1 1755 2 1817 1811 ICV_93 $T=830720 928720 1 0 $X=830290 $Y=924165
X2978 1 1778 2 1811 1812 ICV_93 $T=830720 928720 0 0 $X=830290 $Y=928330
X2979 1 1939 2 1947 1948 ICV_93 $T=853680 928720 0 0 $X=853250 $Y=928330
X2980 1 1971 2 1967 2033 ICV_93 $T=876640 818960 0 0 $X=876210 $Y=818570
X2981 1 1804 2 2038 2082 ICV_93 $T=882240 858160 1 0 $X=881810 $Y=853605
X2982 1 2110 2 2083 2096 ICV_93 $T=887280 858160 0 0 $X=886850 $Y=857770
X2983 1 2131 2 2139 2156 ICV_93 $T=895120 920880 0 0 $X=894690 $Y=920490
X2984 1 2142 2 1996 2112 ICV_93 $T=895680 905200 1 0 $X=895250 $Y=900645
X2985 1 2166 2 2172 2167 ICV_93 $T=899040 905200 0 0 $X=898610 $Y=904810
X2986 1 2208 2 2286 2277 ICV_93 $T=916960 818960 1 0 $X=916530 $Y=814405
X2987 1 2133 2 2247 2105 ICV_93 $T=918640 897360 1 0 $X=918210 $Y=892805
X2988 1 2294 2 2315 2317 ICV_93 $T=922560 826800 0 0 $X=922130 $Y=826410
X2989 1 2039 2 2419 2349 ICV_93 $T=934880 764080 1 0 $X=934450 $Y=759525
X2990 1 2425 2 2437 2280 ICV_93 $T=937120 803280 1 0 $X=936690 $Y=798725
X2991 1 2371 2 2353 2421 ICV_93 $T=938240 826800 0 0 $X=937810 $Y=826410
X2992 1 2208 2 2437 2453 ICV_93 $T=941600 803280 1 0 $X=941170 $Y=798725
X2993 1 2 436 437 3 ICV_58 $T=588240 842480 1 0 $X=587810 $Y=837925
X2994 1 2 13 449 466 ICV_58 $T=594960 913040 0 0 $X=594530 $Y=912650
X2995 1 2 509 510 526 ICV_58 $T=597200 764080 1 0 $X=596770 $Y=759525
X2996 1 2 497 471 20 ICV_58 $T=597200 826800 1 0 $X=596770 $Y=822245
X2997 1 2 530 511 543 ICV_58 $T=598880 787600 0 0 $X=598450 $Y=787210
X2998 1 2 21 519 23 ICV_58 $T=598880 944400 1 0 $X=598450 $Y=939845
X2999 1 2 597 539 607 ICV_58 $T=605040 842480 0 0 $X=604610 $Y=842090
X3000 1 2 503 494 37 ICV_58 $T=605600 858160 1 0 $X=605170 $Y=853605
X3001 1 2 602 478 37 ICV_58 $T=606720 889520 1 0 $X=606290 $Y=884965
X3002 1 2 627 636 643 ICV_58 $T=607840 881680 0 0 $X=607410 $Y=881290
X3003 1 2 42 543 660 ICV_58 $T=609520 795440 0 0 $X=609090 $Y=795050
X3004 1 2 42 448 691 ICV_58 $T=612320 834640 1 0 $X=611890 $Y=830085
X3005 1 2 695 616 538 ICV_58 $T=614000 771920 1 0 $X=613570 $Y=767365
X3006 1 2 695 703 587 ICV_58 $T=614000 771920 0 0 $X=613570 $Y=771530
X3007 1 2 9 662 719 ICV_58 $T=615120 834640 0 0 $X=614690 $Y=834250
X3008 1 2 746 637 719 ICV_58 $T=619040 771920 1 0 $X=618610 $Y=767365
X3009 1 2 815 704 847 ICV_58 $T=628000 881680 0 0 $X=627570 $Y=881290
X3010 1 2 839 851 67 ICV_58 $T=629120 842480 0 0 $X=628690 $Y=842090
X3011 1 2 743 93 501 ICV_58 $T=633040 913040 0 0 $X=632610 $Y=912650
X3012 1 2 738 915 622 ICV_58 $T=635840 803280 0 0 $X=635410 $Y=802890
X3013 1 2 930 950 501 ICV_58 $T=638080 913040 0 0 $X=637650 $Y=912650
X3014 1 2 111 965 28 ICV_58 $T=639200 920880 1 0 $X=638770 $Y=916325
X3015 1 2 119 1022 70 ICV_58 $T=644800 866000 0 0 $X=644370 $Y=865610
X3016 1 2 125 622 1045 ICV_58 $T=646480 779760 0 0 $X=646050 $Y=779370
X3017 1 2 112 1047 12 ICV_58 $T=647040 803280 1 0 $X=646610 $Y=798725
X3018 1 2 1075 966 12 ICV_58 $T=651520 826800 1 0 $X=651090 $Y=822245
X3019 1 2 71 1110 587 ICV_58 $T=652640 881680 1 0 $X=652210 $Y=877125
X3020 1 2 1058 1145 19 ICV_58 $T=656000 889520 1 0 $X=655570 $Y=884965
X3021 1 2 650 1155 525 ICV_58 $T=656560 826800 1 0 $X=656130 $Y=822245
X3022 1 2 907 1002 156 ICV_58 $T=658800 881680 0 0 $X=658370 $Y=881290
X3023 1 2 1168 1175 3 ICV_58 $T=659360 740560 0 0 $X=658930 $Y=740170
X3024 1 2 517 1206 1116 ICV_58 $T=662160 842480 1 0 $X=661730 $Y=837925
X3025 1 2 497 1163 1210 ICV_58 $T=662720 881680 1 0 $X=662290 $Y=877125
X3026 1 2 1208 1169 50 ICV_58 $T=663840 748400 1 0 $X=663410 $Y=743845
X3027 1 2 1172 166 525 ICV_58 $T=663840 920880 0 0 $X=663410 $Y=920490
X3028 1 2 1183 1263 525 ICV_58 $T=668880 889520 1 0 $X=668450 $Y=884965
X3029 1 2 123 1283 788 ICV_58 $T=671120 834640 0 0 $X=670690 $Y=834250
X3030 1 2 155 1294 861 ICV_58 $T=672240 842480 1 0 $X=671810 $Y=837925
X3031 1 2 1054 1066 182 ICV_58 $T=674480 748400 0 0 $X=674050 $Y=748010
X3032 1 2 42 1325 1154 ICV_58 $T=675040 795440 1 0 $X=674610 $Y=790885
X3033 1 2 1298 1015 1337 ICV_58 $T=676720 826800 0 0 $X=676290 $Y=826410
X3034 1 2 1259 1352 23 ICV_58 $T=677840 779760 1 0 $X=677410 $Y=775205
X3035 1 2 1286 822 1348 ICV_58 $T=678400 913040 1 0 $X=677970 $Y=908485
X3036 1 2 1283 1415 1419 ICV_58 $T=685680 834640 0 0 $X=685250 $Y=834250
X3037 1 2 1400 51 1430 ICV_58 $T=686240 928720 1 0 $X=685810 $Y=924165
X3038 1 2 1346 1211 1437 ICV_58 $T=686800 787600 0 0 $X=686370 $Y=787210
X3039 1 2 1319 732 1439 ICV_58 $T=686800 850320 1 0 $X=686370 $Y=845765
X3040 1 2 155 1436 205 ICV_58 $T=687360 897360 1 0 $X=686930 $Y=892805
X3041 1 2 1409 788 1437 ICV_58 $T=687920 803280 0 0 $X=687490 $Y=802890
X3042 1 2 163 1419 1329 ICV_58 $T=690720 834640 0 0 $X=690290 $Y=834250
X3043 1 2 201 1451 206 ICV_58 $T=690720 920880 1 0 $X=690290 $Y=916325
X3044 1 2 1229 667 1489 ICV_58 $T=694080 834640 1 0 $X=693650 $Y=830085
X3045 1 2 201 1306 225 ICV_58 $T=695760 920880 1 0 $X=695330 $Y=916325
X3046 1 2 201 1364 228 ICV_58 $T=698000 811120 1 0 $X=697570 $Y=806565
X3047 1 2 1364 1020 1437 ICV_58 $T=698560 803280 0 0 $X=698130 $Y=802890
X3048 1 2 1505 18 1489 ICV_58 $T=699120 834640 1 0 $X=698690 $Y=830085
X3049 1 2 909 1517 37 ICV_58 $T=701920 889520 0 0 $X=701490 $Y=889130
X3050 1 2 237 1512 1445 ICV_58 $T=702480 873840 1 0 $X=702050 $Y=869285
X3051 1 2 1484 1261 1428 ICV_58 $T=703040 811120 1 0 $X=702610 $Y=806565
X3052 1 2 182 1289 1525 ICV_58 $T=703600 842480 1 0 $X=703170 $Y=837925
X3053 1 2 1384 142 1439 ICV_58 $T=703600 842480 0 0 $X=703170 $Y=842090
X3054 1 2 201 1320 244 ICV_58 $T=703600 850320 1 0 $X=703170 $Y=845765
X3055 1 2 201 1493 246 ICV_58 $T=705280 779760 0 0 $X=704850 $Y=779370
X3056 1 2 182 1249 239 ICV_58 $T=705280 905200 0 0 $X=704850 $Y=904810
X3057 1 2 182 1485 246 ICV_58 $T=705840 795440 0 0 $X=705410 $Y=795050
X3058 1 2 1357 1282 1369 ICV_58 $T=706960 818960 1 0 $X=706530 $Y=814405
X3059 1 2 127 1544 48 ICV_58 $T=707520 936560 0 0 $X=707090 $Y=936170
X3060 1 2 1449 1460 1565 ICV_58 $T=710880 795440 0 0 $X=710450 $Y=795050
X3061 1 2 241 1563 1527 ICV_58 $T=712560 873840 1 0 $X=712130 $Y=869285
X3062 1 2 48 1566 217 ICV_58 $T=712560 936560 0 0 $X=712130 $Y=936170
X3063 1 2 1547 9 1565 ICV_58 $T=713120 826800 0 0 $X=712690 $Y=826410
X3064 1 2 182 165 1575 ICV_58 $T=713680 811120 1 0 $X=713250 $Y=806565
X3065 1 2 237 1555 1576 ICV_58 $T=713680 858160 1 0 $X=713250 $Y=853605
X3066 1 2 182 1330 1581 ICV_58 $T=714240 842480 1 0 $X=713810 $Y=837925
X3067 1 2 37 1587 229 ICV_58 $T=715360 889520 0 0 $X=714930 $Y=889130
X3068 1 2 1711 1701 295 ICV_58 $T=802160 732720 1 0 $X=801730 $Y=728165
X3069 1 2 1750 1796 1762 ICV_58 $T=830160 873840 0 0 $X=829730 $Y=873450
X3070 1 2 1806 1891 1896 ICV_58 $T=843040 803280 0 0 $X=842610 $Y=802890
X3071 1 2 1899 1910 1892 ICV_58 $T=847520 905200 1 0 $X=847090 $Y=900645
X3072 1 2 131 1914 1940 ICV_58 $T=852560 858160 0 0 $X=852130 $Y=857770
X3073 1 2 1932 1937 1760 ICV_58 $T=853120 881680 1 0 $X=852690 $Y=877125
X3074 1 2 1770 2099 1763 ICV_58 $T=884480 897360 1 0 $X=884050 $Y=892805
X3075 1 2 2124 2144 2133 ICV_58 $T=892320 889520 0 0 $X=891890 $Y=889130
X3076 1 2 2177 2183 2184 ICV_58 $T=900160 866000 0 0 $X=899730 $Y=865610
X3077 1 2 2130 2205 1770 ICV_58 $T=903520 897360 1 0 $X=903090 $Y=892805
X3078 1 2 1953 2239 2236 ICV_58 $T=908560 944400 1 0 $X=908130 $Y=939845
X3079 1 2 2224 2281 2289 ICV_58 $T=916960 787600 1 0 $X=916530 $Y=783045
X3080 1 2 2276 2304 2039 ICV_58 $T=920320 756240 1 0 $X=919890 $Y=751685
X3081 1 2 2130 2325 2136 ICV_58 $T=923680 913040 1 0 $X=923250 $Y=908485
X3082 1 2 2332 2331 2342 ICV_58 $T=924800 732720 0 0 $X=924370 $Y=732330
X3083 1 2 2337 376 2348 ICV_58 $T=925360 756240 1 0 $X=924930 $Y=751685
X3084 1 2 2315 2431 2371 ICV_58 $T=937120 818960 1 0 $X=936690 $Y=814405
X3085 1 2 2432 2442 2447 ICV_58 $T=938800 834640 0 0 $X=938370 $Y=834250
X3086 1 2 2403 390 2457 ICV_58 $T=941600 748400 1 0 $X=941170 $Y=743845
X3087 1 2 2250 2502 2390 ICV_58 $T=949440 756240 1 0 $X=949010 $Y=751685
X3088 1 2 434 3 450 ICV_94 $T=588240 897360 1 0 $X=587810 $Y=892805
X3089 1 2 6 491 504 ICV_94 $T=594400 913040 1 0 $X=593970 $Y=908485
X3090 1 2 39 517 596 ICV_94 $T=608960 795440 1 0 $X=608530 $Y=790885
X3091 1 2 67 69 927 ICV_94 $T=635280 850320 1 0 $X=634850 $Y=845765
X3092 1 2 66 907 946 ICV_94 $T=636960 881680 0 0 $X=636530 $Y=881290
X3093 1 2 57 832 1026 ICV_94 $T=643680 724880 0 0 $X=643250 $Y=724490
X3094 1 2 28 1023 983 ICV_94 $T=644800 905200 0 0 $X=644370 $Y=904810
X3095 1 2 53 124 1009 ICV_94 $T=645360 944400 0 0 $X=644930 $Y=944010
X3096 1 2 28 1084 1090 ICV_94 $T=654320 944400 1 0 $X=653890 $Y=939845
X3097 1 2 1177 1121 1226 ICV_94 $T=664400 842480 0 0 $X=663970 $Y=842090
X3098 1 2 587 1244 1236 ICV_94 $T=667200 873840 1 0 $X=666770 $Y=869285
X3099 1 2 290 1723 301 ICV_94 $T=806080 748400 1 0 $X=805650 $Y=743845
X3100 1 2 295 1736 1732 ICV_94 $T=811680 732720 1 0 $X=811250 $Y=728165
X3101 1 2 1746 1758 1752 ICV_94 $T=818960 889520 0 0 $X=818530 $Y=889130
X3102 1 2 1817 1760 1852 ICV_94 $T=836880 913040 1 0 $X=836450 $Y=908485
X3103 1 2 1845 1900 1933 ICV_94 $T=850880 897360 0 0 $X=850450 $Y=896970
X3104 1 2 1760 1929 1936 ICV_94 $T=851440 920880 0 0 $X=851010 $Y=920490
X3105 1 2 2030 2044 2066 ICV_94 $T=878880 850320 1 0 $X=878450 $Y=845765
X3106 1 2 2004 2132 2108 ICV_94 $T=890080 866000 0 0 $X=889650 $Y=865610
X3107 1 2 2009 2132 2164 ICV_94 $T=895120 866000 0 0 $X=894690 $Y=865610
X3108 1 2 1903 2137 2179 ICV_94 $T=897360 858160 1 0 $X=896930 $Y=853605
X3109 1 2 2178 2106 2187 ICV_94 $T=899600 920880 0 0 $X=899170 $Y=920490
X3110 1 2 2252 2256 2260 ICV_94 $T=912480 889520 0 0 $X=912050 $Y=889130
X3111 1 2 2453 2272 2474 ICV_94 $T=941600 795440 0 0 $X=941170 $Y=795050
X3112 1 2 438 442 6 ICV_88 $T=588800 834640 0 0 $X=588370 $Y=834250
X3113 1 2 440 446 6 ICV_88 $T=588800 913040 1 0 $X=588370 $Y=908485
X3114 1 2 542 25 548 ICV_88 $T=600000 913040 0 0 $X=599570 $Y=912650
X3115 1 2 621 651 662 ICV_88 $T=609520 834640 0 0 $X=609090 $Y=834250
X3116 1 2 621 597 684 ICV_88 $T=611760 850320 1 0 $X=611330 $Y=845765
X3117 1 2 874 898 903 ICV_88 $T=633600 732720 0 0 $X=633170 $Y=732330
X3118 1 2 517 461 1203 ICV_88 $T=661600 826800 1 0 $X=661170 $Y=822245
X3119 1 2 7 1199 972 ICV_88 $T=662160 811120 1 0 $X=661730 $Y=806565
X3120 1 2 1320 958 1330 ICV_88 $T=675600 834640 1 0 $X=675170 $Y=830085
X3121 1 2 42 1378 1211 ICV_88 $T=681200 787600 0 0 $X=680770 $Y=787210
X3122 1 2 119 1458 23 ICV_88 $T=691280 866000 0 0 $X=690850 $Y=865610
X3123 1 2 1449 20 1486 ICV_88 $T=692960 803280 0 0 $X=692530 $Y=802890
X3124 1 2 182 1472 1546 ICV_88 $T=708080 811120 1 0 $X=707650 $Y=806565
X3125 1 2 296 1711 1721 ICV_88 $T=803840 724880 0 0 $X=803410 $Y=724490
X3126 1 2 2046 2062 1804 ICV_88 $T=880000 866000 0 0 $X=879570 $Y=865610
X3127 1 2 2130 2263 2206 ICV_88 $T=914160 920880 0 0 $X=913730 $Y=920490
X3128 1 2 2292 2389 383 ICV_88 $T=929840 732720 0 0 $X=929410 $Y=732330
X3129 1 2 325 2458 2497 ICV_88 $T=946640 858160 0 0 $X=946210 $Y=857770
X3130 1 2 439 447 453 459 ICV_87 $T=588800 905200 0 0 $X=588370 $Y=904810
X3131 1 2 451 461 464 471 ICV_87 $T=590480 826800 1 0 $X=590050 $Y=822245
X3132 1 2 483 496 506 466 ICV_87 $T=594400 928720 1 0 $X=593970 $Y=924165
X3133 1 2 522 539 462 553 ICV_87 $T=598320 842480 0 0 $X=597890 $Y=842090
X3134 1 2 479 544 555 561 ICV_87 $T=598880 889520 0 0 $X=598450 $Y=889130
X3135 1 2 717 506 743 750 ICV_87 $T=616240 913040 0 0 $X=615810 $Y=912650
X3136 1 2 809 827 836 740 ICV_87 $T=625760 771920 0 0 $X=625330 $Y=771530
X3137 1 2 969 1137 150 1051 ICV_87 $T=654880 889520 0 0 $X=654450 $Y=889130
X3138 1 2 1008 1160 1172 1176 ICV_87 $T=657120 920880 0 0 $X=656690 $Y=920490
X3139 1 2 1147 1166 679 466 ICV_87 $T=657680 842480 0 0 $X=657250 $Y=842090
X3140 1 2 1153 1173 1179 1115 ICV_87 $T=658240 771920 1 0 $X=657810 $Y=767365
X3141 1 2 1170 1199 1209 1212 ICV_87 $T=661600 795440 1 0 $X=661170 $Y=790885
X3142 1 2 1310 1263 1327 1328 ICV_87 $T=674480 881680 0 0 $X=674050 $Y=881290
X3143 1 2 1322 1331 1342 189 ICV_87 $T=675600 944400 1 0 $X=675170 $Y=939845
X3144 1 2 1466 1294 1506 1498 ICV_87 $T=696880 842480 0 0 $X=696450 $Y=842090
X3145 1 2 1709 294 1713 1717 ICV_87 $T=801600 748400 0 0 $X=801170 $Y=748010
X3146 1 2 1714 295 1723 307 ICV_87 $T=808320 756240 1 0 $X=807890 $Y=751685
X3147 1 2 302 306 1721 307 ICV_87 $T=809440 724880 0 0 $X=809010 $Y=724490
X3148 1 2 1760 1762 1766 1765 ICV_87 $T=820080 920880 1 0 $X=819650 $Y=916325
X3149 1 2 1774 1785 1788 1775 ICV_87 $T=823440 881680 1 0 $X=823010 $Y=877125
X3150 1 2 1787 1742 1906 1733 ICV_87 $T=845280 889520 0 0 $X=844850 $Y=889130
X3151 1 2 1912 1830 1946 1893 ICV_87 $T=852560 913040 1 0 $X=852130 $Y=908485
X3152 1 2 2204 2218 2227 2231 ICV_87 $T=905200 928720 1 0 $X=904770 $Y=924165
X3153 1 2 2256 2112 2262 2206 ICV_87 $T=912480 913040 0 0 $X=912050 $Y=912650
X3154 1 2 2343 2401 384 2135 ICV_87 $T=930960 740560 1 0 $X=930530 $Y=736005
X3155 1 2 2473 2468 2483 2302 ICV_87 $T=943840 771920 0 0 $X=943410 $Y=771530
X3156 1 2 2485 2491 2496 2503 ICV_87 $T=947760 756240 0 0 $X=947330 $Y=755850
X3157 1 458 2 452 457 ICV_97 $T=593280 850320 1 180 $X=590050 $Y=849930
X3158 1 545 2 525 43 ICV_97 $T=616800 881680 0 180 $X=613570 $Y=877125
X3159 1 663 2 525 19 ICV_97 $T=617360 873840 1 180 $X=614130 $Y=873450
X3160 1 794 2 759 787 ICV_97 $T=625200 779760 0 180 $X=621970 $Y=775205
X3161 1 1003 2 941 999 ICV_97 $T=644800 905200 0 180 $X=641570 $Y=900645
X3162 1 1057 2 1034 1050 ICV_97 $T=650400 842480 1 180 $X=647170 $Y=842090
X3163 1 118 2 1061 100 ICV_97 $T=656000 724880 1 180 $X=652770 $Y=724490
X3164 1 1140 2 1014 1134 ICV_97 $T=658240 771920 1 180 $X=655010 $Y=771530
X3165 1 151 2 1107 1146 ICV_97 $T=658800 936560 0 180 $X=655570 $Y=932005
X3166 1 1367 2 49 1063 ICV_97 $T=685680 779760 0 180 $X=682450 $Y=775205
X3167 1 1435 2 1276 1424 ICV_97 $T=689600 881680 1 180 $X=686370 $Y=881290
X3168 1 1487 2 1241 1499 ICV_97 $T=700240 889520 1 180 $X=697010 $Y=889130
X3169 1 1783 2 1780 1758 ICV_97 $T=826800 889520 1 180 $X=823570 $Y=889130
X3170 1 1765 2 1784 1792 ICV_97 $T=829600 920880 0 180 $X=826370 $Y=916325
X3171 1 1760 2 1829 1904 ICV_97 $T=849200 913040 1 180 $X=845970 $Y=912650
X3172 1 2030 2 2038 2041 ICV_97 $T=880560 858160 0 180 $X=877330 $Y=853605
X3173 1 1971 2 2035 2091 ICV_97 $T=886720 842480 0 180 $X=883490 $Y=837925
X3174 1 1763 2 1770 2152 ICV_97 $T=896800 897360 0 180 $X=893570 $Y=892805
X3175 1 2174 2 2169 2171 ICV_97 $T=900720 834640 0 180 $X=897490 $Y=830085
X3176 1 2273 2 2282 2308 ICV_97 $T=924240 818960 0 180 $X=921010 $Y=814405
X3177 1 2419 2 373 2348 ICV_97 $T=937120 756240 0 180 $X=933890 $Y=751685
X3178 1 2135 2 2305 387 ICV_97 $T=941600 740560 1 180 $X=938370 $Y=740170
X3179 1 2 477 469 466 ICV_80 $T=591040 818960 1 0 $X=590610 $Y=814405
X3180 1 2 503 481 458 ICV_80 $T=593280 858160 1 0 $X=592850 $Y=853605
X3181 1 2 546 500 23 ICV_80 $T=597760 795440 0 0 $X=597330 $Y=795050
X3182 1 2 582 561 23 ICV_80 $T=600560 897360 1 0 $X=600130 $Y=892805
X3183 1 2 598 580 541 ICV_80 $T=602240 858160 0 0 $X=601810 $Y=857770
X3184 1 2 436 630 587 ICV_80 $T=605600 842480 1 0 $X=605170 $Y=837925
X3185 1 2 696 676 28 ICV_80 $T=611200 944400 1 0 $X=610770 $Y=939845
X3186 1 2 861 747 67 ICV_80 $T=628000 842480 1 0 $X=627570 $Y=837925
X3187 1 2 878 922 951 ICV_80 $T=637520 740560 0 0 $X=637090 $Y=740170
X3188 1 2 1030 904 538 ICV_80 $T=643680 756240 1 0 $X=643250 $Y=751685
X3189 1 2 1290 1254 538 ICV_80 $T=670000 858160 1 0 $X=669570 $Y=853605
X3190 1 2 1386 802 1356 ICV_80 $T=683440 920880 1 0 $X=683010 $Y=916325
X3191 1 2 154 1488 1321 ICV_80 $T=693520 858160 1 0 $X=693090 $Y=853605
X3192 1 2 30 1510 1491 ICV_80 $T=698000 858160 0 0 $X=697570 $Y=857770
X3193 1 2 49 1540 249 ICV_80 $T=705280 944400 1 0 $X=704850 $Y=939845
X3194 1 2 1562 1612 1538 ICV_80 $T=717040 873840 0 0 $X=716610 $Y=873450
X3195 1 2 49 1617 1261 ICV_80 $T=718720 811120 1 0 $X=718290 $Y=806565
X3196 1 2 1602 1609 1618 ICV_80 $T=719840 913040 1 0 $X=719410 $Y=908485
X3197 1 2 7 1626 83 ICV_80 $T=720960 920880 0 0 $X=720530 $Y=920490
X3198 1 2 1562 1621 1590 ICV_80 $T=721520 881680 0 0 $X=721090 $Y=881290
X3199 1 2 131 1772 1727 ICV_80 $T=821200 803280 0 0 $X=820770 $Y=802890
X3200 1 2 333 1923 1848 ICV_80 $T=848640 826800 1 0 $X=848210 $Y=822245
X3201 1 2 1750 1760 1737 ICV_80 $T=857600 913040 0 0 $X=857170 $Y=912650
X3202 1 2 333 2008 1902 ICV_80 $T=867680 764080 1 0 $X=867250 $Y=759525
X3203 1 2 333 2020 342 ICV_80 $T=869360 724880 0 0 $X=868930 $Y=724490
X3204 1 2 333 2016 1913 ICV_80 $T=869360 740560 0 0 $X=868930 $Y=740170
X3205 1 2 2063 2059 2026 ICV_80 $T=877760 881680 0 0 $X=877330 $Y=881290
X3206 1 2 2190 360 358 ICV_80 $T=900160 732720 0 0 $X=899730 $Y=732330
X3207 1 2 2255 2253 2176 ICV_80 $T=909120 928720 0 0 $X=908690 $Y=928330
X3208 1 2 2505 2533 2401 ICV_80 $T=957280 740560 0 0 $X=956850 $Y=740170
X3209 1 2 10 454 12 ICV_105 $T=591040 920880 0 0 $X=590610 $Y=920490
X3210 1 2 11 459 12 ICV_105 $T=591040 944400 1 0 $X=590610 $Y=939845
X3211 1 2 521 522 538 ICV_105 $T=596080 842480 1 0 $X=595650 $Y=837925
X3212 1 2 564 550 501 ICV_105 $T=600000 771920 1 0 $X=599570 $Y=767365
X3213 1 2 570 507 30 ICV_105 $T=600560 936560 1 0 $X=600130 $Y=932005
X3214 1 2 618 620 501 ICV_105 $T=605040 897360 1 0 $X=604610 $Y=892805
X3215 1 2 27 534 38 ICV_105 $T=605040 905200 1 0 $X=604610 $Y=900645
X3216 1 2 647 655 43 ICV_105 $T=607280 866000 0 0 $X=606850 $Y=865610
X3217 1 2 30 606 44 ICV_105 $T=607280 936560 0 0 $X=606850 $Y=936170
X3218 1 2 517 644 674 ICV_105 $T=608400 826800 0 0 $X=607970 $Y=826410
X3219 1 2 510 678 682 ICV_105 $T=609520 764080 1 0 $X=609090 $Y=759525
X3220 1 2 721 628 466 ICV_105 $T=614560 764080 0 0 $X=614130 $Y=763690
X3221 1 2 780 614 50 ICV_105 $T=620160 818960 0 0 $X=619730 $Y=818570
X3222 1 2 832 874 82 ICV_105 $T=628560 732720 1 0 $X=628130 $Y=728165
X3223 1 2 881 887 900 ICV_105 $T=630800 826800 1 0 $X=630370 $Y=822245
X3224 1 2 1135 1120 587 ICV_105 $T=653760 866000 0 0 $X=653330 $Y=865610
X3225 1 2 610 1232 23 ICV_105 $T=664960 897360 1 0 $X=664530 $Y=892805
X3226 1 2 1286 490 1295 ICV_105 $T=669440 905200 1 0 $X=669010 $Y=900645
X3227 1 2 155 180 1083 ICV_105 $T=670560 913040 1 0 $X=670130 $Y=908485
X3228 1 2 188 27 1408 ICV_105 $T=683440 905200 1 0 $X=683010 $Y=900645
X3229 1 2 48 1594 240 ICV_105 $T=714240 944400 0 0 $X=713810 $Y=944010
X3230 1 2 303 1759 1731 ICV_105 $T=817280 740560 0 0 $X=816850 $Y=740170
X3231 1 2 1787 1894 1814 ICV_105 $T=841360 881680 1 0 $X=840930 $Y=877125
X3232 1 2 88 2011 316 ICV_105 $T=873840 811120 1 0 $X=873410 $Y=806565
X3233 1 2 325 2102 1964 ICV_105 $T=883360 803280 1 0 $X=882930 $Y=798725
X3234 1 2 2004 2119 2088 ICV_105 $T=885600 842480 0 0 $X=885170 $Y=842090
X3235 1 2 2088 2127 2092 ICV_105 $T=887280 850320 1 0 $X=886850 $Y=845765
X3236 1 2 2200 2223 2209 ICV_105 $T=904640 795440 0 0 $X=904210 $Y=795050
X3237 1 2 2152 2287 2247 ICV_105 $T=919200 881680 0 0 $X=918770 $Y=881290
X3238 1 2 2290 2405 2411 ICV_105 $T=929840 889520 0 0 $X=929410 $Y=889130
X3239 1 2 467 474 6 ICV_61 $T=592720 866000 1 0 $X=592290 $Y=861445
X3240 1 2 559 608 501 ICV_61 $T=605600 850320 0 0 $X=605170 $Y=849930
X3241 1 2 30 544 610 ICV_61 $T=605600 889520 0 0 $X=605170 $Y=889130
X3242 1 2 563 601 612 ICV_61 $T=605600 928720 1 0 $X=605170 $Y=924165
X3243 1 2 30 671 625 ICV_61 $T=610640 858160 1 0 $X=610210 $Y=853605
X3244 1 2 621 627 685 ICV_61 $T=611760 889520 1 0 $X=611330 $Y=884965
X3245 1 2 518 686 50 ICV_61 $T=612880 897360 1 0 $X=612450 $Y=892805
X3246 1 2 49 589 661 ICV_61 $T=614000 795440 1 0 $X=613570 $Y=790885
X3247 1 2 698 707 711 ICV_61 $T=614560 795440 0 0 $X=614130 $Y=795050
X3248 1 2 732 684 719 ICV_61 $T=617360 850320 1 0 $X=616930 $Y=845765
X3249 1 2 18 681 28 ICV_61 $T=617360 858160 0 0 $X=616930 $Y=857770
X3250 1 2 65 771 719 ICV_61 $T=620720 889520 0 0 $X=620290 $Y=889130
X3251 1 2 729 803 23 ICV_61 $T=623520 795440 0 0 $X=623090 $Y=795050
X3252 1 2 48 77 70 ICV_61 $T=623520 936560 0 0 $X=623090 $Y=936170
X3253 1 2 81 826 50 ICV_61 $T=626320 928720 1 0 $X=625890 $Y=924165
X3254 1 2 497 842 932 ICV_61 $T=636400 764080 1 0 $X=635970 $Y=759525
X3255 1 2 884 930 934 ICV_61 $T=636400 913040 1 0 $X=635970 $Y=908485
X3256 1 2 907 682 942 ICV_61 $T=636960 803280 1 0 $X=636530 $Y=798725
X3257 1 2 940 961 982 ICV_61 $T=640320 850320 1 0 $X=639890 $Y=845765
X3258 1 2 28 994 1015 ICV_61 $T=643120 842480 0 0 $X=642690 $Y=842090
X3259 1 2 984 137 23 ICV_61 $T=650960 756240 1 0 $X=650530 $Y=751685
X3260 1 2 125 730 139 ICV_61 $T=651520 779760 0 0 $X=651090 $Y=779370
X3261 1 2 12 1104 942 ICV_61 $T=652080 818960 1 0 $X=651650 $Y=814405
X3262 1 2 1093 1105 19 ICV_61 $T=652640 873840 1 0 $X=652210 $Y=869285
X3263 1 2 28 1098 1128 ICV_61 $T=653760 866000 1 0 $X=653330 $Y=861445
X3264 1 2 517 1139 1081 ICV_61 $T=657120 826800 0 0 $X=656690 $Y=826410
X3265 1 2 1118 1181 1191 ICV_61 $T=659920 787600 0 0 $X=659490 $Y=787210
X3266 1 2 1185 91 48 ICV_61 $T=660480 936560 1 0 $X=660050 $Y=932005
X3267 1 2 1101 660 165 ICV_61 $T=662720 795440 0 0 $X=662290 $Y=795050
X3268 1 2 164 97 1217 ICV_61 $T=663840 944400 1 0 $X=663410 $Y=939845
X3269 1 2 152 1221 958 ICV_61 $T=664400 779760 0 0 $X=663970 $Y=779370
X3270 1 2 152 1158 909 ICV_61 $T=664960 897360 0 0 $X=664530 $Y=896970
X3271 1 2 1223 174 525 ICV_61 $T=667760 881680 1 0 $X=667330 $Y=877125
X3272 1 2 123 1328 184 ICV_61 $T=676160 905200 1 0 $X=675730 $Y=900645
X3273 1 2 1278 1326 1312 ICV_61 $T=677280 818960 0 0 $X=676850 $Y=818570
X3274 1 2 1306 1023 1348 ICV_61 $T=677280 905200 0 0 $X=676850 $Y=904810
X3275 1 2 98 1393 48 ICV_61 $T=681760 905200 0 0 $X=681330 $Y=904810
X3276 1 2 1252 1426 50 ICV_61 $T=686800 771920 0 0 $X=686370 $Y=771530
X3277 1 2 1456 1210 210 ICV_61 $T=690160 936560 0 0 $X=689730 $Y=936170
X3278 1 2 201 1031 211 ICV_61 $T=690720 826800 1 0 $X=690290 $Y=822245
X3279 1 2 182 1395 211 ICV_61 $T=690720 826800 0 0 $X=690290 $Y=826410
X3280 1 2 1448 1471 3 ICV_61 $T=691840 756240 1 0 $X=691410 $Y=751685
X3281 1 2 182 212 1478 ICV_61 $T=691840 928720 0 0 $X=691410 $Y=928330
X3282 1 2 201 1101 1482 ICV_61 $T=692400 779760 0 0 $X=691970 $Y=779370
X3283 1 2 201 1412 1478 ICV_61 $T=695200 928720 1 0 $X=694770 $Y=924165
X3284 1 2 1320 1200 1439 ICV_61 $T=699120 850320 1 0 $X=698690 $Y=845765
X3285 1 2 201 125 1514 ICV_61 $T=700800 779760 0 0 $X=700370 $Y=779370
X3286 1 2 1497 1329 165 ICV_61 $T=701360 795440 0 0 $X=700930 $Y=795050
X3287 1 2 182 1457 1527 ICV_61 $T=704160 834640 1 0 $X=703730 $Y=830085
X3288 1 2 201 1278 1549 ICV_61 $T=708080 803280 0 0 $X=707650 $Y=802890
X3289 1 2 182 1311 1576 ICV_61 $T=713680 818960 0 0 $X=713250 $Y=818570
X3290 1 2 1707 291 1713 ICV_61 $T=801600 748400 1 0 $X=801170 $Y=743845
X3291 1 2 1717 1710 1731 ICV_61 $T=808320 748400 0 0 $X=807890 $Y=748010
X3292 1 2 1864 1885 1892 ICV_61 $T=842480 928720 1 0 $X=842050 $Y=924165
X3293 1 2 1933 1922 1892 ICV_61 $T=855920 897360 0 0 $X=855490 $Y=896970
X3294 1 2 2124 2034 2130 ICV_61 $T=889520 897360 1 0 $X=889090 $Y=892805
X3295 1 2 2159 2218 2152 ICV_61 $T=904640 920880 0 0 $X=904210 $Y=920490
X3296 1 2 2186 2220 2222 ICV_61 $T=905200 850320 0 0 $X=904770 $Y=849930
X3297 1 2 2233 2232 2248 ICV_61 $T=908560 811120 1 0 $X=908130 $Y=806565
X3298 1 2 2106 2274 2142 ICV_61 $T=916960 889520 1 0 $X=916530 $Y=884965
X3299 1 2 2258 2273 2318 ICV_61 $T=922560 811120 0 0 $X=922130 $Y=810730
X3300 1 2 2357 2358 2278 ICV_61 $T=927600 834640 1 0 $X=927170 $Y=830085
X3301 1 2 2135 2467 2419 ICV_61 $T=942160 740560 1 0 $X=941730 $Y=736005
X3302 1 2 2446 2470 2374 ICV_61 $T=942720 818960 0 0 $X=942290 $Y=818570
X3303 1 2 2340 2487 2420 ICV_61 $T=946080 803280 1 0 $X=945650 $Y=798725
X3304 1 2 7 486 15 ICV_90 $T=593280 779760 1 0 $X=592850 $Y=775205
X3305 1 2 486 492 500 ICV_90 $T=593280 779760 0 0 $X=592850 $Y=779370
X3306 1 2 464 493 501 ICV_90 $T=593280 818960 0 0 $X=592850 $Y=818570
X3307 1 2 537 24 548 ICV_90 $T=597760 920880 1 0 $X=597330 $Y=916325
X3308 1 2 573 498 587 ICV_90 $T=601120 842480 1 0 $X=600690 $Y=837925
X3309 1 2 525 17 663 ICV_90 $T=607840 873840 1 0 $X=607410 $Y=869285
X3310 1 2 651 549 683 ICV_90 $T=610080 842480 1 0 $X=609650 $Y=837925
X3311 1 2 764 779 790 ICV_90 $T=620160 756240 1 0 $X=619730 $Y=751685
X3312 1 2 835 844 501 ICV_90 $T=626880 748400 1 0 $X=626450 $Y=743845
X3313 1 2 907 996 116 ICV_90 $T=640320 889520 0 0 $X=639890 $Y=889130
X3314 1 2 1079 1078 1111 ICV_90 $T=650400 928720 1 0 $X=649970 $Y=924165
X3315 1 2 49 1085 623 ICV_90 $T=653760 795440 1 0 $X=653330 $Y=790885
X3316 1 2 503 712 1177 ICV_90 $T=657120 850320 0 0 $X=656690 $Y=849930
X3317 1 2 1168 1173 50 ICV_90 $T=658240 756240 1 0 $X=657810 $Y=751685
X3318 1 2 466 1198 37 ICV_90 $T=659920 858160 0 0 $X=659490 $Y=857770
X3319 1 2 1304 977 1369 ICV_90 $T=677840 811120 0 0 $X=677410 $Y=810730
X3320 1 2 152 1377 36 ICV_90 $T=678960 897360 0 0 $X=678530 $Y=896970
X3321 1 2 182 1217 209 ICV_90 $T=687360 928720 0 0 $X=686930 $Y=928330
X3322 1 2 1476 149 1444 ICV_90 $T=694080 771920 0 0 $X=693650 $Y=771530
X3323 1 2 1323 1511 1522 ICV_90 $T=700800 764080 0 0 $X=700370 $Y=763690
X3324 1 2 235 1271 37 ICV_90 $T=703040 920880 0 0 $X=702610 $Y=920490
X3325 1 2 1554 1534 1561 ICV_90 $T=708640 866000 1 0 $X=708210 $Y=861445
X3326 1 2 1505 1203 1565 ICV_90 $T=710320 826800 1 0 $X=709890 $Y=822245
X3327 1 2 37 1590 1478 ICV_90 $T=714240 889520 1 0 $X=713810 $Y=884965
X3328 1 2 1570 257 1594 ICV_90 $T=714800 944400 1 0 $X=714370 $Y=939845
X3329 1 2 1171 1601 1608 ICV_90 $T=715920 850320 0 0 $X=715490 $Y=849930
X3330 1 2 1600 258 1621 ICV_90 $T=719280 920880 1 0 $X=718850 $Y=916325
X3331 1 2 1796 1825 1826 ICV_90 $T=830160 897360 1 0 $X=829730 $Y=892805
X3332 1 2 1784 1828 1800 ICV_90 $T=831280 905200 0 0 $X=830850 $Y=904810
X3333 1 2 1750 1832 1800 ICV_90 $T=831840 905200 1 0 $X=831410 $Y=900645
X3334 1 2 1859 1881 1787 ICV_90 $T=839680 866000 0 0 $X=839250 $Y=865610
X3335 1 2 1842 1882 1775 ICV_90 $T=840240 889520 1 0 $X=839810 $Y=884965
X3336 1 2 1905 1928 1795 ICV_90 $T=849200 905200 0 0 $X=848770 $Y=904810
X3337 1 2 1926 1942 88 ICV_90 $T=852560 764080 0 0 $X=852130 $Y=763690
X3338 1 2 2100 2061 2092 ICV_90 $T=887840 834640 0 0 $X=887410 $Y=834250
X3339 1 2 2365 2427 2208 ICV_90 $T=934880 795440 1 0 $X=934450 $Y=790885
X3340 1 2 370 395 2039 ICV_90 $T=944960 732720 1 0 $X=944530 $Y=728165
X3341 1 2 493 431 513 520 ICV_91 $T=593280 826800 0 0 $X=592850 $Y=826410
X3342 1 2 514 575 590 594 ICV_91 $T=599440 834640 1 0 $X=599010 $Y=830085
X3343 1 2 848 867 875 466 ICV_91 $T=627440 764080 0 0 $X=627010 $Y=763690
X3344 1 2 1005 37 1029 466 ICV_91 $T=641440 866000 1 0 $X=641010 $Y=861445
X3345 1 2 1161 1139 1189 17 ICV_91 $T=656560 834640 1 0 $X=656130 $Y=830085
X3346 1 2 1201 1232 1241 1228 ICV_91 $T=663280 889520 0 0 $X=662850 $Y=889130
X3347 1 2 1065 1405 1461 37 ICV_91 $T=686800 858160 0 0 $X=686370 $Y=857770
X3348 1 2 1459 113 1475 1471 ICV_91 $T=688480 771920 1 0 $X=688050 $Y=767365
X3349 1 2 1766 1762 1799 1755 ICV_91 $T=823440 920880 0 0 $X=823010 $Y=920490
X3350 1 2 302 293 1781 319 ICV_91 $T=824000 732720 1 0 $X=823570 $Y=728165
X3351 1 2 1780 1796 1801 1755 ICV_91 $T=824000 897360 1 0 $X=823570 $Y=892805
X3352 1 2 1751 1744 1808 1800 ICV_91 $T=825680 905200 1 0 $X=825250 $Y=900645
X3353 1 2 2120 2134 2037 2142 ICV_91 $T=887840 897360 0 0 $X=887410 $Y=896970
X3354 1 2 2237 2271 2288 2253 ICV_91 $T=913600 928720 0 0 $X=913170 $Y=928330
X3355 1 2 2427 2423 2446 2450 ICV_91 $T=935440 787600 0 0 $X=935010 $Y=787210
X3356 1 2 2466 2250 2445 2302 ICV_91 $T=942720 764080 1 0 $X=942290 $Y=759525
X3357 1 2 450 479 485 ICV_62 $T=593280 897360 1 0 $X=592850 $Y=892805
X3358 1 2 443 509 586 ICV_62 $T=602240 764080 1 0 $X=601810 $Y=759525
X3359 1 2 546 540 538 ICV_62 $T=602240 803280 1 0 $X=601810 $Y=798725
X3360 1 2 497 635 41 ICV_62 $T=607840 936560 1 0 $X=607410 $Y=932005
X3361 1 2 9 699 12 ICV_62 $T=614000 826800 1 0 $X=613570 $Y=822245
X3362 1 2 478 56 724 ICV_62 $T=615680 905200 1 0 $X=615250 $Y=900645
X3363 1 2 46 685 719 ICV_62 $T=616240 889520 1 0 $X=615810 $Y=884965
X3364 1 2 27 724 48 ICV_62 $T=626320 905200 1 0 $X=625890 $Y=900645
X3365 1 2 85 827 876 ICV_62 $T=630800 779760 1 0 $X=630370 $Y=775205
X3366 1 2 800 902 30 ICV_62 $T=634160 850320 0 0 $X=633730 $Y=849930
X3367 1 2 863 908 897 ICV_62 $T=634160 897360 0 0 $X=633730 $Y=896970
X3368 1 2 907 929 963 ICV_62 $T=638640 873840 1 0 $X=638210 $Y=869285
X3369 1 2 925 969 501 ICV_62 $T=639760 881680 1 0 $X=639330 $Y=877125
X3370 1 2 907 987 531 ICV_62 $T=640880 803280 0 0 $X=640450 $Y=802890
X3371 1 2 28 995 1005 ICV_62 $T=642000 858160 1 0 $X=641570 $Y=853605
X3372 1 2 517 979 83 ICV_62 $T=642560 936560 1 0 $X=642130 $Y=932005
X3373 1 2 1031 856 1046 ICV_62 $T=646480 795440 1 0 $X=646050 $Y=790885
X3374 1 2 1060 847 12 ICV_62 $T=650400 881680 0 0 $X=649970 $Y=881290
X3375 1 2 967 1109 1106 ICV_62 $T=652640 850320 1 0 $X=652210 $Y=845765
X3376 1 2 1117 1111 67 ICV_62 $T=658240 928720 1 0 $X=657810 $Y=924165
X3377 1 2 802 138 67 ICV_62 $T=658240 928720 0 0 $X=657810 $Y=928330
X3378 1 2 152 1194 879 ICV_62 $T=660480 779760 0 0 $X=660050 $Y=779370
X3379 1 2 1268 696 172 ICV_62 $T=676160 928720 0 0 $X=675730 $Y=928330
X3380 1 2 1258 1351 23 ICV_62 $T=678400 771920 1 0 $X=677970 $Y=767365
X3381 1 2 1319 1234 1395 ICV_62 $T=681760 818960 0 0 $X=681330 $Y=818570
X3382 1 2 1386 1117 1400 ICV_62 $T=682320 928720 1 0 $X=681890 $Y=924165
X3383 1 2 1031 531 1410 ICV_62 $T=684000 795440 0 0 $X=683570 $Y=795050
X3384 1 2 1399 1084 202 ICV_62 $T=685120 944400 1 0 $X=684690 $Y=939845
X3385 1 2 194 147 1430 ICV_62 $T=686240 936560 0 0 $X=685810 $Y=936170
X3386 1 2 201 1319 1438 ICV_62 $T=686800 850320 0 0 $X=686370 $Y=849930
X3387 1 2 201 1346 1452 ICV_62 $T=688480 779760 0 0 $X=688050 $Y=779370
X3388 1 2 1425 80 1468 ICV_62 $T=690720 905200 0 0 $X=690290 $Y=904810
X3389 1 2 1365 179 1400 ICV_62 $T=691280 928720 1 0 $X=690850 $Y=924165
X3390 1 2 1451 72 203 ICV_62 $T=691280 944400 0 0 $X=690850 $Y=944010
X3391 1 2 201 1304 213 ICV_62 $T=691840 787600 0 0 $X=691410 $Y=787210
X3392 1 2 1453 112 1485 ICV_62 $T=692960 803280 1 0 $X=692530 $Y=798725
X3393 1 2 1210 1490 37 ICV_62 $T=694640 873840 0 0 $X=694210 $Y=873450
X3394 1 2 201 1411 220 ICV_62 $T=698560 818960 1 0 $X=698130 $Y=814405
X3395 1 2 201 1425 232 ICV_62 $T=699120 913040 0 0 $X=698690 $Y=912650
X3396 1 2 37 1538 244 ICV_62 $T=706960 873840 0 0 $X=706530 $Y=873450
X3397 1 2 1780 1821 1825 ICV_62 $T=831840 897360 0 0 $X=831410 $Y=896970
X3398 1 2 1991 2026 2000 ICV_62 $T=872160 858160 1 0 $X=871730 $Y=853605
X3399 1 2 2092 2146 2043 ICV_62 $T=892880 842480 1 0 $X=892450 $Y=837925
X3400 1 2 2125 2166 1722 ICV_62 $T=900160 913040 1 0 $X=899730 $Y=908485
X3401 1 2 470 528 487 540 ICV_106 $T=595520 803280 1 0 $X=595090 $Y=798725
X3402 1 2 789 980 115 117 ICV_106 $T=638640 944400 0 0 $X=638210 $Y=944010
X3403 1 2 993 1019 1027 912 ICV_106 $T=642000 811120 0 0 $X=641570 $Y=810730
X3404 1 2 143 1122 1131 1130 ICV_106 $T=651520 920880 1 0 $X=651090 $Y=916325
X3405 1 2 1120 1077 1144 1150 ICV_106 $T=652640 858160 1 0 $X=652210 $Y=853605
X3406 1 2 1102 1159 1170 19 ICV_106 $T=655440 795440 0 0 $X=655010 $Y=795050
X3407 1 2 708 1226 1239 1248 ICV_106 $T=663840 834640 0 0 $X=663410 $Y=834250
X3408 1 2 720 1256 1266 1275 ICV_106 $T=666080 748400 0 0 $X=665650 $Y=748010
X3409 1 2 1188 1352 1362 1373 ICV_106 $T=677280 787600 1 0 $X=676850 $Y=783045
X3410 1 2 1354 1424 1450 1455 ICV_106 $T=685680 889520 0 0 $X=685250 $Y=889130
X3411 1 2 1517 1592 1481 1613 ICV_106 $T=714800 897360 1 0 $X=714370 $Y=892805
X3412 1 2 1359 1636 1638 1597 ICV_106 $T=722080 779760 1 0 $X=721650 $Y=775205
X3413 1 2 1907 1922 1927 1918 ICV_106 $T=847520 897360 1 0 $X=847090 $Y=892805
X3414 1 2 2183 2164 2193 2163 ICV_106 $T=899040 873840 1 0 $X=898610 $Y=869285
X3415 1 2 2254 2136 2306 2247 ICV_106 $T=917520 905200 1 0 $X=917090 $Y=900645
X3416 1 2 2319 2281 2328 2346 ICV_106 $T=922000 787600 1 0 $X=921570 $Y=783045
X3417 1 2 2364 2280 2410 2371 ICV_106 $T=929280 795440 0 0 $X=928850 $Y=795050
X3418 1 2 490 499 12 ICV_56 $T=598320 897360 1 180 $X=595090 $Y=896970
X3419 1 2 523 515 474 ICV_56 $T=600000 866000 0 180 $X=596770 $Y=861445
X3420 1 2 7 551 531 ICV_56 $T=603360 779760 0 180 $X=600130 $Y=775205
X3421 1 2 547 554 538 ICV_56 $T=603360 858160 0 180 $X=600130 $Y=853605
X3422 1 2 625 553 587 ICV_56 $T=609520 850320 0 180 $X=606290 $Y=845765
X3423 1 2 702 576 43 ICV_56 $T=616240 905200 1 180 $X=613010 $Y=904810
X3424 1 2 754 753 587 ICV_56 $T=621840 873840 1 180 $X=618610 $Y=873450
X3425 1 2 800 528 587 ICV_56 $T=625760 842480 0 180 $X=622530 $Y=837925
X3426 1 2 849 828 587 ICV_56 $T=631360 771920 0 180 $X=628130 $Y=767365
X3427 1 2 832 797 87 ICV_56 $T=631920 724880 1 180 $X=628690 $Y=724490
X3428 1 2 557 889 587 ICV_56 $T=635840 858160 1 180 $X=632610 $Y=857770
X3429 1 2 949 920 587 ICV_56 $T=640880 771920 0 180 $X=637650 $Y=767365
X3430 1 2 1011 1010 587 ICV_56 $T=645920 771920 0 180 $X=642690 $Y=767365
X3431 1 2 738 1018 730 ICV_56 $T=647040 858160 1 180 $X=643810 $Y=857770
X3432 1 2 990 1011 1012 ICV_56 $T=648720 771920 1 180 $X=645490 $Y=771530
X3433 1 2 1031 680 1045 ICV_56 $T=652080 787600 1 180 $X=648850 $Y=787210
X3434 1 2 517 1086 1083 ICV_56 $T=653760 889520 0 180 $X=650530 $Y=884965
X3435 1 2 49 1056 505 ICV_56 $T=654880 826800 1 180 $X=651650 $Y=826410
X3436 1 2 1143 1153 1027 ICV_56 $T=659920 811120 0 180 $X=656690 $Y=806565
X3437 1 2 1229 691 1046 ICV_56 $T=668320 834640 0 180 $X=665090 $Y=830085
X3438 1 2 1253 985 165 ICV_56 $T=670560 811120 0 180 $X=667330 $Y=806565
X3439 1 2 42 1269 1185 ICV_56 $T=672240 936560 1 180 $X=669010 $Y=936170
X3440 1 2 163 1248 1075 ICV_56 $T=673360 834640 0 180 $X=670130 $Y=830085
X3441 1 2 1252 1277 3 ICV_56 $T=673920 771920 1 180 $X=670690 $Y=771530
X3442 1 2 42 1288 1237 ICV_56 $T=674480 787600 1 180 $X=671250 $Y=787210
X3443 1 2 163 1267 1282 ICV_56 $T=674480 826800 1 180 $X=671250 $Y=826410
X3444 1 2 1298 721 1289 ICV_56 $T=675040 818960 1 180 $X=671810 $Y=818570
X3445 1 2 1299 1292 1068 ICV_56 $T=675040 873840 0 180 $X=671810 $Y=869285
X3446 1 2 1262 1299 538 ICV_56 $T=675600 873840 1 180 $X=672370 $Y=873450
X3447 1 2 1319 661 1289 ICV_56 $T=677280 826800 0 180 $X=674050 $Y=822245
X3448 1 2 1326 503 37 ICV_56 $T=678400 850320 1 180 $X=675170 $Y=849930
X3449 1 2 1335 1317 23 ICV_56 $T=678960 897360 0 180 $X=675730 $Y=892805
X3450 1 2 1384 1124 1370 ICV_56 $T=685120 842480 0 180 $X=681890 $Y=837925
X3451 1 2 154 1464 602 ICV_56 $T=694080 881680 1 180 $X=690850 $Y=881290
X3452 1 2 1481 1455 30 ICV_56 $T=695200 889520 0 180 $X=691970 $Y=884965
X3453 1 2 182 1295 216 ICV_56 $T=697440 905200 0 180 $X=694210 $Y=900645
X3454 1 2 182 218 206 ICV_56 $T=698000 920880 1 180 $X=694770 $Y=920490
X3455 1 2 42 1492 1350 ICV_56 $T=699120 756240 0 180 $X=695890 $Y=751685
X3456 1 2 1244 1494 37 ICV_56 $T=699680 866000 1 180 $X=696450 $Y=865610
X3457 1 2 1505 959 1457 ICV_56 $T=700800 811120 1 180 $X=697570 $Y=810730
X3458 1 2 154 1516 148 ICV_56 $T=704720 771920 0 180 $X=701490 $Y=767365
X3459 1 2 49 1515 1329 ICV_56 $T=704720 779760 0 180 $X=701490 $Y=775205
X3460 1 2 1516 1469 1515 ICV_56 $T=705840 771920 1 180 $X=702610 $Y=771530
X3461 1 2 1456 111 1249 ICV_56 $T=709200 936560 0 180 $X=705970 $Y=932005
X3462 1 2 49 1537 776 ICV_56 $T=709760 771920 0 180 $X=706530 $Y=767365
X3463 1 2 241 1542 228 ICV_56 $T=710320 866000 1 180 $X=707090 $Y=865610
X3464 1 2 49 1541 15 ICV_56 $T=710880 764080 1 180 $X=707650 $Y=763690
X3465 1 2 42 1545 1372 ICV_56 $T=710880 771920 1 180 $X=707650 $Y=771530
X3466 1 2 1547 932 1204 ICV_56 $T=710880 826800 1 180 $X=707650 $Y=826410
X3467 1 2 201 1505 222 ICV_56 $T=711440 818960 1 180 $X=708210 $Y=818570
X3468 1 2 201 1357 1527 ICV_56 $T=711440 834640 0 180 $X=708210 $Y=830085
X3469 1 2 1547 5 1489 ICV_56 $T=711440 834640 1 180 $X=708210 $Y=834250
X3470 1 2 1570 1554 1533 ICV_56 $T=714240 928720 1 180 $X=711010 $Y=928330
X3471 1 2 1568 1567 1537 ICV_56 $T=714800 771920 0 180 $X=711570 $Y=767365
X3472 1 2 154 1597 1460 ICV_56 $T=719840 779760 0 180 $X=716610 $Y=775205
X3473 1 2 49 1607 5 ICV_56 $T=720960 818960 1 180 $X=717730 $Y=818570
X3474 1 2 237 1605 1507 ICV_56 $T=724880 866000 0 180 $X=721650 $Y=861445
X3475 1 2 1784 1790 1765 ICV_56 $T=828480 928720 1 180 $X=825250 $Y=928330
X3476 1 2 295 1818 319 ICV_56 $T=834080 724880 1 180 $X=830850 $Y=724490
X3477 1 2 1914 1909 160 ICV_56 $T=850320 858160 1 180 $X=847090 $Y=857770
X3478 1 2 333 1919 1856 ICV_56 $T=852000 795440 1 180 $X=848770 $Y=795050
X3479 1 2 1993 2141 2119 ICV_56 $T=895120 842480 1 180 $X=891890 $Y=842090
X3480 1 2 2240 2236 160 ICV_56 $T=910800 944400 1 180 $X=907570 $Y=944010
X3481 1 2 2152 2230 2133 ICV_56 $T=911920 920880 1 180 $X=908690 $Y=920490
X3482 1 2 2259 2248 2257 ICV_56 $T=915840 811120 0 180 $X=912610 $Y=806565
X3483 1 2 2250 2265 2039 ICV_56 $T=916960 740560 1 180 $X=913730 $Y=740170
X3484 1 2 2181 2283 2263 ICV_56 $T=919760 928720 0 180 $X=916530 $Y=924165
X3485 1 2 2283 2301 2296 ICV_56 $T=922560 920880 1 180 $X=919330 $Y=920490
X3486 1 2 2375 2370 1763 ICV_56 $T=930960 913040 1 180 $X=927730 $Y=912650
X3487 1 2 2377 2320 2208 ICV_56 $T=931520 787600 1 180 $X=928290 $Y=787210
X3488 1 2 2305 2418 373 ICV_56 $T=939360 748400 0 180 $X=936130 $Y=743845
X3489 1 2 2371 2423 2259 ICV_56 $T=939360 795440 1 180 $X=936130 $Y=795050
X3490 1 2 2424 386 2039 ICV_56 $T=940480 724880 1 180 $X=937250 $Y=724490
X3491 1 2 2440 2415 2257 ICV_56 $T=940480 818960 1 180 $X=937250 $Y=818570
X3492 1 2 2286 2447 2353 ICV_56 $T=942160 834640 0 180 $X=938930 $Y=830085
X3493 1 2 2461 2460 1916 ICV_56 $T=943840 866000 0 180 $X=940610 $Y=861445
X3494 1 2 2420 2465 2353 ICV_56 $T=944960 826800 0 180 $X=941730 $Y=822245
X3495 1 2 2286 2404 2454 ICV_56 $T=947200 803280 1 180 $X=943970 $Y=802890
X3496 1 2 2469 2522 2390 ICV_56 $T=957280 756240 1 180 $X=954050 $Y=755850
X3497 1 2 14 504 516 525 ICV_92 $T=595520 905200 0 0 $X=595090 $Y=904810
X3498 1 2 532 512 552 558 ICV_92 $T=598880 818960 1 0 $X=598450 $Y=814405
X3499 1 2 508 549 559 554 ICV_92 $T=599440 850320 0 0 $X=599010 $Y=849930
X3500 1 2 524 529 560 567 ICV_92 $T=599440 873840 0 0 $X=599010 $Y=873450
X3501 1 2 604 581 634 641 ICV_92 $T=606160 881680 1 0 $X=605730 $Y=877125
X3502 1 2 603 644 650 656 ICV_92 $T=607840 826800 1 0 $X=607410 $Y=822245
X3503 1 2 646 655 672 671 ICV_92 $T=609520 858160 0 0 $X=609090 $Y=857770
X3504 1 2 645 686 669 701 ICV_92 $T=611760 897360 0 0 $X=611330 $Y=896970
X3505 1 2 694 709 715 703 ICV_92 $T=614000 756240 1 0 $X=613570 $Y=751685
X3506 1 2 657 744 653 663 ICV_92 $T=617360 913040 1 0 $X=616930 $Y=908485
X3507 1 2 927 956 773 37 ICV_92 $T=638080 858160 0 0 $X=637650 $Y=857770
X3508 1 2 938 118 859 1016 ICV_92 $T=642000 732720 1 0 $X=641570 $Y=728165
X3509 1 2 986 928 1007 1010 ICV_92 $T=642000 795440 0 0 $X=641570 $Y=795050
X3510 1 2 574 954 128 1056 ICV_92 $T=645920 842480 1 0 $X=645490 $Y=837925
X3511 1 2 1072 1047 1103 1099 ICV_92 $T=650960 811120 1 0 $X=650530 $Y=806565
X3512 1 2 846 1192 1197 1196 ICV_92 $T=659920 748400 0 0 $X=659490 $Y=748010
X3513 1 2 1174 1138 1223 1231 ICV_92 $T=663840 881680 0 0 $X=663410 $Y=881290
X3514 1 2 1205 1233 1247 1065 ICV_92 $T=666080 818960 0 0 $X=665650 $Y=818570
X3515 1 2 1227 1055 1296 1301 ICV_92 $T=671120 740560 0 0 $X=670690 $Y=740170
X3516 1 2 787 1293 1303 1221 ICV_92 $T=671680 779760 1 0 $X=671250 $Y=775205
X3517 1 2 1087 1287 1305 1317 ICV_92 $T=672240 889520 0 0 $X=671810 $Y=889130
X3518 1 2 1279 902 1392 1385 ICV_92 $T=680640 850320 0 0 $X=680210 $Y=849930
X3519 1 2 664 1390 1398 195 ICV_92 $T=681200 897360 1 0 $X=680770 $Y=892805
X3520 1 2 1178 1379 1404 1388 ICV_92 $T=682320 779760 0 0 $X=681890 $Y=779370
X3521 1 2 1257 1353 1442 1454 ICV_92 $T=687360 858160 1 0 $X=686930 $Y=853605
X3522 1 2 1313 1495 1500 1464 ICV_92 $T=696320 881680 0 0 $X=695890 $Y=881290
X3523 1 2 1523 1543 71 1574 ICV_92 $T=710320 913040 1 0 $X=709890 $Y=908485
X3524 1 2 1494 1595 1552 1605 ICV_92 $T=715920 866000 1 0 $X=715490 $Y=861445
X3525 1 2 1701 1702 1704 1706 ICV_92 $T=798240 732720 0 0 $X=797810 $Y=732330
X3526 1 2 303 298 1749 306 ICV_92 $T=816160 724880 0 0 $X=815730 $Y=724490
X3527 1 2 1752 1762 1764 1765 ICV_92 $T=818960 928720 1 0 $X=818530 $Y=924165
X3528 1 2 1995 1967 1997 2000 ICV_92 $T=867120 850320 0 0 $X=866690 $Y=849930
X3529 1 2 2033 2053 2072 2082 ICV_92 $T=881120 858160 0 0 $X=880690 $Y=857770
X3530 1 2 2194 2202 2216 2221 ICV_92 $T=902960 881680 1 0 $X=902530 $Y=877125
X3531 1 2 2187 2176 2204 2125 ICV_92 $T=902960 928720 0 0 $X=902530 $Y=928330
X3532 1 2 2296 2058 2307 1996 ICV_92 $T=919200 920880 1 0 $X=918770 $Y=916325
X3533 1 2 2152 2160 2310 1996 ICV_92 $T=919760 905200 0 0 $X=919330 $Y=904810
X3534 1 2 2268 2302 371 372 ICV_92 $T=920880 732720 1 0 $X=920450 $Y=728165
X3535 1 2 2323 2304 2342 2305 ICV_92 $T=924240 748400 1 0 $X=923810 $Y=743845
X3536 1 2 2365 2353 2378 2258 ICV_92 $T=928160 811120 1 0 $X=927730 $Y=806565
X3537 1 2 2384 2344 2403 2397 ICV_92 $T=930400 748400 1 0 $X=929970 $Y=743845
X3538 1 2 2424 373 389 2419 ICV_92 $T=938800 732720 1 0 $X=938370 $Y=728165
X3539 1 2 2424 370 392 2276 ICV_92 $T=942720 724880 0 0 $X=942290 $Y=724490
X3540 1 2 507 519 535 527 ICV_98 $T=595520 936560 0 0 $X=595090 $Y=936170
X3541 1 2 550 551 579 589 ICV_98 $T=600000 771920 0 0 $X=599570 $Y=771530
X3542 1 2 692 466 60 501 ICV_98 $T=615120 920880 1 0 $X=614690 $Y=916325
X3543 1 2 723 768 626 782 ICV_98 $T=618480 850320 0 0 $X=618050 $Y=849930
X3544 1 2 608 817 824 831 ICV_98 $T=623520 850320 0 0 $X=623090 $Y=849930
X3545 1 2 807 913 925 929 ICV_98 $T=633600 881680 1 0 $X=633170 $Y=877125
X3546 1 2 497 112 113 501 ICV_98 $T=638080 764080 0 0 $X=637650 $Y=763690
X3547 1 2 933 974 988 994 ICV_98 $T=638640 834640 0 0 $X=638210 $Y=834250
X3548 1 2 999 1035 1041 6 ICV_98 $T=644240 897360 0 0 $X=643810 $Y=896970
X3549 1 2 991 1036 1044 6 ICV_98 $T=644240 936560 0 0 $X=643810 $Y=936170
X3550 1 2 978 37 1070 466 ICV_98 $T=646480 913040 1 0 $X=646050 $Y=908485
X3551 1 2 1079 138 140 144 ICV_98 $T=649280 936560 0 0 $X=648850 $Y=936170
X3552 1 2 1041 1148 1156 1158 ICV_98 $T=654320 897360 0 0 $X=653890 $Y=896970
X3553 1 2 1092 1180 1187 1194 ICV_98 $T=658800 779760 1 0 $X=658370 $Y=775205
X3554 1 2 1222 716 1240 1254 ICV_98 $T=664960 858160 1 0 $X=664530 $Y=853605
X3555 1 2 1272 803 1332 1325 ICV_98 $T=673920 795440 0 0 $X=673490 $Y=795050
X3556 1 2 1308 1280 1353 1065 ICV_98 $T=675600 850320 1 0 $X=675170 $Y=845765
X3557 1 2 1413 1458 1462 1182 ICV_98 $T=687920 866000 1 0 $X=687490 $Y=861445
X3558 1 2 1870 1830 1899 1829 ICV_98 $T=841360 920880 1 0 $X=840930 $Y=916325
X3559 1 2 2440 2353 2455 2258 ICV_98 $T=937680 811120 0 0 $X=937250 $Y=810730
X3560 1 2 547 541 23 ICV_83 $T=597200 858160 0 0 $X=596770 $Y=857770
X3561 1 2 689 640 587 ICV_83 $T=610080 779760 1 0 $X=609650 $Y=775205
X3562 1 2 42 701 47 ICV_83 $T=615120 920880 0 0 $X=614690 $Y=920490
X3563 1 2 517 675 58 ICV_83 $T=615120 936560 1 0 $X=614690 $Y=932005
X3564 1 2 1053 924 1006 ICV_83 $T=645360 873840 0 0 $X=644930 $Y=873450
X3565 1 2 1126 921 1016 ICV_83 $T=651520 732720 1 0 $X=651090 $Y=728165
X3566 1 2 1320 888 1289 ICV_83 $T=672800 842480 0 0 $X=672370 $Y=842090
X3567 1 2 1411 869 1407 ICV_83 $T=682320 811120 0 0 $X=681890 $Y=810730
X3568 1 2 1476 39 1410 ICV_83 $T=689600 795440 1 0 $X=689170 $Y=790885
X3569 1 2 1481 1397 23 ICV_83 $T=690160 881680 1 0 $X=689730 $Y=877125
X3570 1 2 1491 1454 23 ICV_83 $T=692960 858160 0 0 $X=692530 $Y=857770
X3571 1 2 231 1524 50 ICV_83 $T=700800 936560 0 0 $X=700370 $Y=936170
X3572 1 2 182 1489 243 ICV_83 $T=705840 858160 1 0 $X=705410 $Y=853605
X3573 1 2 42 1557 149 ICV_83 $T=708080 764080 1 0 $X=707650 $Y=759525
X3574 1 2 237 1564 246 ICV_83 $T=713120 858160 0 0 $X=712690 $Y=857770
X3575 1 2 241 1611 1581 ICV_83 $T=716480 866000 0 0 $X=716050 $Y=865610
X3576 1 2 325 1951 322 ICV_83 $T=860960 732720 1 0 $X=860530 $Y=728165
X3577 1 2 333 2031 1883 ICV_83 $T=871600 779760 1 0 $X=871170 $Y=775205
X3578 1 2 2091 2149 2029 ICV_83 $T=891760 826800 0 0 $X=891330 $Y=826410
X3579 1 2 2166 2134 1763 ICV_83 $T=894000 897360 0 0 $X=893570 $Y=896970
X3580 1 2 2185 2184 2028 ICV_83 $T=897920 866000 1 0 $X=897490 $Y=861445
X3581 1 2 2420 2432 2257 ICV_83 $T=935440 826800 1 0 $X=935010 $Y=822245
X3582 1 2 370 2507 2462 ICV_83 $T=948320 748400 1 0 $X=947890 $Y=743845
X3583 1 2 2502 2514 2507 ICV_83 $T=949440 748400 0 0 $X=949010 $Y=748010
X3584 1 2 2500 2518 2440 ICV_83 $T=950560 818960 0 0 $X=950130 $Y=818570
X3602 1 2 562 499 491 534 ICV_100 $T=603360 913040 0 180 $X=599010 $Y=908485
X3603 1 2 649 637 564 616 ICV_100 $T=611760 771920 0 180 $X=607410 $Y=767365
X3604 1 2 1123 1112 1080 1091 ICV_100 $T=656560 748400 0 180 $X=652210 $Y=743845
X3605 1 2 1230 1219 768 466 ICV_100 $T=668320 850320 1 180 $X=663970 $Y=849930
X3606 1 2 1569 1558 1556 201 ICV_100 $T=714240 905200 0 180 $X=709890 $Y=900645
X3607 1 2 1572 1563 1262 1555 ICV_100 $T=714800 873840 1 180 $X=710450 $Y=873450
X3608 1 2 1757 290 1779 307 ICV_100 $T=827920 756240 0 180 $X=823570 $Y=751685
X3609 1 2 1816 1810 1807 1788 ICV_100 $T=834080 881680 0 180 $X=829730 $Y=877125
X3610 1 2 1819 1814 1816 1762 ICV_100 $T=834640 881680 1 180 $X=830290 $Y=881290
X3611 1 2 1970 1963 341 1960 ICV_100 $T=862080 818960 0 180 $X=857730 $Y=814405
X3612 1 2 2019 2009 2002 1804 ICV_100 $T=873280 858160 1 180 $X=868930 $Y=857770
X3613 1 2 2045 2037 2001 2034 ICV_100 $T=879440 889520 1 180 $X=875090 $Y=889130
X3614 1 2 2097 2085 2060 2079 ICV_100 $T=886720 920880 0 180 $X=882370 $Y=916325
X3615 1 2 2111 2101 2064 2094 ICV_100 $T=888960 905200 1 180 $X=884610 $Y=904810
X3616 1 2 2210 2105 2188 2172 ICV_100 $T=906320 889520 1 180 $X=901970 $Y=889130
X3617 1 2 2245 2232 2224 2223 ICV_100 $T=911360 803280 0 180 $X=907010 $Y=798725
X3618 1 2 2291 2278 2269 2209 ICV_100 $T=920320 826800 0 180 $X=915970 $Y=822245
X3619 1 2 2389 2424 2332 2135 ICV_100 $T=939360 732720 1 180 $X=935010 $Y=732330
X3620 1 2 2441 2305 2430 2135 ICV_100 $T=941040 771920 0 180 $X=936690 $Y=767365
X3621 1 2 585 556 34 606 ICV_84 $T=600560 936560 0 0 $X=600130 $Y=936170
X3622 1 2 693 854 866 872 ICV_84 $T=625760 920880 0 0 $X=625330 $Y=920490
X3623 1 2 843 966 967 976 ICV_84 $T=635840 826800 1 0 $X=635410 $Y=822245
X3624 1 2 938 1126 160 145 ICV_84 $T=656560 732720 1 0 $X=656130 $Y=728165
X3625 1 2 16 129 1432 1441 ICV_84 $T=682880 787600 1 0 $X=682450 $Y=783045
X3626 1 2 1615 1583 1620 1510 ICV_84 $T=717040 850320 1 0 $X=716610 $Y=845765
X3627 1 2 1427 1580 1624 1586 ICV_84 $T=718160 795440 1 0 $X=717730 $Y=790885
X3628 1 2 261 1627 1640 1540 ICV_84 $T=724880 944400 1 0 $X=724450 $Y=939845
X3629 1 2 1779 1791 323 1759 ICV_84 $T=822320 740560 0 0 $X=821890 $Y=740170
X3630 1 2 1799 1871 1875 1827 ICV_84 $T=836320 920880 0 0 $X=835890 $Y=920490
X3631 1 2 1792 1814 1918 1733 ICV_84 $T=844720 881680 0 0 $X=844290 $Y=881290
X3632 1 2 2048 2060 2051 2074 ICV_84 $T=876080 905200 1 0 $X=875650 $Y=900645
X3633 1 2 2068 2081 2084 2036 ICV_84 $T=878320 756240 1 0 $X=877890 $Y=751685
X3634 1 2 2260 2274 2251 2287 ICV_84 $T=912480 881680 0 0 $X=912050 $Y=881290
X3635 1 2 2369 2383 2387 2378 ICV_84 $T=925920 842480 0 0 $X=925490 $Y=842090
X3636 1 2 2478 2279 2499 2501 ICV_84 $T=943280 850320 1 0 $X=942850 $Y=845765
X3637 1 2 2508 2483 2520 2517 ICV_84 $T=949440 779760 1 0 $X=949010 $Y=775205
X3638 1 2 2516 2518 2524 2481 ICV_84 $T=950560 818960 1 0 $X=950130 $Y=814405
X3639 1 2 569 556 3 ICV_60 $T=603920 928720 0 180 $X=600690 $Y=924165
X3640 1 2 570 563 23 ICV_60 $T=603920 928720 1 180 $X=600690 $Y=928330
X3641 1 2 652 646 525 ICV_60 $T=612880 850320 1 180 $X=609650 $Y=849930
X3642 1 2 30 739 689 ICV_60 $T=620720 779760 0 180 $X=617490 $Y=775205
X3643 1 2 754 749 538 ICV_60 $T=621280 881680 0 180 $X=618050 $Y=877125
X3644 1 2 63 750 587 ICV_60 $T=621280 905200 1 180 $X=618050 $Y=904810
X3645 1 2 760 698 52 ICV_60 $T=621840 795440 1 180 $X=618610 $Y=795050
X3646 1 2 788 725 28 ICV_60 $T=624640 850320 0 180 $X=621410 $Y=845765
X3647 1 2 76 447 38 ICV_60 $T=625760 905200 1 180 $X=622530 $Y=904810
X3648 1 2 808 790 719 ICV_60 $T=626880 771920 0 180 $X=623650 $Y=767365
X3649 1 2 901 873 587 ICV_60 $T=636400 771920 0 180 $X=633170 $Y=767365
X3650 1 2 906 438 812 ICV_60 $T=636960 842480 1 180 $X=633730 $Y=842090
X3651 1 2 961 954 4 ICV_60 $T=641440 842480 1 180 $X=638210 $Y=842090
X3652 1 2 985 990 48 ICV_60 $T=644240 771920 1 180 $X=641010 $Y=771530
X3653 1 2 952 1013 878 ICV_60 $T=646480 748400 1 180 $X=643250 $Y=748010
X3654 1 2 123 905 122 ICV_60 $T=647600 803280 1 180 $X=644370 $Y=802890
X3655 1 2 30 1052 901 ICV_60 $T=650400 787600 0 180 $X=647170 $Y=783045
X3656 1 2 1066 132 1026 ICV_60 $T=651520 724880 1 180 $X=648290 $Y=724490
X3657 1 2 1011 1088 30 ICV_60 $T=653760 771920 1 180 $X=650530 $Y=771530
X3658 1 2 870 1106 17 ICV_60 $T=656000 873840 1 180 $X=652770 $Y=873450
X3659 1 2 32 1122 12 ICV_60 $T=657120 936560 1 180 $X=653890 $Y=936170
X3660 1 2 147 1130 67 ICV_60 $T=657680 913040 1 180 $X=654450 $Y=912650
X3661 1 2 1154 1133 12 ICV_60 $T=659360 818960 0 180 $X=656130 $Y=814405
X3662 1 2 157 1000 67 ICV_60 $T=662160 944400 0 180 $X=658930 $Y=939845
X3663 1 2 1186 1180 3 ICV_60 $T=662720 771920 1 180 $X=659490 $Y=771530
X3664 1 2 1216 1214 1198 ICV_60 $T=666640 873840 1 180 $X=663410 $Y=873450
X3665 1 2 1262 1216 587 ICV_60 $T=671120 873840 1 180 $X=667890 $Y=873450
X3666 1 2 1265 1220 3 ICV_60 $T=671680 748400 0 180 $X=668450 $Y=743845
X3667 1 2 1270 32 176 ICV_60 $T=671680 944400 1 180 $X=668450 $Y=944010
X3668 1 2 1278 1075 178 ICV_60 $T=672800 811120 1 180 $X=669570 $Y=810730
X3669 1 2 1300 1231 538 ICV_60 $T=675040 881680 0 180 $X=671810 $Y=877125
X3670 1 2 1306 126 1295 ICV_60 $T=675600 905200 1 180 $X=672370 $Y=904810
X3671 1 2 1309 1301 50 ICV_60 $T=676160 748400 0 180 $X=672930 $Y=743845
X3672 1 2 1285 1318 525 ICV_60 $T=677280 866000 0 180 $X=674050 $Y=861445
X3673 1 2 1346 688 1337 ICV_60 $T=680080 818960 0 180 $X=676850 $Y=814405
X3674 1 2 1384 886 1330 ICV_60 $T=684000 834640 1 180 $X=680770 $Y=834250
X3675 1 2 49 1389 8 ICV_60 $T=684560 936560 1 180 $X=681330 $Y=936170
X3676 1 2 152 1385 1124 ICV_60 $T=685120 850320 0 180 $X=681890 $Y=845765
X3677 1 2 201 1253 199 ICV_60 $T=688480 818960 1 180 $X=685250 $Y=818570
X3678 1 2 1425 602 1356 ICV_60 $T=689040 905200 1 180 $X=685810 $Y=904810
X3679 1 2 1434 1422 1420 ICV_60 $T=689600 842480 1 180 $X=686370 $Y=842090
X3680 1 2 1497 1372 1312 ICV_60 $T=699680 795440 1 180 $X=696450 $Y=795050
X3681 1 2 42 1496 1245 ICV_60 $T=700240 771920 0 180 $X=697010 $Y=767365
X3682 1 2 182 1045 1452 ICV_60 $T=700240 779760 0 180 $X=697010 $Y=775205
X3683 1 2 1501 1495 3 ICV_60 $T=700240 889520 0 180 $X=697010 $Y=884965
X3684 1 2 1493 148 1472 ICV_60 $T=704160 787600 0 180 $X=700930 $Y=783045
X3685 1 2 1520 104 1486 ICV_60 $T=705280 818960 0 180 $X=702050 $Y=814405
X3686 1 2 1520 122 1428 ICV_60 $T=705840 811120 1 180 $X=702610 $Y=810730
X3687 1 2 182 1437 1514 ICV_60 $T=706400 803280 1 180 $X=703170 $Y=802890
X3688 1 2 1501 1536 50 ICV_60 $T=709200 889520 0 180 $X=705970 $Y=884965
X3689 1 2 1521 1539 223 ICV_60 $T=709760 889520 1 180 $X=706530 $Y=889130
X3690 1 2 7 1603 1020 ICV_60 $T=720960 803280 1 180 $X=717730 $Y=802890
X3691 1 2 49 1604 1203 ICV_60 $T=720960 826800 1 180 $X=717730 $Y=826410
X3692 1 2 1925 334 1873 ICV_60 $T=852560 944400 0 180 $X=849330 $Y=939845
X3693 1 2 2019 2010 1995 ICV_60 $T=873280 834640 0 180 $X=870050 $Y=830085
X3694 1 2 2108 2098 2086 ICV_60 $T=888400 866000 1 180 $X=885170 $Y=865610
X3695 1 2 2019 2153 2043 ICV_60 $T=897920 818960 0 180 $X=894690 $Y=814405
X3696 1 2 2300 2264 88 ICV_60 $T=922000 944400 0 180 $X=918770 $Y=939845
X3697 1 2 2424 2401 2302 ICV_60 $T=940480 740560 0 180 $X=937250 $Y=736005
X3698 1 2 2454 2451 2429 ICV_60 $T=942720 803280 1 180 $X=939490 $Y=802890
X3699 1 2 2469 2327 2305 ICV_60 $T=944960 764080 1 180 $X=941730 $Y=763690
X3700 1 2 2471 2477 2470 ICV_60 $T=946640 834640 1 180 $X=943410 $Y=834250
X3701 1 2 572 566 3 ICV_89 $T=604480 811120 0 180 $X=601250 $Y=806565
X3702 1 2 722 666 545 ICV_89 $T=618480 842480 1 180 $X=615250 $Y=842090
X3703 1 2 63 756 538 ICV_89 $T=622400 905200 0 180 $X=619170 $Y=900645
X3704 1 2 770 765 545 ICV_89 $T=622960 787600 1 180 $X=619730 $Y=787210
X3705 1 2 795 782 783 ICV_89 $T=625200 858160 0 180 $X=621970 $Y=853605
X3706 1 2 822 815 38 ICV_89 $T=628000 889520 1 180 $X=624770 $Y=889130
X3707 1 2 820 825 70 ICV_89 $T=629120 850320 0 180 $X=625890 $Y=845765
X3708 1 2 837 830 719 ICV_89 $T=629680 779760 0 180 $X=626450 $Y=775205
X3709 1 2 821 831 50 ICV_89 $T=631920 858160 1 180 $X=628690 $Y=857770
X3710 1 2 869 845 48 ICV_89 $T=633040 850320 1 180 $X=629810 $Y=849930
X3711 1 2 90 863 538 ICV_89 $T=633040 897360 1 180 $X=629810 $Y=896970
X3712 1 2 94 872 538 ICV_89 $T=635280 928720 1 180 $X=632050 $Y=928330
X3713 1 2 896 893 719 ICV_89 $T=635840 881680 1 180 $X=632610 $Y=881290
X3714 1 2 101 897 719 ICV_89 $T=636960 897360 0 180 $X=633730 $Y=892805
X3715 1 2 105 919 663 ICV_89 $T=638640 928720 0 180 $X=635410 $Y=924165
X3716 1 2 780 933 70 ICV_89 $T=639760 834640 0 180 $X=636530 $Y=830085
X3717 1 2 738 997 822 ICV_89 $T=644800 889520 0 180 $X=641570 $Y=884965
X3718 1 2 819 1012 37 ICV_89 $T=646480 787600 0 180 $X=643250 $Y=783045
X3719 1 2 120 913 587 ICV_89 $T=646480 881680 0 180 $X=643250 $Y=877125
X3720 1 2 1032 916 12 ICV_89 $T=648160 834640 1 180 $X=644930 $Y=834250
X3721 1 2 1064 1058 998 ICV_89 $T=650960 897360 0 180 $X=647730 $Y=892805
X3722 1 2 850 1072 38 ICV_89 $T=652080 811120 1 180 $X=648850 $Y=810730
X3723 1 2 1076 960 67 ICV_89 $T=652080 834640 1 180 $X=648850 $Y=834250
X3724 1 2 1081 812 67 ICV_89 $T=652640 834640 0 180 $X=649410 $Y=830085
X3725 1 2 1101 819 139 ICV_89 $T=654880 787600 0 180 $X=651650 $Y=783045
X3726 1 2 888 1149 38 ICV_89 $T=659360 850320 0 180 $X=656130 $Y=845765
X3727 1 2 1152 1182 43 ICV_89 $T=662720 873840 0 180 $X=659490 $Y=869285
X3728 1 2 1268 1083 1249 ICV_89 $T=671680 905200 1 180 $X=668450 $Y=904810
X3729 1 2 1448 1440 50 ICV_89 $T=690720 756240 0 180 $X=687490 $Y=751685
X3730 1 2 1453 942 1417 ICV_89 $T=691840 803280 0 180 $X=688610 $Y=798725
X3731 1 2 1298 839 1395 ICV_89 $T=692960 818960 1 180 $X=689730 $Y=818570
X3732 1 2 1463 1441 50 ICV_89 $T=693520 850320 1 180 $X=690290 $Y=849930
X3733 1 2 182 1465 199 ICV_89 $T=696880 818960 1 180 $X=693650 $Y=818570
X3734 1 2 182 219 1483 ICV_89 $T=698000 944400 0 180 $X=694770 $Y=939845
X3735 1 2 182 1348 217 ICV_89 $T=699120 928720 1 180 $X=695890 $Y=928330
X3736 1 2 182 1417 1482 ICV_89 $T=699680 779760 1 180 $X=696450 $Y=779370
X3737 1 2 1364 1244 1485 ICV_89 $T=699680 803280 0 180 $X=696450 $Y=798725
X3738 1 2 1502 1543 225 ICV_89 $T=710320 920880 0 180 $X=707090 $Y=916325
X3739 1 2 1750 1747 1755 ICV_89 $T=830720 897360 1 180 $X=827490 $Y=896970
X3740 1 2 2024 2015 2009 ICV_89 $T=873840 842480 0 180 $X=870610 $Y=837925
X3741 1 2 2115 2065 2110 ICV_89 $T=889520 858160 0 180 $X=886290 $Y=853605
X3742 1 2 2138 2101 2133 ICV_89 $T=894000 905200 1 180 $X=890770 $Y=904810
X3743 1 2 2217 2201 2125 ICV_89 $T=906880 913040 0 180 $X=903650 $Y=908485
X3744 1 2 2226 2074 2210 ICV_89 $T=909120 897360 1 180 $X=905890 $Y=896970
X3745 1 2 2256 2290 2133 ICV_89 $T=920320 889520 1 180 $X=917090 $Y=889130
X3746 1 2 2200 2294 2208 ICV_89 $T=920880 803280 1 180 $X=917650 $Y=802890
X3747 1 2 2270 2309 2105 ICV_89 $T=924240 897360 1 180 $X=921010 $Y=896970
X3748 1 2 2377 2367 2371 ICV_89 $T=931520 826800 0 180 $X=928290 $Y=822245
X3749 1 2 2475 2471 2377 ICV_89 $T=945520 826800 1 180 $X=942290 $Y=826410
X3750 1 2 2486 2485 2361 ICV_89 $T=948320 756240 0 180 $X=945090 $Y=751685
X3751 1 2 591 535 581 ICV_81 $T=605600 881680 1 180 $X=602370 $Y=881290
X3752 1 2 801 778 796 ICV_81 $T=625760 881680 1 180 $X=622530 $Y=881290
X3753 1 2 813 484 791 ICV_81 $T=626880 873840 1 180 $X=623650 $Y=873450
X3754 1 2 937 921 793 ICV_81 $T=639760 732720 0 180 $X=636530 $Y=728165
X3755 1 2 1023 738 936 ICV_81 $T=648720 889520 0 180 $X=645490 $Y=884965
X3756 1 2 1284 1260 1279 ICV_81 $T=673360 850320 1 180 $X=670130 $Y=849930
X3757 1 2 1344 824 1343 ICV_81 $T=680080 842480 0 180 $X=676850 $Y=837925
X3758 1 2 1800 1801 1803 ICV_81 $T=831280 889520 1 180 $X=828050 $Y=889130
X3759 1 2 290 319 1709 ICV_81 $T=833520 748400 1 180 $X=830290 $Y=748010
X3760 1 2 2133 1996 2130 ICV_81 $T=892880 920880 1 180 $X=889650 $Y=920490
X3761 1 2 2172 2156 2170 ICV_81 $T=900160 889520 1 180 $X=896930 $Y=889130
X3762 1 2 2244 2226 2211 ICV_81 $T=911360 905200 1 180 $X=908130 $Y=904810
X3763 1 2 2294 2280 2285 ICV_81 $T=920880 811120 0 180 $X=917650 $Y=806565
X3764 1 2 2142 2247 2243 ICV_81 $T=924240 889520 0 180 $X=921010 $Y=884965
X3765 1 2 2318 2258 2233 ICV_81 $T=925920 811120 0 180 $X=922690 $Y=806565
X3766 1 2 372 2276 2523 ICV_81 $T=957840 764080 1 180 $X=954610 $Y=763690
X3767 1 2 560 604 525 569 567 587 ICV_110 $T=605600 873840 0 0 $X=605170 $Y=873450
X3768 1 2 878 770 891 48 891 937 ICV_110 $T=632480 771920 0 0 $X=632050 $Y=771530
X3769 1 2 730 910 38 1020 974 67 ICV_110 $T=640880 834640 1 0 $X=640450 $Y=830085
X3770 1 2 1032 1069 67 28 1121 19 ICV_110 $T=649280 858160 0 0 $X=648850 $Y=857770
X3771 1 2 167 181 1314 186 159 1314 ICV_110 $T=673360 944400 0 0 $X=672930 $Y=944010
X3772 1 2 1346 79 1395 1411 1005 1428 ICV_110 $T=681760 818960 1 0 $X=681330 $Y=814405
X3773 1 2 163 1388 1203 182 1337 1429 ICV_110 $T=681760 826800 0 0 $X=681330 $Y=826410
X3774 1 2 201 1403 204 201 1365 209 ICV_110 $T=686240 920880 0 0 $X=685810 $Y=920490
X3775 1 2 1414 69 1417 1414 1350 1465 ICV_110 $T=687920 795440 0 0 $X=687490 $Y=795050
X3776 1 2 1449 674 1457 1453 1321 1407 ICV_110 $T=689040 811120 0 0 $X=688610 $Y=810730
X3777 1 2 201 1229 233 182 1439 233 ICV_110 $T=699680 850320 0 0 $X=699250 $Y=849930
X3778 1 2 201 1268 229 201 1270 224 ICV_110 $T=701360 905200 1 0 $X=700930 $Y=900645
X3779 1 2 201 1286 1508 48 1533 243 ICV_110 $T=701360 913040 1 0 $X=700930 $Y=908485
X3780 1 2 201 1453 1546 201 1414 1575 ICV_110 $T=707520 811120 0 0 $X=707090 $Y=810730
X3781 1 2 2018 2078 1994 1967 2103 1971 ICV_110 $T=881120 818960 0 0 $X=880690 $Y=818570
X3782 1 2 2024 2137 2082 2032 2165 2137 ICV_110 $T=891760 858160 0 0 $X=891330 $Y=857770
X3783 1 2 622 586 466 ICV_99 $T=606160 764080 0 0 $X=605730 $Y=763690
X3784 1 2 626 523 501 ICV_99 $T=606160 866000 1 0 $X=605730 $Y=861445
X3785 1 2 632 629 443 ICV_99 $T=606720 803280 0 0 $X=606290 $Y=802890
X3786 1 2 785 806 783 ICV_99 $T=623520 928720 0 0 $X=623090 $Y=928330
X3787 1 2 821 668 70 ICV_99 $T=624640 858160 0 0 $X=624210 $Y=857770
X3788 1 2 690 843 23 ICV_99 $T=627440 826800 1 0 $X=627010 $Y=822245
X3789 1 2 883 439 53 ICV_99 $T=631360 905200 0 0 $X=630930 $Y=904810
X3790 1 2 885 880 466 ICV_99 $T=631920 795440 0 0 $X=631490 $Y=795050
X3791 1 2 888 882 28 ICV_99 $T=631920 858160 1 0 $X=631490 $Y=853605
X3792 1 2 1007 1004 501 ICV_99 $T=642000 795440 1 0 $X=641570 $Y=790885
X3793 1 2 989 1008 545 ICV_99 $T=642560 920880 0 0 $X=642130 $Y=920490
X3794 1 2 1071 1024 67 ICV_99 $T=648160 920880 1 0 $X=647730 $Y=916325
X3795 1 2 1078 1042 663 ICV_99 $T=648720 920880 0 0 $X=648290 $Y=920490
X3796 1 2 153 623 1046 ICV_99 $T=656560 803280 0 0 $X=656130 $Y=802890
X3797 1 2 1184 1183 1070 ICV_99 $T=659360 905200 0 0 $X=658930 $Y=904810
X3798 1 2 1189 161 1162 ICV_99 $T=660480 834640 0 0 $X=660050 $Y=834250
X3799 1 2 154 175 1151 ICV_99 $T=667200 913040 1 0 $X=666770 $Y=908485
X3800 1 2 7 1315 861 ICV_99 $T=673920 787600 1 0 $X=673490 $Y=783045
X3801 1 2 1406 1382 30 ICV_99 $T=682880 889520 1 0 $X=682450 $Y=884965
X3802 1 2 1412 1195 1348 ICV_99 $T=684000 928720 0 0 $X=683570 $Y=928330
X3803 1 2 1451 162 202 ICV_99 $T=687920 944400 0 0 $X=687490 $Y=944010
X3804 1 2 1456 86 1217 ICV_99 $T=688480 936560 1 0 $X=688050 $Y=932005
X3805 1 2 1484 811 1465 ICV_99 $T=692400 811120 1 0 $X=691970 $Y=806565
X3806 1 2 201 227 226 ICV_99 $T=698000 944400 0 0 $X=697570 $Y=944010
X3807 1 2 182 1486 213 ICV_99 $T=698560 787600 0 0 $X=698130 $Y=787210
X3808 1 2 182 1410 1507 ICV_99 $T=699120 795440 1 0 $X=698690 $Y=790885
X3809 1 2 241 1509 239 ICV_99 $T=702480 873840 0 0 $X=702050 $Y=873450
X3810 1 2 1879 1876 1778 ICV_99 $T=840240 905200 0 0 $X=839810 $Y=904810
X3811 1 2 1945 1944 1861 ICV_99 $T=853680 811120 1 0 $X=853250 $Y=806565
X3812 1 2 1974 1973 1891 ICV_99 $T=859840 803280 0 0 $X=859410 $Y=802890
X3813 1 2 2145 2214 1967 ICV_99 $T=904080 818960 0 0 $X=903650 $Y=818570
X3814 1 2 2426 2438 2385 ICV_99 $T=937120 842480 0 0 $X=936690 $Y=842090
X3815 1 2 615 639 642 ICV_104 $T=606720 756240 0 0 $X=606290 $Y=755850
X3816 1 2 629 716 718 ICV_104 $T=614000 803280 1 0 $X=613570 $Y=798725
X3817 1 2 755 789 501 ICV_104 $T=621280 897360 0 0 $X=620850 $Y=896970
X3818 1 2 517 733 80 ICV_104 $T=623520 889520 1 0 $X=623090 $Y=884965
X3819 1 2 774 816 91 ICV_104 $T=629120 936560 1 0 $X=628690 $Y=932005
X3820 1 2 710 877 106 ICV_104 $T=634720 944400 0 0 $X=634290 $Y=944010
X3821 1 2 917 817 6 ICV_104 $T=635280 858160 1 0 $X=634850 $Y=853605
X3822 1 2 922 900 53 ICV_104 $T=635840 811120 1 0 $X=635410 $Y=806565
X3823 1 2 41 975 28 ICV_104 $T=639760 928720 0 0 $X=639330 $Y=928330
X3824 1 2 970 1049 783 ICV_104 $T=646480 818960 1 0 $X=646050 $Y=814405
X3825 1 2 12 146 1071 ICV_104 $T=653760 944400 0 0 $X=653330 $Y=944010
X3826 1 2 1193 1091 926 ICV_104 $T=660480 764080 0 0 $X=660050 $Y=763690
X3827 1 2 123 1215 696 ICV_104 $T=662720 913040 0 0 $X=662290 $Y=912650
X3828 1 2 154 1275 1211 ICV_104 $T=669440 764080 1 0 $X=669010 $Y=759525
X3829 1 2 154 183 1117 ICV_104 $T=673920 928720 1 0 $X=673490 $Y=924165
X3830 1 2 1324 1355 3 ICV_104 $T=677280 756240 0 0 $X=676850 $Y=755850
X3831 1 2 1363 879 1369 ICV_104 $T=678960 795440 0 0 $X=678530 $Y=795050
X3832 1 2 1412 36 202 ICV_104 $T=684560 936560 1 0 $X=684130 $Y=932005
X3833 1 2 1519 119 1534 ICV_104 $T=704720 866000 1 0 $X=704290 $Y=861445
X3834 1 2 1521 1574 216 ICV_104 $T=710880 897360 1 0 $X=710450 $Y=892805
X3835 1 2 1502 1588 1429 ICV_104 $T=717600 881680 0 0 $X=717170 $Y=881290
X3836 1 2 286 1698 288 ICV_104 $T=796560 724880 0 0 $X=796130 $Y=724490
X3837 1 2 1790 1864 1863 ICV_104 $T=836880 928720 1 0 $X=836450 $Y=924165
X3838 1 2 1842 1884 1742 ICV_104 $T=840800 905200 1 0 $X=840370 $Y=900645
X3839 1 2 1886 1941 1737 ICV_104 $T=853680 913040 0 0 $X=853250 $Y=912650
X3840 1 2 2091 2132 2082 ICV_104 $T=890640 866000 1 0 $X=890210 $Y=861445
X3841 1 2 359 2196 2199 ICV_104 $T=901280 944400 1 0 $X=900850 $Y=939845
X3842 1 2 379 2397 2305 ICV_104 $T=930400 740560 0 0 $X=929970 $Y=740170
X3843 1 2 2361 383 372 ICV_104 $T=930400 756240 0 0 $X=929970 $Y=755850
X3844 1 2 653 636 618 619 ICV_103 $T=611760 905200 1 180 $X=607410 $Y=904810
X3845 1 2 679 666 652 630 ICV_103 $T=614000 842480 1 180 $X=609650 $Y=842090
X3846 1 2 705 707 595 545 ICV_103 $T=618480 787600 1 180 $X=614130 $Y=787210
X3847 1 2 733 714 600 700 ICV_103 $T=619040 889520 1 180 $X=614690 $Y=889130
X3848 1 2 786 767 764 466 ICV_103 $T=624640 764080 0 180 $X=620290 $Y=759525
X3849 1 2 819 48 809 545 ICV_103 $T=628000 787600 0 180 $X=623650 $Y=783045
X3850 1 2 875 873 860 830 ICV_103 $T=634720 764080 0 180 $X=630370 $Y=759525
X3851 1 2 946 894 918 719 ICV_103 $T=640320 889520 0 180 $X=635970 $Y=884965
X3852 1 2 1141 1129 1118 4 ICV_103 $T=658240 787600 1 180 $X=653890 $Y=787210
X3853 1 2 1397 1382 1376 1145 ICV_103 $T=685120 881680 1 180 $X=680770 $Y=881290
X3854 1 2 303 1730 1726 295 ICV_103 $T=811680 740560 0 180 $X=807330 $Y=736005
X3855 1 2 1790 1743 1786 1765 ICV_103 $T=829040 928720 0 180 $X=824690 $Y=924165
X3856 1 2 2112 2099 2094 1722 ICV_103 $T=888960 913040 0 180 $X=884610 $Y=908485
X3857 1 2 2195 2160 2111 2175 ICV_103 $T=904640 897360 1 180 $X=900290 $Y=896970
X3858 1 2 2267 2252 2221 1770 ICV_103 $T=916960 897360 0 180 $X=912610 $Y=892805
X3859 1 2 2272 2259 2245 2258 ICV_103 $T=918640 803280 0 180 $X=914290 $Y=798725
X3860 1 2 2421 2365 2372 2233 ICV_103 $T=937120 834640 1 180 $X=932770 $Y=834250
X3861 1 2 42 633 680 ICV_86 $T=609520 811120 1 0 $X=609090 $Y=806565
X3862 1 2 668 467 681 ICV_86 $T=609520 866000 1 0 $X=609090 $Y=861445
X3863 1 2 582 619 538 ICV_86 $T=610080 905200 1 0 $X=609650 $Y=900645
X3864 1 2 774 785 792 ICV_86 $T=620160 936560 1 0 $X=619730 $Y=932005
X3865 1 2 69 711 48 ICV_86 $T=621280 795440 1 0 $X=620850 $Y=790885
X3866 1 2 972 748 12 ICV_86 $T=639200 866000 0 0 $X=638770 $Y=865610
X3867 1 2 907 993 972 ICV_86 $T=639760 811120 1 0 $X=639330 $Y=806565
X3868 1 2 497 1132 142 ICV_86 $T=654320 764080 1 0 $X=653890 $Y=759525
X3869 1 2 155 1136 963 ICV_86 $T=659360 897360 0 0 $X=658930 $Y=896970
X3870 1 2 188 1060 1360 ICV_86 $T=676720 913040 0 0 $X=676290 $Y=912650
X3871 1 2 201 1255 1445 ICV_86 $T=685680 913040 0 0 $X=685250 $Y=912650
X3872 1 2 201 1456 234 ICV_86 $T=700800 936560 1 0 $X=700370 $Y=932005
X3873 1 2 309 1771 306 ICV_86 $T=821200 748400 1 0 $X=820770 $Y=743845
X3874 1 2 2019 2044 2038 ICV_86 $T=874960 850320 0 0 $X=874530 $Y=849930
X3875 1 2 1993 2054 2012 ICV_86 $T=878320 842480 1 0 $X=877890 $Y=837925
X3876 1 2 2416 2417 2429 ICV_86 $T=934320 803280 0 0 $X=933890 $Y=802890
X3877 1 2 2250 2505 370 ICV_86 $T=948320 740560 0 0 $X=947890 $Y=740170
X3878 1 2 572 656 587 ICV_101 $T=610640 818960 1 0 $X=610210 $Y=814405
X3879 1 2 729 709 538 ICV_101 $T=614560 764080 1 0 $X=614130 $Y=759525
X3880 1 2 732 752 28 ICV_101 $T=616800 866000 1 0 $X=616370 $Y=861445
X3881 1 2 102 854 587 ICV_101 $T=632480 920880 0 0 $X=632050 $Y=920490
X3882 1 2 517 947 108 ICV_101 $T=636400 936560 1 0 $X=635970 $Y=932005
X3883 1 2 889 1073 1029 ICV_101 $T=647600 866000 1 0 $X=647170 $Y=861445
X3884 1 2 7 168 147 ICV_101 $T=662720 944400 0 0 $X=662290 $Y=944010
X3885 1 2 1255 1151 1249 ICV_101 $T=666640 913040 0 0 $X=666210 $Y=912650
X3886 1 2 155 1287 86 ICV_101 $T=670000 897360 1 0 $X=669570 $Y=892805
X3887 1 2 155 1293 674 ICV_101 $T=670560 803280 1 0 $X=670130 $Y=798725
X3888 1 2 1315 1302 1288 ICV_101 $T=672240 779760 0 0 $X=671810 $Y=779370
X3889 1 2 1784 1863 1776 ICV_101 $T=836320 913040 0 0 $X=835890 $Y=912650
X3890 1 2 1906 1949 1868 ICV_101 $T=853120 897360 1 0 $X=852690 $Y=892805
X3891 1 2 2033 2032 1804 ICV_101 $T=872160 866000 0 0 $X=871730 $Y=865610
X3892 1 2 2044 2186 2162 ICV_101 $T=899040 850320 0 0 $X=898610 $Y=849930
X3893 1 2 387 2435 2349 ICV_101 $T=936000 764080 0 0 $X=935570 $Y=763690
X3894 1 2 731 532 545 ICV_95 $T=619600 818960 0 180 $X=616370 $Y=814405
X3895 1 2 895 892 23 ICV_95 $T=635840 779760 1 180 $X=632610 $Y=779370
X3896 1 2 738 1019 122 ICV_95 $T=648160 811120 0 180 $X=644930 $Y=806565
X3897 1 2 977 976 38 ICV_95 $T=648720 826800 0 180 $X=645490 $Y=822245
X3898 1 2 123 612 909 ICV_95 $T=652080 913040 1 180 $X=648850 $Y=912650
X3899 1 2 182 1204 244 ICV_95 $T=711440 842480 0 180 $X=708210 $Y=837925
X3900 1 2 182 1428 1549 ICV_95 $T=715360 803280 1 180 $X=712130 $Y=802890
X3901 1 2 154 1589 1350 ICV_95 $T=718720 795440 1 180 $X=715490 $Y=795050
X3902 1 2 154 1596 1345 ICV_95 $T=719840 771920 0 180 $X=716610 $Y=767365
X3903 1 2 49 1606 104 ICV_95 $T=720960 818960 0 180 $X=717730 $Y=814405
X3904 1 2 1745 1743 1739 ICV_95 $T=817280 920880 1 180 $X=814050 $Y=920490
X3905 1 2 1875 1908 1780 ICV_95 $T=849760 928720 0 180 $X=846530 $Y=924165
X3906 1 2 2129 2090 2070 ICV_95 $T=892320 818960 0 180 $X=889090 $Y=814405
X3907 1 2 2264 366 2239 ICV_95 $T=916400 944400 0 180 $X=913170 $Y=939845
X3908 1 2 2398 2319 2377 ICV_95 $T=933760 787600 0 180 $X=930530 $Y=783045
X3909 1 2 2451 2439 2208 ICV_95 $T=942720 779760 1 180 $X=939490 $Y=779370
X3910 1 2 741 632 719 ICV_79 $T=619040 803280 0 0 $X=618610 $Y=802890
X3911 1 2 820 520 50 ICV_79 $T=624080 834640 0 0 $X=623650 $Y=834250
X3912 1 2 98 858 719 ICV_79 $T=632480 889520 0 0 $X=632050 $Y=889130
X3913 1 2 988 129 6 ICV_79 $T=646480 826800 0 0 $X=646050 $Y=826410
X3914 1 2 907 1068 110 ICV_79 $T=648160 850320 0 0 $X=647730 $Y=849930
X3915 1 2 1082 1077 783 ICV_79 $T=648720 858160 1 0 $X=648290 $Y=853605
X3916 1 2 939 1100 23 ICV_79 $T=652640 764080 0 0 $X=652210 $Y=763690
X3917 1 2 1157 1176 587 ICV_79 $T=658240 905200 1 0 $X=657810 $Y=900645
X3918 1 2 1259 1323 30 ICV_79 $T=673920 764080 0 0 $X=673490 $Y=763690
X3919 1 2 1425 74 1408 ICV_79 $T=687920 913040 1 0 $X=687490 $Y=908485
X3920 1 2 153 1345 1410 ICV_79 $T=701920 787600 0 0 $X=701490 $Y=787210
X3921 1 2 1570 1560 1566 ICV_79 $T=710880 944400 1 0 $X=710450 $Y=939845
X3922 1 2 154 1586 932 ICV_79 $T=714240 787600 0 0 $X=713810 $Y=787210
X3923 1 2 1502 1591 226 ICV_79 $T=714800 913040 0 0 $X=714370 $Y=912650
X3924 1 2 1744 1739 1684 ICV_79 $T=813360 920880 1 0 $X=812930 $Y=916325
X3925 1 2 1860 1857 160 ICV_79 $T=836320 803280 0 0 $X=835890 $Y=802890
X3926 1 2 330 1880 1781 ICV_79 $T=840800 724880 0 0 $X=840370 $Y=724490
X3927 1 2 2148 2163 2053 ICV_79 $T=895120 873840 1 0 $X=894690 $Y=869285
X3928 1 2 361 2199 160 ICV_79 $T=901280 944400 0 0 $X=900850 $Y=944010
X3929 1 2 2172 2296 2275 ICV_79 $T=918080 913040 1 0 $X=917650 $Y=908485
X3930 1 2 2380 2406 2270 ICV_79 $T=930960 897360 0 0 $X=930530 $Y=896970
X3931 1 2 2413 2368 2396 ICV_79 $T=931520 842480 1 0 $X=931090 $Y=837925
X3932 1 2 2533 2409 2523 ICV_79 $T=957840 764080 1 0 $X=957410 $Y=759525
X3933 1 2 829 818 763 461 ICV_82 $T=622400 756240 0 0 $X=621970 $Y=755850
X3934 1 2 1635 1637 1463 1611 ICV_82 $T=721520 866000 0 0 $X=721090 $Y=865610
X3935 1 2 1757 1754 315 314 ICV_82 $T=815600 748400 0 0 $X=815170 $Y=748010
X3936 1 2 1776 1762 1829 1800 ICV_82 $T=829600 913040 0 0 $X=829170 $Y=912650
X3937 1 2 1817 1733 1830 1765 ICV_82 $T=829600 920880 0 0 $X=829170 $Y=920490
X3938 1 2 1787 1776 1878 1762 ICV_82 $T=838000 873840 0 0 $X=837570 $Y=873450
X3939 1 2 1948 1764 1935 1915 ICV_82 $T=850320 936560 1 0 $X=849890 $Y=932005
X3940 1 2 2017 2011 2007 1923 ICV_82 $T=867120 811120 1 0 $X=866690 $Y=806565
X3941 1 2 2022 2012 2014 1804 ICV_82 $T=867120 818960 0 0 $X=866690 $Y=818570
X3942 1 2 2047 1967 2023 2012 ICV_82 $T=873840 826800 1 0 $X=873410 $Y=822245
X3943 1 2 2061 2035 1977 2043 ICV_82 $T=875520 834640 0 0 $X=875090 $Y=834250
X3944 1 2 2069 2055 2056 2031 ICV_82 $T=876080 771920 0 0 $X=875650 $Y=771530
X3945 1 2 351 2075 2076 2020 ICV_82 $T=878320 724880 0 0 $X=877890 $Y=724490
X3946 1 2 2102 2052 2089 1919 ICV_82 $T=881680 795440 0 0 $X=881250 $Y=795050
X3947 1 2 2122 1984 2118 2010 ICV_82 $T=884480 834640 1 0 $X=884050 $Y=830085
X3948 1 2 2168 2161 2155 2008 ICV_82 $T=892880 779760 1 0 $X=892450 $Y=775205
X3949 1 2 2188 2201 2207 2144 ICV_82 $T=900160 889520 1 0 $X=899730 $Y=884965
X3950 1 2 2293 2279 2266 2269 ICV_82 $T=913600 779760 0 0 $X=913170 $Y=779370
X3951 1 2 2402 383 382 373 ICV_82 $T=927600 724880 0 0 $X=927170 $Y=724490
X3952 1 2 2406 2310 2399 2306 ICV_82 $T=928160 905200 1 0 $X=927730 $Y=900645
X3953 1 2 2422 2433 2428 2408 ICV_82 $T=934320 936560 0 0 $X=933890 $Y=936170
X3954 1 2 2401 387 2503 2462 ICV_82 $T=948320 740560 1 0 $X=947890 $Y=736005
X3955 1 2 2409 2530 2495 2482 ICV_82 $T=953360 771920 0 0 $X=952930 $Y=771530
X3956 1 2 784 796 745 ICV_109 $T=622400 897360 1 0 $X=621970 $Y=892805
X3957 1 2 501 862 50 ICV_109 $T=629680 866000 0 0 $X=629250 $Y=865610
X3958 1 2 663 48 876 ICV_109 $T=632480 811120 0 0 $X=632050 $Y=810730
X3959 1 2 48 840 907 ICV_109 $T=634720 873840 1 0 $X=634290 $Y=869285
X3960 1 2 501 1002 114 ICV_109 $T=642000 881680 0 0 $X=641570 $Y=881290
X3961 1 2 1033 1043 992 ICV_109 $T=646480 936560 1 0 $X=646050 $Y=932005
X3962 1 2 52 127 1033 ICV_109 $T=646480 944400 1 0 $X=646050 $Y=939845
X3963 1 2 548 1083 1043 ICV_109 $T=649840 905200 0 0 $X=649410 $Y=904810
X3964 1 2 548 1060 1003 ICV_109 $T=650960 905200 1 0 $X=650530 $Y=900645
X3965 1 2 1167 1095 1178 ICV_109 $T=659920 764080 1 0 $X=659490 $Y=759525
X3966 1 2 185 1342 1347 ICV_109 $T=677840 936560 0 0 $X=677410 $Y=936170
X3967 1 2 1250 1349 1339 ICV_109 $T=678400 779760 0 0 $X=677970 $Y=779370
X3968 1 2 201 48 1521 ICV_109 $T=702480 881680 0 0 $X=702050 $Y=881290
X3969 1 2 1742 1747 1746 ICV_109 $T=815040 889520 0 0 $X=814610 $Y=889130
X3970 1 2 306 295 289 ICV_109 $T=816720 732720 1 0 $X=816290 $Y=728165
X3971 1 2 314 294 303 ICV_109 $T=818400 740560 1 0 $X=817970 $Y=736005
X3972 1 2 1812 1790 1847 ICV_109 $T=835200 928720 0 0 $X=834770 $Y=928330
X3973 1 2 1784 1829 1886 ICV_109 $T=842480 913040 0 0 $X=842050 $Y=912650
X3974 1 2 1904 1895 1907 ICV_109 $T=846960 897360 0 0 $X=846530 $Y=896970
X3975 1 2 1722 2125 2160 ICV_109 $T=898480 920880 1 0 $X=898050 $Y=916325
X3976 1 2 2160 2219 2210 ICV_109 $T=908560 889520 0 0 $X=908130 $Y=889130
X3977 1 2 71 73 70 696 841 67 ICV_102 $T=622960 913040 0 0 $X=622530 $Y=912650
X3978 1 2 70 740 545 525 912 545 ICV_102 $T=630240 818960 1 0 $X=629810 $Y=814405
X3979 1 2 860 899 501 621 952 937 ICV_102 $T=633600 748400 0 0 $X=633170 $Y=748010
X3980 1 2 926 1006 76 67 1053 6 ICV_102 $T=642560 873840 1 0 $X=642130 $Y=869285
X3981 1 2 849 1055 30 30 1115 939 ICV_102 $T=648160 771920 1 0 $X=647730 $Y=767365
X3982 1 2 490 1064 67 1157 1137 3 ICV_102 $T=652080 897360 1 0 $X=651650 $Y=892805
X3983 1 2 153 477 1204 1229 505 1204 ICV_102 $T=661600 826800 0 0 $X=661170 $Y=826410
X3984 1 2 123 1213 985 155 1242 1075 ICV_102 $T=664400 803280 0 0 $X=663970 $Y=802890
X3985 1 2 177 1264 1271 49 1307 179 ICV_102 $T=668880 920880 0 0 $X=668450 $Y=920490
X3986 1 2 1065 1402 1421 154 1390 1210 ICV_102 $T=685680 897360 0 0 $X=685250 $Y=896970
X3987 1 2 125 85 1444 1476 1032 1045 ICV_102 $T=687360 779760 1 0 $X=686930 $Y=775205
X3988 1 2 152 1420 20 49 1477 972 ICV_102 $T=687360 842480 1 0 $X=686930 $Y=837925
X3989 1 2 1101 110 1472 1493 1128 1444 ICV_102 $T=691280 787600 1 0 $X=690850 $Y=783045
X3990 1 2 1493 15 139 7 1568 110 ICV_102 $T=706960 779760 1 0 $X=706530 $Y=775205
X3991 1 2 2272 2311 2318 2364 2352 2272 ICV_102 $T=922000 795440 1 0 $X=921570 $Y=790885
X3992 1 2 2268 2344 2039 2392 2384 2373 ICV_102 $T=925360 748400 0 0 $X=924930 $Y=748010
X3993 1 2 2418 2392 2276 2457 2452 2135 ICV_102 $T=935440 748400 0 0 $X=935010 $Y=748010
X3994 37 1 2 48 INVX4 $T=634160 787600 0 0 $X=633730 $Y=787210
X3995 131 1 2 88 INVX4 $T=873840 795440 0 0 $X=873410 $Y=795050
X3996 1 2 1015 1028 38 130 982 67 ICV_107 $T=644800 850320 1 0 $X=644370 $Y=845765
X3997 1 2 167 978 170 1255 95 170 ICV_107 $T=664960 936560 1 0 $X=664530 $Y=932005
X3998 1 2 1253 781 178 1253 861 1312 ICV_107 $T=669440 818960 1 0 $X=669010 $Y=814405
X3999 1 2 1270 83 170 154 1338 1202 ICV_107 $T=672800 936560 1 0 $X=672370 $Y=932005
X4000 1 2 155 1379 1282 1409 133 1417 ICV_107 $T=681200 803280 1 0 $X=680770 $Y=798725
X4001 1 2 1411 972 1465 182 1312 220 ICV_107 $T=690720 818960 1 0 $X=690290 $Y=814405
X4002 1 2 1451 1375 1381 182 1381 223 ICV_107 $T=691280 913040 0 0 $X=690850 $Y=912650
X4003 1 2 182 1370 222 201 1476 1429 ICV_107 $T=695200 826800 1 0 $X=694770 $Y=822245
X4004 1 2 201 1298 1507 182 178 1518 ICV_107 $T=698000 818960 0 0 $X=697570 $Y=818570
X4005 1 2 1497 1405 1472 1409 776 1485 ICV_107 $T=700800 803280 1 0 $X=700370 $Y=798725
X4006 1 2 1521 1535 243 1521 1559 1507 ICV_107 $T=706400 881680 0 0 $X=705970 $Y=881290
X4007 1 2 2347 2357 2367 2347 2394 2400 ICV_107 $T=927040 826800 0 0 $X=926610 $Y=826410
X4008 1 2 1119 1133 1143 525 ICV_96 $T=650960 818960 0 0 $X=650530 $Y=818570
X4009 1 2 1530 1513 1551 1541 ICV_96 $T=704160 756240 1 0 $X=703730 $Y=751685
X4010 1 2 1251 1598 1616 1585 ICV_96 $T=715360 756240 0 0 $X=714930 $Y=755850
X4011 1 2 1499 1626 1633 1536 ICV_96 $T=718720 913040 0 0 $X=718290 $Y=912650
X4012 1 2 1725 1822 1874 1834 ICV_96 $T=836880 732720 0 0 $X=836450 $Y=732330
X4013 1 2 1797 1910 1917 1881 ICV_96 $T=844160 866000 0 0 $X=843730 $Y=865610
X4014 1 2 1792 1750 1921 1776 ICV_96 $T=844720 873840 0 0 $X=844290 $Y=873450
X4015 1 2 1942 1951 1954 340 ICV_96 $T=850880 740560 0 0 $X=850450 $Y=740170
X4016 1 2 1958 1968 1972 1808 ICV_96 $T=855360 905200 1 0 $X=854930 $Y=900645
X4017 1 2 2104 2066 355 2123 ICV_96 $T=883360 889520 1 0 $X=882930 $Y=884965
X4018 1 2 2116 2125 2181 2133 ICV_96 $T=894560 928720 1 0 $X=894130 $Y=924165
X4019 1 2 2033 2009 2238 2246 ICV_96 $T=903520 858160 0 0 $X=903090 $Y=857770
X4020 1 2 2338 2351 2356 2298 ICV_96 $T=922000 771920 0 0 $X=921570 $Y=771530
X4021 1 2 2358 2372 2379 2386 ICV_96 $T=924240 834640 0 0 $X=923810 $Y=834250
X4022 1 2 2360 2412 2422 378 ICV_96 $T=929840 928720 0 0 $X=929410 $Y=928330
X4023 1 2 2407 88 2433 2456 ICV_96 $T=934880 928720 1 0 $X=934450 $Y=924165
X4024 1 2 2454 2377 2480 2362 ICV_96 $T=939360 795440 1 0 $X=938930 $Y=790885
.ENDS
***************************************
.SUBCKT ICV_40
** N=4 EP=0 IP=8 FDC=0
.ENDS
***************************************
.SUBCKT ICV_45
** N=4 EP=0 IP=8 FDC=0
.ENDS
***************************************
.SUBCKT ICV_52 1 2 3 4 5 6
** N=8 EP=6 IP=13 FDC=40
X1 4 6 5 2 1 2 3 DFFQSRX1 $T=0 0 0 0 $X=-430 $Y=-390
.ENDS
***************************************
.SUBCKT ICV_54 1 2 3 4 5 6
** N=8 EP=6 IP=13 FDC=40
X1 4 6 5 2 1 2 3 DFFQSRX1 $T=0 0 0 0 $X=-430 $Y=-390
.ENDS
***************************************
.SUBCKT ICV_50 1 2 3 4 5 6
** N=8 EP=6 IP=12 FDC=12
X1 4 3 5 1 2 6 MUX2X1 $T=6160 0 1 180 $X=130 $Y=-390
.ENDS
***************************************
.SUBCKT ICV_51 1 2 3 4 5 6
** N=8 EP=6 IP=13 FDC=40
X1 4 6 5 2 1 2 3 DFFQSRX1 $T=3360 0 0 0 $X=2930 $Y=-390
.ENDS
***************************************
.SUBCKT ICV_53 1 2 3 4 5 6
** N=8 EP=6 IP=13 FDC=40
X1 4 6 5 2 1 2 3 DFFQSRX1 $T=0 0 0 0 $X=-430 $Y=-390
.ENDS
***************************************
.SUBCKT ICV_57
** N=4 EP=0 IP=8 FDC=0
.ENDS
***************************************
.SUBCKT ICV_44
** N=5 EP=0 IP=8 FDC=0
.ENDS
***************************************
.SUBCKT ICV_46
** N=5 EP=0 IP=10 FDC=0
.ENDS
***************************************
.SUBCKT ICV_64 1 2 3 4 5 6 7 8 9 10 11 12 13 14 15 16 17 18 19 20
+ 21 22 23 24 25 26 27 28 29 30 31 32 33 34 35 36 37 38 39 40
+ 41 42 43 44 45 46 47 48 49 50 51 52 53 54 55 56 57 58 59 60
+ 61 62 63 64 65 66 67 68 69 70 71 72 73 74 75 76 77 78 79 80
+ 81 82 83 84 85 86 87 88 89 90 91 92 93 94 95 96 97 98 99 100
+ 101 102 103 104 105 106 107 108 109 110 111 112 113 114 115 116 117 118 119 120
+ 121 122 123 124 125 126 127 128 129 130 131 132 133 134 135 136 137 138 139 140
+ 141 142 143 144 145 146 147 148 149 150 151 152 153 154 155 156 157 158 159 160
+ 161 162 163 164 165 166 167 168 169 170 171 172 173 174 175 176 177 178 179 180
+ 181 182 183 184 185 186 187 188 189 190 191 192 193 194 195 196 197 198 199 200
+ 201 202 203 204 205 206 207 208 209 210 211 212 213 214 215 216 217 218 219 220
+ 221 222 223 224 225 226 227 228 229 230 231 232 233 234 235 236 237 238 239 240
+ 241 242 243 244 245 246 247 248 249 250 251 252 253 254 255 256 257 258 259 260
+ 261 262 263 264 265 266 267 268 269 270 271 272 273 274 275 276 277 278 279 280
+ 281 282 283 284 285 286 287 288 289 290 291 292 293 294 295 296 297 298 299 300
+ 301 302 303 304 305 306 307 308 309 310 311 312 313 314 315 316 317 318 319 320
+ 321 322 323 324 325 326 327 332 333 334 335 336
** N=1254 EP=332 IP=12556 FDC=13712
X580 489 326 327 2 1 2 399 DFFQSRX1 $T=651520 1077680 0 180 $X=625890 $Y=1073125
X581 539 326 327 2 1 2 531 DFFQSRX1 $T=648160 1030640 0 0 $X=647730 $Y=1030250
X582 562 326 327 2 1 2 475 DFFQSRX1 $T=678960 1093360 1 180 $X=653330 $Y=1092970
X583 586 594 327 2 1 2 135 DFFQSRX1 $T=678960 1022800 0 0 $X=678530 $Y=1022410
X584 599 594 327 2 1 2 606 DFFQSRX1 $T=678960 1030640 0 0 $X=678530 $Y=1030250
X585 564 594 327 2 1 2 125 DFFQSRX1 $T=678960 1038480 0 0 $X=678530 $Y=1038090
X586 592 594 327 2 1 2 603 DFFQSRX1 $T=678960 1046320 0 0 $X=678530 $Y=1045930
X587 626 326 327 2 1 2 630 DFFQSRX1 $T=678960 1054160 0 0 $X=678530 $Y=1053770
X588 596 602 327 2 1 2 607 DFFQSRX1 $T=678960 1093360 1 0 $X=678530 $Y=1088805
X589 565 326 327 2 1 2 573 DFFQSRX1 $T=682880 1062000 1 0 $X=682450 $Y=1057445
X590 651 594 327 2 1 2 167 DFFQSRX1 $T=688480 1030640 1 0 $X=688050 $Y=1026085
X591 646 326 327 2 1 2 645 DFFQSRX1 $T=692400 1085520 1 0 $X=691970 $Y=1080965
X592 670 762 327 2 1 2 152 DFFQSRX1 $T=720960 1038480 0 180 $X=695330 $Y=1033925
X593 672 602 327 2 1 2 677 DFFQSRX1 $T=698000 1101200 1 0 $X=697570 $Y=1096645
X594 662 602 327 2 1 2 674 DFFQSRX1 $T=698000 1109040 1 0 $X=697570 $Y=1104485
X595 710 762 327 2 1 2 169 DFFQSRX1 $T=729360 1014960 1 180 $X=703730 $Y=1014570
X596 688 762 327 2 1 2 170 DFFQSRX1 $T=729920 1030640 1 180 $X=704290 $Y=1030250
X597 668 762 327 2 1 2 171 DFFQSRX1 $T=729920 1054160 0 180 $X=704290 $Y=1049605
X598 703 762 327 2 1 2 140 DFFQSRX1 $T=731040 1022800 1 180 $X=705410 $Y=1022410
X599 689 762 327 2 1 2 174 DFFQSRX1 $T=734400 1046320 1 180 $X=708770 $Y=1045930
X600 722 755 327 2 1 2 647 DFFQSRX1 $T=745600 1007120 0 180 $X=719970 $Y=1002565
X601 739 326 327 2 1 2 634 DFFQSRX1 $T=745600 1069840 0 180 $X=719970 $Y=1065285
X602 724 755 327 2 1 2 188 DFFQSRX1 $T=746160 991440 0 180 $X=720530 $Y=986885
X603 723 755 327 2 1 2 665 DFFQSRX1 $T=746160 1022800 0 180 $X=720530 $Y=1018245
X604 726 755 327 2 1 2 189 DFFQSRX1 $T=746720 1014960 0 180 $X=721090 $Y=1010405
X605 727 326 327 2 1 2 717 DFFQSRX1 $T=723760 1077680 1 0 $X=723330 $Y=1073125
X606 758 326 327 2 1 2 701 DFFQSRX1 $T=753440 1046320 0 180 $X=727810 $Y=1041765
X607 743 326 327 2 1 2 707 DFFQSRX1 $T=760160 1054160 0 180 $X=734530 $Y=1049605
X608 779 326 327 2 1 2 580 DFFQSRX1 $T=764080 1069840 1 180 $X=738450 $Y=1069450
X609 783 326 327 2 1 2 716 DFFQSRX1 $T=766880 1038480 0 180 $X=741250 $Y=1033925
X610 773 226 327 2 1 2 154 DFFQSRX1 $T=767440 975760 0 180 $X=741810 $Y=971205
X611 774 226 327 2 1 2 212 DFFQSRX1 $T=767440 983600 0 180 $X=741810 $Y=979045
X612 775 755 327 2 1 2 632 DFFQSRX1 $T=768000 999280 0 180 $X=742370 $Y=994725
X613 776 755 327 2 1 2 213 DFFQSRX1 $T=768560 1007120 1 180 $X=742930 $Y=1006730
X614 789 226 327 2 1 2 219 DFFQSRX1 $T=776400 952240 1 180 $X=750770 $Y=951850
X615 784 226 327 2 1 2 165 DFFQSRX1 $T=776400 967920 0 180 $X=750770 $Y=963365
X616 760 326 327 2 1 2 750 DFFQSRX1 $T=752320 1069840 1 0 $X=751890 $Y=1065285
X617 791 326 327 2 1 2 790 DFFQSRX1 $T=757360 1030640 0 0 $X=756930 $Y=1030250
X618 820 326 327 2 1 2 777 DFFQSRX1 $T=784240 960080 1 180 $X=758610 $Y=959690
X619 825 326 327 2 1 2 769 DFFQSRX1 $T=784240 975760 1 180 $X=758610 $Y=975370
X620 828 326 327 2 1 2 715 DFFQSRX1 $T=784240 1038480 1 180 $X=758610 $Y=1038090
X621 821 326 327 2 1 2 720 DFFQSRX1 $T=784240 1046320 1 180 $X=758610 $Y=1045930
X622 830 326 327 2 1 2 731 DFFQSRX1 $T=784240 1062000 1 180 $X=758610 $Y=1061610
X623 797 659 327 2 1 2 233 DFFQSRX1 $T=759040 1109040 0 0 $X=758610 $Y=1108650
X624 804 326 327 2 1 2 788 DFFQSRX1 $T=789840 975760 1 0 $X=789410 $Y=971205
X625 810 326 327 2 1 2 238 DFFQSRX1 $T=789840 999280 1 0 $X=789410 $Y=994725
X626 832 326 327 2 1 2 815 DFFQSRX1 $T=789840 1014960 0 0 $X=789410 $Y=1014570
X627 875 326 327 2 1 2 260 DFFQSRX1 $T=790960 967920 1 0 $X=790530 $Y=963365
X628 869 326 327 2 1 2 256 DFFQSRX1 $T=792080 960080 1 0 $X=791650 $Y=955525
X629 332 326 327 2 1 2 223 DFFQSRX1 $T=793760 952240 1 0 $X=793330 $Y=947685
X630 848 326 327 2 1 2 772 DFFQSRX1 $T=796560 1030640 0 0 $X=796130 $Y=1030250
X631 861 920 327 2 1 2 228 DFFQSRX1 $T=799360 1109040 0 0 $X=798930 $Y=1108650
X632 867 326 327 2 1 2 818 DFFQSRX1 $T=826240 1054160 0 180 $X=800610 $Y=1049605
X633 880 326 327 2 1 2 852 DFFQSRX1 $T=828480 991440 1 180 $X=802850 $Y=991050
X634 878 920 327 2 1 2 269 DFFQSRX1 $T=806080 1069840 0 0 $X=805650 $Y=1069450
X635 902 326 327 2 1 2 257 DFFQSRX1 $T=836320 967920 1 180 $X=810690 $Y=967530
X636 914 274 327 2 1 2 921 DFFQSRX1 $T=822320 960080 1 0 $X=821890 $Y=955525
X637 924 935 327 2 1 2 272 DFFQSRX1 $T=822880 1116880 0 0 $X=822450 $Y=1116490
X638 928 274 327 2 1 2 933 DFFQSRX1 $T=827360 952240 1 0 $X=826930 $Y=947685
X639 905 920 327 2 1 2 264 DFFQSRX1 $T=829040 1085520 0 0 $X=828610 $Y=1085130
X640 827 920 327 2 1 2 248 DFFQSRX1 $T=829600 1093360 1 0 $X=829170 $Y=1088805
X641 894 929 327 2 1 2 903 DFFQSRX1 $T=856480 983600 1 180 $X=830850 $Y=983210
X642 949 326 327 2 1 2 945 DFFQSRX1 $T=835200 1054160 1 0 $X=834770 $Y=1049605
X643 950 326 327 2 1 2 946 DFFQSRX1 $T=836320 1062000 0 0 $X=835890 $Y=1061610
X644 967 968 327 2 1 2 738 DFFQSRX1 $T=862080 1007120 1 180 $X=836450 $Y=1006730
X645 938 929 327 2 1 2 952 DFFQSRX1 $T=844160 999280 0 0 $X=843730 $Y=998890
X646 963 968 327 2 1 2 277 DFFQSRX1 $T=845280 1077680 0 0 $X=844850 $Y=1077290
X647 975 929 327 2 1 2 984 DFFQSRX1 $T=857600 967920 0 0 $X=857170 $Y=967530
X648 979 968 327 2 1 2 994 DFFQSRX1 $T=859280 1054160 0 0 $X=858850 $Y=1053770
X649 970 929 327 2 1 2 977 DFFQSRX1 $T=862080 975760 0 0 $X=861650 $Y=975370
X650 1012 1043 327 2 1 2 961 DFFQSRX1 $T=895120 1077680 0 180 $X=869490 $Y=1073125
X651 1023 1084 327 2 1 2 757 DFFQSRX1 $T=895680 960080 1 180 $X=870050 $Y=959690
X652 997 1084 327 2 1 2 985 DFFQSRX1 $T=895680 975760 0 180 $X=870050 $Y=971205
X653 1008 1047 327 2 1 2 981 DFFQSRX1 $T=895680 1007120 1 180 $X=870050 $Y=1006730
X654 1017 1043 327 2 1 2 863 DFFQSRX1 $T=895680 1046320 1 180 $X=870050 $Y=1045930
X655 1006 1043 327 2 1 2 986 DFFQSRX1 $T=895680 1085520 0 180 $X=870050 $Y=1080965
X656 1018 295 327 2 1 2 987 DFFQSRX1 $T=895680 1109040 1 180 $X=870050 $Y=1108650
X657 1022 295 327 2 1 2 988 DFFQSRX1 $T=895680 1124720 1 180 $X=870050 $Y=1124330
X658 1046 1047 327 2 1 2 1014 DFFQSRX1 $T=911360 1007120 0 180 $X=885730 $Y=1002565
X659 1055 1047 327 2 1 2 802 DFFQSRX1 $T=901280 991440 0 0 $X=900850 $Y=991050
X660 1040 1047 327 2 1 2 1056 DFFQSRX1 $T=901280 1022800 0 0 $X=900850 $Y=1022410
X661 1061 1043 327 2 1 2 1069 DFFQSRX1 $T=901280 1062000 0 0 $X=900850 $Y=1061610
X662 1054 1043 327 2 1 2 1066 DFFQSRX1 $T=901280 1069840 1 0 $X=900850 $Y=1065285
X663 1048 1043 327 2 1 2 1088 DFFQSRX1 $T=901280 1093360 1 0 $X=900850 $Y=1088805
X664 1070 1047 327 2 1 2 307 DFFQSRX1 $T=914720 999280 1 0 $X=914290 $Y=994725
X665 1094 1106 327 2 1 2 879 DFFQSRX1 $T=941040 1014960 0 180 $X=915410 $Y=1010405
X666 1090 1116 327 2 1 2 1099 DFFQSRX1 $T=916400 1030640 0 0 $X=915970 $Y=1030250
X667 1091 1116 327 2 1 2 1100 DFFQSRX1 $T=916400 1046320 0 0 $X=915970 $Y=1045930
X668 1065 300 327 2 1 2 1111 DFFQSRX1 $T=916960 1116880 0 0 $X=916530 $Y=1116490
X669 1092 1116 327 2 1 2 1101 DFFQSRX1 $T=918080 1022800 1 0 $X=917650 $Y=1018245
X670 1097 300 327 2 1 2 1115 DFFQSRX1 $T=918080 1085520 0 0 $X=917650 $Y=1085130
X671 1110 1106 327 2 1 2 313 DFFQSRX1 $T=932640 960080 0 0 $X=932210 $Y=959690
X672 1122 1106 327 2 1 2 1129 DFFQSRX1 $T=937680 975760 0 0 $X=937250 $Y=975370
X673 1098 1106 327 2 1 2 1087 DFFQSRX1 $T=938800 991440 1 0 $X=938370 $Y=986885
X674 1157 335 327 2 1 2 1103 DFFQSRX1 $T=969040 1077680 0 180 $X=943410 $Y=1073125
X675 1133 1125 327 2 1 2 1154 DFFQSRX1 $T=946640 1054160 0 0 $X=946210 $Y=1053770
X676 1121 335 327 2 1 2 1132 DFFQSRX1 $T=947760 1101200 1 0 $X=947330 $Y=1096645
X677 1145 335 327 2 1 2 1149 DFFQSRX1 $T=948320 1101200 0 0 $X=947890 $Y=1100810
X678 334 335 327 2 1 2 1160 DFFQSRX1 $T=948320 1124720 0 0 $X=947890 $Y=1124330
X679 1144 335 327 2 1 2 1148 DFFQSRX1 $T=948880 1116880 0 0 $X=948450 $Y=1116490
X680 1141 335 327 2 1 2 1135 DFFQSRX1 $T=949440 1109040 0 0 $X=949010 $Y=1108650
X681 1162 335 327 2 1 2 1136 DFFQSRX1 $T=980800 1085520 1 180 $X=955170 $Y=1085130
X682 1153 316 327 2 1 2 318 DFFQSRX1 $T=959520 952240 0 0 $X=959090 $Y=951850
X683 1165 1125 327 2 1 2 1169 DFFQSRX1 $T=964000 1069840 1 0 $X=963570 $Y=1065285
X684 1142 335 327 2 1 2 1173 DFFQSRX1 $T=964000 1085520 1 0 $X=963570 $Y=1080965
X685 1176 335 327 2 1 2 1150 DFFQSRX1 $T=990880 1007120 1 180 $X=965250 $Y=1006730
X686 1171 1159 327 2 1 2 1182 DFFQSRX1 $T=966240 991440 0 0 $X=965810 $Y=991050
X687 1164 1118 327 2 1 2 1185 DFFQSRX1 $T=966800 1014960 0 0 $X=966370 $Y=1014570
X688 1166 1125 327 2 1 2 1197 DFFQSRX1 $T=978560 1030640 1 0 $X=978130 $Y=1026085
X689 1180 316 327 2 1 2 1203 DFFQSRX1 $T=981360 960080 1 0 $X=980930 $Y=955525
X690 1188 335 327 2 1 2 323 DFFQSRX1 $T=981360 967920 0 0 $X=980930 $Y=967530
X691 1190 335 327 2 1 2 1194 DFFQSRX1 $T=981360 1022800 0 0 $X=980930 $Y=1022410
X692 1184 335 327 2 1 2 1206 DFFQSRX1 $T=981360 1062000 0 0 $X=980930 $Y=1061610
X693 1151 335 327 2 1 2 1192 DFFQSRX1 $T=981360 1077680 0 0 $X=980930 $Y=1077290
X694 1195 335 327 2 1 2 1127 DFFQSRX1 $T=1006560 1085520 1 180 $X=980930 $Y=1085130
X695 1208 335 327 2 1 2 1187 DFFQSRX1 $T=1020560 1007120 0 180 $X=994930 $Y=1002565
X696 1191 335 327 2 1 2 1189 DFFQSRX1 $T=1021120 999280 1 180 $X=995490 $Y=998890
X697 1207 335 327 2 1 2 325 DFFQSRX1 $T=1012160 952240 0 0 $X=1011730 $Y=951850
X698 336 335 327 2 1 2 1200 DFFQSRX1 $T=1012160 960080 0 0 $X=1011730 $Y=959690
X699 1201 335 327 2 1 2 1204 DFFQSRX1 $T=1012160 975760 0 0 $X=1011730 $Y=975370
X700 1198 335 327 2 1 2 1205 DFFQSRX1 $T=1012160 1038480 1 0 $X=1011730 $Y=1033925
X701 1209 335 327 2 1 2 1193 DFFQSRX1 $T=1012160 1054160 1 0 $X=1011730 $Y=1049605
X702 358 18 1 2 360 NOR2X1 $T=607280 960080 0 0 $X=606850 $Y=959690
X703 360 362 1 2 359 NOR2X1 $T=607840 967920 1 0 $X=607410 $Y=963365
X704 369 364 1 2 368 NOR2X1 $T=614560 975760 1 180 $X=611330 $Y=975370
X705 366 370 1 2 362 NOR2X1 $T=612320 960080 0 0 $X=611890 $Y=959690
X706 386 389 1 2 388 NOR2X1 $T=619600 991440 1 0 $X=619170 $Y=986885
X707 8 390 1 2 370 NOR2X1 $T=620160 960080 1 0 $X=619730 $Y=955525
X708 41 47 1 2 390 NOR2X1 $T=623520 952240 0 0 $X=623090 $Y=951850
X709 4 358 1 2 45 NOR2X1 $T=626880 952240 0 0 $X=626450 $Y=951850
X710 434 427 1 2 433 NOR2X1 $T=637520 1007120 0 180 $X=634290 $Y=1002565
X711 423 63 1 2 436 NOR2X1 $T=638080 999280 0 180 $X=634850 $Y=994725
X712 74 467 1 2 463 NOR2X1 $T=641440 1007120 0 0 $X=641010 $Y=1006730
X713 485 480 1 2 483 NOR2X1 $T=648720 975760 1 180 $X=645490 $Y=975370
X714 481 486 1 2 484 NOR2X1 $T=645920 999280 0 0 $X=645490 $Y=998890
X715 4 84 1 2 88 NOR2X1 $T=654320 952240 0 180 $X=651090 $Y=947685
X716 499 502 1 2 501 NOR2X1 $T=652640 1007120 0 0 $X=652210 $Y=1006730
X717 510 468 1 2 508 NOR2X1 $T=657680 999280 0 180 $X=654450 $Y=994725
X718 513 103 1 2 517 NOR2X1 $T=658240 991440 1 0 $X=657810 $Y=986885
X719 429 521 1 2 109 NOR2X1 $T=667200 967920 1 180 $X=663970 $Y=967530
X720 524 561 1 2 559 NOR2X1 $T=668880 1007120 0 0 $X=668450 $Y=1006730
X721 572 560 1 2 576 NOR2X1 $T=672800 991440 0 0 $X=672370 $Y=991050
X722 551 124 1 2 578 NOR2X1 $T=673920 952240 1 0 $X=673490 $Y=947685
X723 610 598 1 2 609 NOR2X1 $T=686240 999280 0 180 $X=683010 $Y=994725
X724 628 554 1 2 627 NOR2X1 $T=693520 991440 1 180 $X=690290 $Y=991050
X725 168 649 1 2 656 NOR2X1 $T=704720 999280 0 180 $X=701490 $Y=994725
X726 187 196 1 2 186 NOR2X1 $T=727680 1124720 1 180 $X=724450 $Y=1124330
X727 204 714 1 2 202 NOR2X1 $T=732160 1109040 0 0 $X=731730 $Y=1108650
X728 204 199 1 2 205 NOR2X1 $T=735520 1116880 1 180 $X=732290 $Y=1116490
X729 199 721 1 2 719 NOR2X1 $T=733280 1093360 0 0 $X=732850 $Y=1092970
X730 714 196 1 2 725 NOR2X1 $T=734960 1101200 0 0 $X=734530 $Y=1100810
X731 736 206 1 2 740 NOR2X1 $T=746160 1116880 1 180 $X=742930 $Y=1116490
X732 194 736 1 2 741 NOR2X1 $T=743360 1124720 1 0 $X=742930 $Y=1120165
X733 214 209 1 2 194 NOR2X1 $T=744480 1101200 0 0 $X=744050 $Y=1100810
X734 751 217 1 2 753 NOR2X1 $T=748400 1116880 1 0 $X=747970 $Y=1112325
X735 204 718 1 2 763 NOR2X1 $T=752880 1116880 0 0 $X=752450 $Y=1116490
X736 766 761 1 2 765 NOR2X1 $T=756800 1101200 0 180 $X=753570 $Y=1096645
X737 209 767 1 2 766 NOR2X1 $T=754000 1109040 1 0 $X=753570 $Y=1104485
X738 740 222 1 2 767 NOR2X1 $T=754000 1116880 1 0 $X=753570 $Y=1112325
X739 224 734 1 2 787 NOR2X1 $T=769120 1101200 1 180 $X=765890 $Y=1100810
X740 806 224 1 2 801 NOR2X1 $T=783680 1101200 0 180 $X=780450 $Y=1096645
X741 677 232 1 2 805 NOR2X1 $T=781440 1093360 1 0 $X=781010 $Y=1088805
X742 237 235 1 2 809 NOR2X1 $T=787600 1124720 1 180 $X=784370 $Y=1124330
X743 234 803 1 2 817 NOR2X1 $T=789840 1116880 1 180 $X=786610 $Y=1116490
X744 809 239 1 2 819 NOR2X1 $T=787600 1124720 1 0 $X=787170 $Y=1120165
X745 847 819 1 2 845 NOR2X1 $T=800480 1124720 0 180 $X=797250 $Y=1120165
X746 248 245 1 2 826 NOR2X1 $T=802720 1093360 0 180 $X=799490 $Y=1088805
X747 247 850 1 2 868 NOR2X1 $T=811680 1124720 1 180 $X=808450 $Y=1124330
X748 868 259 1 2 873 NOR2X1 $T=812800 1124720 0 0 $X=812370 $Y=1124330
X749 224 870 1 2 877 NOR2X1 $T=817840 1077680 1 180 $X=814610 $Y=1077290
X750 918 913 1 2 886 NOR2X1 $T=831840 1022800 0 180 $X=828610 $Y=1018245
X751 269 245 1 2 918 NOR2X1 $T=832400 1022800 1 0 $X=831970 $Y=1018245
X752 271 919 1 2 927 NOR2X1 $T=835760 1124720 0 0 $X=835330 $Y=1124330
X753 910 232 1 2 959 NOR2X1 $T=854240 1030640 0 0 $X=853810 $Y=1030250
X754 962 959 1 2 960 NOR2X1 $T=857600 1022800 0 180 $X=854370 $Y=1018245
X755 738 245 1 2 962 NOR2X1 $T=857600 1022800 1 0 $X=857170 $Y=1018245
X756 933 232 1 2 281 NOR2X1 $T=863760 952240 0 0 $X=863330 $Y=951850
X757 912 232 1 2 982 NOR2X1 $T=868800 1022800 0 0 $X=868370 $Y=1022410
X758 1030 982 1 2 294 NOR2X1 $T=894000 991440 0 180 $X=890770 $Y=986885
X759 245 229 1 2 232 NOR2X1 $T=899040 967920 1 180 $X=895810 $Y=967530
X847 458 179 2 1 187 XOR2X1 $T=714800 1014960 1 0 $X=714370 $Y=1010405
X848 654 197 2 1 196 XOR2X1 $T=724320 1085520 1 0 $X=723890 $Y=1080965
X849 579 198 2 1 199 XOR2X1 $T=726000 1038480 0 0 $X=725570 $Y=1038090
X850 637 738 2 1 209 XOR2X1 $T=745040 1046320 1 180 $X=738450 $Y=1045930
X851 549 211 2 1 214 XOR2X1 $T=740560 1014960 0 0 $X=740130 $Y=1014570
X852 214 204 2 1 721 XOR2X1 $T=746720 1093360 0 180 $X=740130 $Y=1088805
X853 595 757 2 1 204 XOR2X1 $T=752880 1014960 1 180 $X=746290 $Y=1014570
X854 227 228 2 1 794 XOR2X1 $T=772480 1124720 0 0 $X=772050 $Y=1124330
X855 669 231 2 1 234 XOR2X1 $T=776400 999280 0 0 $X=775970 $Y=998890
X856 650 802 2 1 236 XOR2X1 $T=779760 1046320 1 0 $X=779330 $Y=1041765
X857 451 233 2 1 241 XOR2X1 $T=787040 1077680 0 0 $X=786610 $Y=1077290
X858 234 244 2 1 237 XOR2X1 $T=796000 1124720 1 180 $X=789410 $Y=1124330
X859 240 829 2 1 835 XOR2X1 $T=791520 1116880 0 0 $X=791090 $Y=1116490
X860 621 243 2 1 246 XOR2X1 $T=792080 1007120 1 0 $X=791650 $Y=1002565
X861 523 251 2 1 254 XOR2X1 $T=803280 1038480 1 0 $X=802850 $Y=1033925
X862 765 863 2 1 870 XOR2X1 $T=806640 1077680 0 0 $X=806210 $Y=1077290
X863 545 879 2 1 258 XOR2X1 $T=818400 1038480 0 180 $X=811810 $Y=1033925
X864 265 896 2 1 892 XOR2X1 $T=826800 1116880 0 180 $X=820210 $Y=1112325
X865 889 897 2 1 908 XOR2X1 $T=821760 1124720 1 0 $X=821330 $Y=1120165
X866 278 966 2 1 958 XOR2X1 $T=859840 991440 0 180 $X=853250 $Y=986885
X867 934 961 2 1 965 XOR2X1 $T=854800 1093360 1 0 $X=854370 $Y=1088805
X868 287 981 2 1 991 XOR2X1 $T=867680 1038480 0 0 $X=867250 $Y=1038090
X869 292 1014 2 1 1029 XOR2X1 $T=887280 952240 1 0 $X=886850 $Y=947685
X870 299 1056 2 1 1049 XOR2X1 $T=910800 983600 0 180 $X=904210 $Y=979045
X871 311 1053 2 1 1104 XOR2X1 $T=943280 1007120 0 180 $X=936690 $Y=1002565
X872 5 8 1 2 349 NAND2X1 $T=597760 960080 1 0 $X=597330 $Y=955525
X873 352 6 1 2 7 NAND2X1 $T=601120 952240 0 180 $X=597890 $Y=947685
X874 20 17 1 2 350 NAND2X1 $T=611200 952240 1 180 $X=607970 $Y=951850
X875 24 8 1 2 365 NAND2X1 $T=614560 952240 1 180 $X=611330 $Y=951850
X876 355 365 1 2 371 NAND2X1 $T=615680 960080 0 180 $X=612450 $Y=955525
X877 20 8 1 2 372 NAND2X1 $T=614560 952240 0 0 $X=614130 $Y=951850
X878 28 29 1 2 376 NAND2X1 $T=615680 991440 0 0 $X=615250 $Y=991050
X879 31 11 1 2 375 NAND2X1 $T=619040 983600 0 180 $X=615810 $Y=979045
X880 34 17 1 2 379 NAND2X1 $T=620720 952240 1 180 $X=617490 $Y=951850
X881 14 17 1 2 387 NAND2X1 $T=620720 952240 0 0 $X=620290 $Y=951850
X882 394 395 1 2 386 NAND2X1 $T=622400 983600 0 0 $X=621970 $Y=983210
X883 43 39 1 2 391 NAND2X1 $T=625200 999280 0 180 $X=621970 $Y=994725
X884 377 6 1 2 398 NAND2X1 $T=624640 991440 1 0 $X=624210 $Y=986885
X885 50 41 1 2 358 NAND2X1 $T=630240 952240 0 180 $X=627010 $Y=947685
X886 61 405 1 2 427 NAND2X1 $T=635840 999280 1 180 $X=632610 $Y=998890
X887 62 11 1 2 413 NAND2X1 $T=636960 960080 0 180 $X=633730 $Y=955525
X888 439 46 1 2 418 NAND2X1 $T=638640 960080 1 180 $X=635410 $Y=959690
X889 67 53 1 2 441 NAND2X1 $T=639200 983600 0 180 $X=635970 $Y=979045
X890 447 8 1 2 444 NAND2X1 $T=640880 952240 1 180 $X=637650 $Y=951850
X891 456 358 1 2 453 NAND2X1 $T=643120 952240 0 180 $X=639890 $Y=947685
X892 447 48 1 2 460 NAND2X1 $T=640880 960080 1 0 $X=640450 $Y=955525
X893 460 464 1 2 472 NAND2X1 $T=646480 960080 0 180 $X=643250 $Y=955525
X894 25 77 1 2 456 NAND2X1 $T=644240 952240 1 0 $X=643810 $Y=947685
X895 449 50 1 2 459 NAND2X1 $T=644800 960080 0 0 $X=644370 $Y=959690
X896 78 442 1 2 462 NAND2X1 $T=648160 1007120 0 180 $X=644930 $Y=1002565
X897 79 17 1 2 448 NAND2X1 $T=648720 952240 1 180 $X=645490 $Y=951850
X898 422 490 1 2 485 NAND2X1 $T=647040 975760 1 0 $X=646610 $Y=971205
X899 81 31 1 2 496 NAND2X1 $T=652640 991440 0 180 $X=649410 $Y=986885
X900 87 23 1 2 495 NAND2X1 $T=653200 975760 1 180 $X=649970 $Y=975370
X901 71 90 1 2 488 NAND2X1 $T=655440 991440 1 180 $X=652210 $Y=991050
X902 497 26 1 2 506 NAND2X1 $T=657120 967920 0 180 $X=653890 $Y=963365
X903 11 509 1 2 95 NAND2X1 $T=654320 975760 0 0 $X=653890 $Y=975370
X904 78 449 1 2 515 NAND2X1 $T=661040 983600 0 0 $X=660610 $Y=983210
X905 529 543 1 2 449 NAND2X1 $T=662720 960080 0 0 $X=662290 $Y=959690
X906 100 113 1 2 527 NAND2X1 $T=664960 999280 1 0 $X=664530 $Y=994725
X907 71 116 1 2 548 NAND2X1 $T=667760 983600 1 0 $X=667330 $Y=979045
X908 119 30 1 2 76 NAND2X1 $T=672800 952240 0 180 $X=669570 $Y=947685
X909 121 568 1 2 572 NAND2X1 $T=675040 999280 0 180 $X=671810 $Y=994725
X910 43 94 1 2 568 NAND2X1 $T=675040 999280 1 180 $X=671810 $Y=998890
X911 86 90 1 2 567 NAND2X1 $T=676160 991440 0 180 $X=672930 $Y=986885
X912 100 122 1 2 577 NAND2X1 $T=676160 1007120 0 180 $X=672930 $Y=1002565
X913 132 53 1 2 584 NAND2X1 $T=676720 975760 0 0 $X=676290 $Y=975370
X914 134 125 1 2 118 NAND2X1 $T=681760 983600 0 180 $X=678530 $Y=979045
X915 81 447 1 2 593 NAND2X1 $T=681760 991440 0 180 $X=678530 $Y=986885
X916 129 589 1 2 113 NAND2X1 $T=683440 967920 0 180 $X=680210 $Y=963365
X917 43 520 1 2 141 NAND2X1 $T=685680 983600 1 180 $X=682450 $Y=983210
X918 43 102 1 2 614 NAND2X1 $T=687920 1007120 0 180 $X=684690 $Y=1002565
X919 619 600 1 2 520 NAND2X1 $T=690160 975760 1 180 $X=686930 $Y=975370
X920 147 543 1 2 19 NAND2X1 $T=688480 952240 0 0 $X=688050 $Y=951850
X921 147 117 1 2 494 NAND2X1 $T=688480 960080 0 0 $X=688050 $Y=959690
X922 570 148 1 2 465 NAND2X1 $T=689040 967920 1 0 $X=688610 $Y=963365
X923 134 632 1 2 149 NAND2X1 $T=690720 952240 1 0 $X=690290 $Y=947685
X924 134 152 1 2 543 NAND2X1 $T=691280 952240 0 0 $X=690850 $Y=951850
X925 155 60 1 2 640 NAND2X1 $T=695200 983600 1 0 $X=694770 $Y=979045
X926 643 29 1 2 583 NAND2X1 $T=698000 991440 0 180 $X=694770 $Y=986885
X927 529 148 1 2 158 NAND2X1 $T=698560 960080 1 180 $X=695330 $Y=959690
X928 638 6 1 2 644 NAND2X1 $T=698560 991440 1 180 $X=695330 $Y=991050
X929 134 160 1 2 566 NAND2X1 $T=697440 952240 1 0 $X=697010 $Y=947685
X930 164 633 1 2 653 NAND2X1 $T=703040 975760 1 180 $X=699810 $Y=975370
X931 643 60 1 2 642 NAND2X1 $T=703040 983600 1 180 $X=699810 $Y=983210
X932 570 581 1 2 163 NAND2X1 $T=703600 960080 0 180 $X=700370 $Y=955525
X933 382 50 1 2 661 NAND2X1 $T=708640 967920 0 180 $X=705410 $Y=963365
X934 176 152 1 2 663 NAND2X1 $T=710880 975760 0 180 $X=707650 $Y=971205
X935 176 647 1 2 648 NAND2X1 $T=714800 967920 0 180 $X=711570 $Y=963365
X936 164 159 1 2 667 NAND2X1 $T=715360 975760 1 180 $X=712130 $Y=975370
X937 183 686 1 2 679 NAND2X1 $T=717040 967920 0 0 $X=716610 $Y=967530
X938 86 19 1 2 697 NAND2X1 $T=726000 960080 0 180 $X=722770 $Y=955525
X939 699 682 1 2 693 NAND2X1 $T=726000 1101200 0 180 $X=722770 $Y=1096645
X940 702 704 1 2 699 NAND2X1 $T=726000 1101200 1 0 $X=725570 $Y=1096645
X941 705 187 1 2 702 NAND2X1 $T=727680 1093360 0 0 $X=727250 $Y=1092970
X942 697 636 1 2 201 NAND2X1 $T=731040 952240 1 180 $X=727810 $Y=951850
X943 200 202 1 2 680 NAND2X1 $T=728800 1124720 1 0 $X=728370 $Y=1120165
X944 718 202 1 2 709 NAND2X1 $T=735520 1116880 0 180 $X=732290 $Y=1112325
X945 737 721 1 2 735 NAND2X1 $T=743920 1093360 1 180 $X=740690 $Y=1092970
X946 744 706 1 2 742 NAND2X1 $T=746160 1109040 0 180 $X=742930 $Y=1104485
X947 793 798 1 2 797 NAND2X1 $T=774720 1116880 1 0 $X=774290 $Y=1112325
X948 794 229 1 2 793 NAND2X1 $T=774720 1124720 1 0 $X=774290 $Y=1120165
X949 796 230 1 2 795 NAND2X1 $T=775280 1077680 0 0 $X=774850 $Y=1077290
X950 224 233 1 2 796 NAND2X1 $T=783680 1077680 1 180 $X=780450 $Y=1077290
X951 224 764 1 2 823 NAND2X1 $T=790960 1030640 1 180 $X=787730 $Y=1030250
X952 835 229 1 2 831 NAND2X1 $T=796560 1093360 0 180 $X=793330 $Y=1088805
X953 245 639 1 2 838 NAND2X1 $T=798240 1109040 0 180 $X=795010 $Y=1104485
X954 245 615 1 2 841 NAND2X1 $T=798800 1101200 1 180 $X=795570 $Y=1100810
X955 245 786 1 2 842 NAND2X1 $T=800480 1093360 1 180 $X=797250 $Y=1092970
X956 245 674 1 2 843 NAND2X1 $T=800480 1101200 0 180 $X=797250 $Y=1096645
X957 224 197 1 2 840 NAND2X1 $T=800480 1077680 0 0 $X=800050 $Y=1077290
X958 250 234 1 2 844 NAND2X1 $T=805520 1124720 0 180 $X=802290 $Y=1120165
X959 229 248 1 2 854 NAND2X1 $T=803840 1093360 0 0 $X=803410 $Y=1092970
X960 245 684 1 2 859 NAND2X1 $T=808880 1093360 0 180 $X=805650 $Y=1088805
X961 229 233 1 2 864 NAND2X1 $T=810000 1093360 0 0 $X=809570 $Y=1092970
X962 813 891 1 2 890 NAND2X1 $T=818400 1085520 1 0 $X=817970 $Y=1080965
X963 892 229 1 2 893 NAND2X1 $T=820640 1093360 0 0 $X=820210 $Y=1092970
X964 229 264 1 2 900 NAND2X1 $T=823440 1093360 0 0 $X=823010 $Y=1092970
X965 268 823 1 2 916 NAND2X1 $T=831840 1014960 1 180 $X=828610 $Y=1014570
X966 224 264 1 2 904 NAND2X1 $T=829600 1077680 0 0 $X=829170 $Y=1077290
X967 923 230 1 2 922 NAND2X1 $T=835760 1077680 0 180 $X=832530 $Y=1073125
X968 907 922 1 2 925 NAND2X1 $T=833520 1085520 1 0 $X=833090 $Y=1080965
X969 917 925 1 2 924 NAND2X1 $T=833520 1124720 1 0 $X=833090 $Y=1120165
X970 932 947 1 2 942 NAND2X1 $T=845840 1069840 0 0 $X=845410 $Y=1069450
X971 956 230 1 2 947 NAND2X1 $T=854240 1069840 1 180 $X=851010 $Y=1069450
X972 245 911 1 2 957 NAND2X1 $T=854800 1054160 1 180 $X=851570 $Y=1053770
X973 224 277 1 2 956 NAND2X1 $T=852000 1077680 1 0 $X=851570 $Y=1073125
X974 964 942 1 2 963 NAND2X1 $T=859280 1085520 0 180 $X=856050 $Y=1080965
X975 965 229 1 2 964 NAND2X1 $T=859280 1085520 1 180 $X=856050 $Y=1085130
X976 229 272 1 2 973 NAND2X1 $T=864880 1085520 0 0 $X=864450 $Y=1085130
X977 989 996 1 2 992 NAND2X1 $T=871040 991440 0 0 $X=870610 $Y=991050
X978 232 897 1 2 976 NAND2X1 $T=871600 1093360 0 0 $X=871170 $Y=1092970
X979 245 953 1 2 998 NAND2X1 $T=877760 1022800 0 180 $X=874530 $Y=1018245
X980 229 277 1 2 1001 NAND2X1 $T=876640 1062000 0 0 $X=876210 $Y=1061610
X981 245 951 1 2 1002 NAND2X1 $T=880000 999280 0 180 $X=876770 $Y=994725
X982 229 738 1 2 1003 NAND2X1 $T=877200 1038480 1 0 $X=876770 $Y=1033925
X983 245 954 1 2 1004 NAND2X1 $T=881680 1014960 0 180 $X=878450 $Y=1010405
X984 224 290 1 2 999 NAND2X1 $T=880000 991440 1 0 $X=879570 $Y=986885
X985 245 944 1 2 1009 NAND2X1 $T=886160 999280 0 180 $X=882930 $Y=994725
X986 232 966 1 2 1005 NAND2X1 $T=883360 1038480 1 0 $X=882930 $Y=1033925
X987 245 994 1 2 1010 NAND2X1 $T=886160 1062000 0 180 $X=882930 $Y=1057445
X988 232 961 1 2 1007 NAND2X1 $T=883360 1069840 1 0 $X=882930 $Y=1065285
X989 245 952 1 2 1016 NAND2X1 $T=888400 991440 0 180 $X=885170 $Y=986885
X990 229 290 1 2 1011 NAND2X1 $T=890640 999280 1 180 $X=887410 $Y=998890
X991 232 981 1 2 1013 NAND2X1 $T=891760 999280 0 0 $X=891330 $Y=998890
X992 245 977 1 2 1034 NAND2X1 $T=899040 983600 0 180 $X=895810 $Y=979045
X993 245 995 1 2 1038 NAND2X1 $T=900720 1054160 1 180 $X=897490 $Y=1053770
X994 229 757 1 2 1044 NAND2X1 $T=900720 1014960 0 0 $X=900290 $Y=1014570
X995 224 296 1 2 1035 NAND2X1 $T=901280 991440 1 0 $X=900850 $Y=986885
X996 232 757 1 2 1025 NAND2X1 $T=902400 967920 0 0 $X=901970 $Y=967530
X997 224 251 1 2 297 NAND2X1 $T=905760 952240 0 180 $X=902530 $Y=947685
X998 232 1053 1 2 1052 NAND2X1 $T=904640 1030640 0 0 $X=904210 $Y=1030250
X999 229 802 1 2 1039 NAND2X1 $T=906320 1022800 1 0 $X=905890 $Y=1018245
X1000 229 879 1 2 1051 NAND2X1 $T=906320 1046320 1 0 $X=905890 $Y=1041765
X1001 232 802 1 2 1057 NAND2X1 $T=907440 999280 1 0 $X=907010 $Y=994725
X1002 1064 230 1 2 1063 NAND2X1 $T=911360 952240 0 180 $X=908130 $Y=947685
X1003 1077 1062 1 2 1075 NAND2X1 $T=917520 952240 1 180 $X=914290 $Y=951850
X1004 232 307 1 2 1076 NAND2X1 $T=927040 1007120 1 0 $X=926610 $Y=1002565
X1005 1096 1033 1 2 1094 NAND2X1 $T=930400 1007120 1 180 $X=927170 $Y=1006730
X1006 232 308 1 2 1085 NAND2X1 $T=929840 975760 1 0 $X=929410 $Y=971205
X1007 232 309 1 2 1089 NAND2X1 $T=934320 952240 0 180 $X=931090 $Y=947685
X1008 1104 229 1 2 1096 NAND2X1 $T=936560 1007120 1 180 $X=933330 $Y=1006730
X1009 229 302 1 2 312 NAND2X1 $T=942160 952240 1 0 $X=941730 $Y=947685
X1010 232 313 1 2 1117 NAND2X1 $T=944960 967920 1 0 $X=944530 $Y=963365
X1011 315 229 1 2 1077 NAND2X1 $T=953360 952240 0 180 $X=950130 $Y=947685
X1012 10 1 2 25 INVX2 $T=613440 952240 1 0 $X=613010 $Y=947685
X1013 27 1 2 11 INVX2 $T=620720 975760 0 180 $X=618610 $Y=971205
X1014 358 1 2 17 INVX2 $T=629680 952240 0 0 $X=629250 $Y=951850
X1015 411 1 2 421 INVX2 $T=632480 1007120 0 0 $X=632050 $Y=1006730
X1016 420 1 2 443 INVX2 $T=636960 1007120 0 0 $X=636530 $Y=1006730
X1017 84 1 2 497 INVX2 $T=650960 967920 1 0 $X=650530 $Y=963365
X1018 476 1 2 498 INVX2 $T=650960 1014960 1 0 $X=650530 $Y=1010405
X1019 507 1 2 516 INVX2 $T=660480 975760 0 180 $X=658370 $Y=971205
X1020 544 1 2 552 INVX2 $T=666640 983600 0 0 $X=666210 $Y=983210
X1021 660 1 2 482 INVX2 $T=706960 967920 1 180 $X=704850 $Y=967530
X1022 696 1 2 685 INVX2 $T=724880 1116880 1 180 $X=722770 $Y=1116490
X1023 187 1 2 182 INVX2 $T=732160 1101200 1 0 $X=731730 $Y=1096645
X1024 199 1 2 714 INVX2 $T=732160 1101200 0 0 $X=731730 $Y=1100810
X1025 206 1 2 207 INVX2 $T=734400 1124720 1 0 $X=733970 $Y=1120165
X1026 202 1 2 728 INVX2 $T=738320 1116880 1 0 $X=737890 $Y=1112325
X1027 205 1 2 736 INVX2 $T=741680 1124720 0 0 $X=741250 $Y=1124330
X1028 210 1 2 718 INVX2 $T=750080 1109040 0 0 $X=749650 $Y=1108650
X1029 695 1 2 792 INVX2 $T=772480 1101200 0 0 $X=772050 $Y=1100810
X1030 235 1 2 803 INVX2 $T=783120 1116880 1 180 $X=781010 $Y=1116490
X1031 254 1 2 247 INVX2 $T=808880 1124720 1 0 $X=808450 $Y=1120165
X1304 11 13 1 2 356 OR2X1 $T=601680 960080 0 0 $X=601250 $Y=959690
X1305 11 14 1 2 354 OR2X1 $T=606160 967920 0 180 $X=602370 $Y=963365
X1306 11 19 1 2 351 OR2X1 $T=611200 960080 0 180 $X=607410 $Y=955525
X1307 374 27 1 2 361 OR2X1 $T=617360 975760 0 180 $X=613570 $Y=971205
X1308 41 39 1 2 392 OR2X1 $T=625760 967920 0 180 $X=621970 $Y=963365
X1309 8 55 1 2 406 OR2X1 $T=633600 960080 0 180 $X=629810 $Y=955525
X1310 41 442 1 2 439 OR2X1 $T=636400 967920 1 0 $X=635970 $Y=963365
X1311 437 45 1 2 446 OR2X1 $T=636960 975760 1 0 $X=636530 $Y=971205
X1312 11 465 1 2 452 OR2X1 $T=645360 975760 0 180 $X=641570 $Y=971205
X1313 50 570 1 2 652 OR2X1 $T=705280 952240 1 180 $X=701490 $Y=951850
X1314 181 680 1 2 178 OR2X1 $T=717600 1124720 1 180 $X=713810 $Y=1124330
X1315 606 164 1 2 686 OR2X1 $T=715920 975760 1 0 $X=715490 $Y=971205
X1316 199 713 1 2 203 OR2X1 $T=733840 1124720 1 180 $X=730050 $Y=1124330
X1317 209 721 1 2 704 OR2X1 $T=738320 1093360 0 180 $X=734530 $Y=1088805
X1318 218 746 1 2 749 OR2X1 $T=751200 1124720 1 180 $X=747410 $Y=1124330
X1319 741 763 1 2 768 OR2X1 $T=753440 1124720 1 0 $X=753010 $Y=1120165
X1320 618 232 1 2 799 OR2X1 $T=779200 1085520 0 0 $X=778770 $Y=1085130
X1321 635 232 1 2 813 OR2X1 $T=784800 1085520 0 0 $X=784370 $Y=1085130
X1322 607 232 1 2 814 OR2X1 $T=785360 1085520 1 0 $X=784930 $Y=1080965
X1323 826 805 1 2 812 OR2X1 $T=790400 1093360 0 180 $X=786610 $Y=1088805
X1324 811 787 1 2 824 OR2X1 $T=787040 1101200 1 0 $X=786610 $Y=1096645
X1325 886 877 1 2 878 OR2X1 $T=819520 1077680 0 180 $X=815730 $Y=1073125
X1326 785 232 1 2 907 OR2X1 $T=824560 1085520 1 0 $X=824130 $Y=1080965
X1327 883 232 1 2 932 OR2X1 $T=839120 1069840 1 0 $X=838690 $Y=1065285
X1328 921 232 1 2 989 OR2X1 $T=868240 991440 1 0 $X=867810 $Y=986885
X1329 983 232 1 2 291 OR2X1 $T=881120 952240 0 0 $X=880690 $Y=951850
X1330 984 232 1 2 1027 OR2X1 $T=890080 952240 0 0 $X=889650 $Y=951850
X1331 879 245 1 2 1028 OR2X1 $T=890080 1014960 0 0 $X=889650 $Y=1014570
X1332 224 1049 1 2 1060 OR2X1 $T=906320 983600 0 0 $X=905890 $Y=983210
X1377 20 50 37 1 2 36 MUX2X1 $T=626880 952240 0 180 $X=620850 $Y=947685
X1378 65 50 59 1 2 412 MUX2X1 $T=638080 952240 1 180 $X=632050 $Y=951850
X1379 382 50 66 1 2 68 MUX2X1 $T=633600 952240 1 0 $X=633170 $Y=947685
X1380 440 70 430 1 2 428 MUX2X1 $T=639760 1030640 1 180 $X=633730 $Y=1030250
X1381 399 72 438 1 2 431 MUX2X1 $T=641440 1069840 0 180 $X=635410 $Y=1065285
X1382 440 72 474 1 2 478 MUX2X1 $T=640880 1054160 1 0 $X=640450 $Y=1049605
X1383 430 70 461 1 2 455 MUX2X1 $T=647040 1030640 1 180 $X=641010 $Y=1030250
X1384 475 70 399 1 2 489 MUX2X1 $T=643680 1069840 1 0 $X=643250 $Y=1065285
X1385 79 50 494 1 2 373 MUX2X1 $T=646480 960080 1 0 $X=646050 $Y=955525
X1386 18 50 465 1 2 89 MUX2X1 $T=647600 960080 0 0 $X=647170 $Y=959690
X1387 55 50 79 1 2 514 MUX2X1 $T=653200 960080 0 0 $X=652770 $Y=959690
X1388 461 70 511 1 2 505 MUX2X1 $T=661040 1077680 1 180 $X=655010 $Y=1077290
X1389 430 72 530 1 2 538 MUX2X1 $T=659360 1022800 0 0 $X=658930 $Y=1022410
X1390 461 72 531 1 2 539 MUX2X1 $T=659360 1038480 0 0 $X=658930 $Y=1038090
X1391 550 70 541 1 2 533 MUX2X1 $T=668880 1077680 1 180 $X=662850 $Y=1077290
X1392 580 70 475 1 2 562 MUX2X1 $T=676720 1077680 1 180 $X=670690 $Y=1077290
X1393 541 72 569 1 2 582 MUX2X1 $T=671120 1085520 1 0 $X=670690 $Y=1080965
X1394 125 130 474 1 2 564 MUX2X1 $T=677280 1046320 0 180 $X=671250 $Y=1041765
X1395 541 70 573 1 2 565 MUX2X1 $T=677840 1062000 1 180 $X=671810 $Y=1061610
X1396 447 50 31 1 2 587 MUX2X1 $T=673920 960080 1 0 $X=673490 $Y=955525
X1397 135 130 569 1 2 586 MUX2X1 $T=684000 1022800 0 180 $X=677970 $Y=1018245
X1398 511 72 601 1 2 604 MUX2X1 $T=678960 1077680 0 0 $X=678530 $Y=1077290
X1399 603 130 438 1 2 592 MUX2X1 $T=685680 1046320 0 180 $X=679650 $Y=1041765
X1400 607 144 474 1 2 596 MUX2X1 $T=686240 1085520 0 180 $X=680210 $Y=1080965
X1401 606 130 542 1 2 599 MUX2X1 $T=686800 1038480 0 180 $X=680770 $Y=1033925
X1402 618 144 540 1 2 608 MUX2X1 $T=690160 1085520 1 180 $X=684130 $Y=1085130
X1403 634 70 550 1 2 622 MUX2X1 $T=696320 1077680 1 180 $X=690290 $Y=1077290
X1404 635 144 542 1 2 623 MUX2X1 $T=696320 1101200 1 180 $X=690290 $Y=1100810
X1405 573 72 630 1 2 626 MUX2X1 $T=696880 1046320 0 180 $X=690850 $Y=1041765
X1406 639 144 569 1 2 631 MUX2X1 $T=698000 1109040 0 180 $X=691970 $Y=1104485
X1407 511 70 645 1 2 646 MUX2X1 $T=692960 1085520 0 0 $X=692530 $Y=1085130
X1408 167 130 630 1 2 651 MUX2X1 $T=704720 1046320 0 180 $X=698690 $Y=1041765
X1409 171 130 601 1 2 668 MUX2X1 $T=704160 1038480 0 0 $X=703730 $Y=1038090
X1410 152 130 664 1 2 670 MUX2X1 $T=704720 1046320 1 0 $X=704290 $Y=1041765
X1411 674 144 664 1 2 662 MUX2X1 $T=712560 1101200 1 180 $X=706530 $Y=1100810
X1412 634 72 664 1 2 676 MUX2X1 $T=708080 1062000 1 0 $X=707650 $Y=1057445
X1413 633 136 166 1 2 374 MUX2X1 $T=708640 960080 0 0 $X=708210 $Y=959690
X1414 677 144 630 1 2 672 MUX2X1 $T=715360 1093360 0 180 $X=709330 $Y=1088805
X1415 170 130 531 1 2 688 MUX2X1 $T=713680 1038480 0 0 $X=713250 $Y=1038090
X1416 174 130 673 1 2 689 MUX2X1 $T=713680 1062000 1 0 $X=713250 $Y=1057445
X1417 684 144 601 1 2 678 MUX2X1 $T=719840 1077680 1 180 $X=713810 $Y=1077290
X1418 140 130 701 1 2 703 MUX2X1 $T=722080 1038480 1 0 $X=721650 $Y=1033925
X1419 169 130 707 1 2 710 MUX2X1 $T=724880 1007120 0 0 $X=724450 $Y=1006730
X1420 647 130 715 1 2 722 MUX2X1 $T=730480 1007120 0 0 $X=730050 $Y=1006730
X1421 665 130 716 1 2 723 MUX2X1 $T=730480 1038480 1 0 $X=730050 $Y=1033925
X1422 717 70 712 1 2 711 MUX2X1 $T=736080 1062000 1 180 $X=730050 $Y=1061610
X1423 188 130 720 1 2 724 MUX2X1 $T=731040 991440 0 0 $X=730610 $Y=991050
X1424 189 130 530 1 2 726 MUX2X1 $T=732160 1014960 0 0 $X=731730 $Y=1014570
X1425 645 70 717 1 2 727 MUX2X1 $T=732720 1077680 0 0 $X=732290 $Y=1077290
X1426 731 70 634 1 2 739 MUX2X1 $T=738880 1062000 0 0 $X=738450 $Y=1061610
X1427 573 70 216 1 2 745 MUX2X1 $T=740560 1022800 0 0 $X=740130 $Y=1022410
X1428 728 187 736 1 2 744 MUX2X1 $T=742240 1109040 0 0 $X=741810 $Y=1108650
X1429 725 209 215 1 2 737 MUX2X1 $T=748400 1101200 0 180 $X=742370 $Y=1096645
X1430 580 72 748 1 2 747 MUX2X1 $T=752320 1077680 1 180 $X=746290 $Y=1077290
X1431 712 70 750 1 2 760 MUX2X1 $T=747280 1062000 0 0 $X=746850 $Y=1061610
X1432 764 144 701 1 2 756 MUX2X1 $T=756800 1030640 0 180 $X=750770 $Y=1026085
X1433 712 72 701 1 2 758 MUX2X1 $T=757360 1046320 1 180 $X=751330 $Y=1045930
X1434 154 130 769 1 2 773 MUX2X1 $T=753440 967920 0 0 $X=753010 $Y=967530
X1435 212 130 770 1 2 774 MUX2X1 $T=753440 991440 1 0 $X=753010 $Y=986885
X1436 632 130 771 1 2 775 MUX2X1 $T=753440 999280 0 0 $X=753010 $Y=998890
X1437 213 130 772 1 2 776 MUX2X1 $T=753440 1014960 1 0 $X=753010 $Y=1010405
X1438 778 72 716 1 2 783 MUX2X1 $T=760160 1046320 1 0 $X=759730 $Y=1041765
X1439 165 130 223 1 2 784 MUX2X1 $T=760720 960080 1 0 $X=760290 $Y=955525
X1440 777 70 580 1 2 779 MUX2X1 $T=767440 1062000 0 180 $X=761410 $Y=1057445
X1441 786 144 748 1 2 781 MUX2X1 $T=769120 1093360 0 180 $X=763090 $Y=1088805
X1442 750 70 778 1 2 782 MUX2X1 $T=769680 1054160 0 180 $X=763650 $Y=1049605
X1443 219 130 788 1 2 789 MUX2X1 $T=766320 960080 1 0 $X=765890 $Y=955525
X1444 778 70 790 1 2 791 MUX2X1 $T=768000 1046320 1 0 $X=767570 $Y=1041765
X1445 777 72 788 1 2 804 MUX2X1 $T=788160 967920 1 180 $X=782130 $Y=967530
X1446 815 72 771 1 2 807 MUX2X1 $T=789840 1007120 0 180 $X=783810 $Y=1002565
X1447 731 72 720 1 2 821 MUX2X1 $T=784240 1062000 1 0 $X=783810 $Y=1057445
X1448 717 72 816 1 2 822 MUX2X1 $T=784240 1069840 1 0 $X=783810 $Y=1065285
X1449 790 72 769 1 2 825 MUX2X1 $T=784800 983600 0 0 $X=784370 $Y=983210
X1450 815 70 238 1 2 810 MUX2X1 $T=792080 999280 1 180 $X=786050 $Y=998890
X1451 812 229 806 1 2 811 MUX2X1 $T=792080 1093360 1 180 $X=786050 $Y=1092970
X1452 818 72 715 1 2 828 MUX2X1 $T=787600 1046320 1 0 $X=787170 $Y=1041765
X1453 242 70 777 1 2 820 MUX2X1 $T=794880 952240 1 180 $X=788850 $Y=951850
X1454 839 70 731 1 2 830 MUX2X1 $T=798800 1062000 0 180 $X=792770 $Y=1057445
X1455 238 72 770 1 2 846 MUX2X1 $T=794320 999280 0 0 $X=793890 $Y=998890
X1456 837 70 815 1 2 832 MUX2X1 $T=799920 1022800 1 180 $X=793890 $Y=1022410
X1457 837 72 772 1 2 848 MUX2X1 $T=794880 1038480 1 0 $X=794450 $Y=1033925
X1458 844 246 249 1 2 850 MUX2X1 $T=797680 1124720 0 0 $X=797250 $Y=1124330
X1459 818 70 837 1 2 856 MUX2X1 $T=801600 1038480 0 0 $X=801170 $Y=1038090
X1460 216 70 253 1 2 865 MUX2X1 $T=803840 967920 0 0 $X=803410 $Y=967530
X1461 790 70 860 1 2 866 MUX2X1 $T=803840 983600 0 0 $X=803410 $Y=983210
X1462 255 70 839 1 2 855 MUX2X1 $T=811120 999280 1 180 $X=805090 $Y=998890
X1463 852 72 256 1 2 869 MUX2X1 $T=806080 960080 0 0 $X=805650 $Y=959690
X1464 872 70 818 1 2 867 MUX2X1 $T=815600 1038480 1 180 $X=809570 $Y=1038090
X1465 860 70 852 1 2 880 MUX2X1 $T=812240 983600 0 0 $X=811810 $Y=983210
X1466 852 70 876 1 2 884 MUX2X1 $T=813920 999280 0 0 $X=813490 $Y=998890
X1467 876 70 872 1 2 885 MUX2X1 $T=813920 1022800 1 0 $X=813490 $Y=1018245
X1468 253 70 261 1 2 888 MUX2X1 $T=814480 960080 0 0 $X=814050 $Y=959690
X1469 883 144 720 1 2 874 MUX2X1 $T=820080 1062000 0 180 $X=814050 $Y=1057445
X1470 860 72 260 1 2 875 MUX2X1 $T=820640 975760 0 180 $X=814610 $Y=971205
X1471 876 72 257 1 2 902 MUX2X1 $T=820640 975760 1 0 $X=820210 $Y=971205
X1472 903 144 788 1 2 894 MUX2X1 $T=827920 983600 1 180 $X=821890 $Y=983210
X1473 910 144 716 1 2 898 MUX2X1 $T=830160 1038480 0 180 $X=824130 $Y=1033925
X1474 911 144 707 1 2 899 MUX2X1 $T=830160 1046320 1 180 $X=824130 $Y=1045930
X1475 912 144 531 1 2 901 MUX2X1 $T=830720 1030640 1 180 $X=824690 $Y=1030250
X1476 921 144 267 1 2 914 MUX2X1 $T=835200 952240 1 180 $X=829170 $Y=951850
X1477 933 144 260 1 2 928 MUX2X1 $T=843600 952240 1 180 $X=837570 $Y=951850
X1478 261 72 943 1 2 948 MUX2X1 $T=843600 967920 0 0 $X=843170 $Y=967530
X1479 944 144 275 1 2 936 MUX2X1 $T=849200 991440 0 180 $X=843170 $Y=986885
X1480 872 72 945 1 2 949 MUX2X1 $T=843600 1046320 1 0 $X=843170 $Y=1041765
X1481 839 72 946 1 2 950 MUX2X1 $T=843600 1062000 1 0 $X=843170 $Y=1057445
X1482 951 144 770 1 2 937 MUX2X1 $T=850880 999280 0 180 $X=844850 $Y=994725
X1483 952 144 771 1 2 938 MUX2X1 $T=850880 1007120 0 180 $X=844850 $Y=1002565
X1484 953 144 530 1 2 939 MUX2X1 $T=850880 1030640 1 180 $X=844850 $Y=1030250
X1485 955 144 715 1 2 941 MUX2X1 $T=851440 1030640 0 180 $X=845410 $Y=1026085
X1486 958 224 960 1 2 967 MUX2X1 $T=854240 999280 1 0 $X=853810 $Y=994725
X1487 282 283 829 1 2 279 MUX2X1 $T=866560 1124720 1 180 $X=860530 $Y=1124330
X1488 284 283 896 1 2 280 MUX2X1 $T=867680 1124720 0 180 $X=861650 $Y=1120165
X1489 978 144 945 1 2 971 MUX2X1 $T=870480 1046320 1 180 $X=864450 $Y=1045930
X1490 983 144 223 1 2 974 MUX2X1 $T=872160 952240 1 180 $X=866130 $Y=951850
X1491 984 144 257 1 2 975 MUX2X1 $T=872160 967920 0 180 $X=866130 $Y=963365
X1492 289 144 288 1 2 286 MUX2X1 $T=873280 952240 0 180 $X=867250 $Y=947685
X1493 994 144 946 1 2 979 MUX2X1 $T=874400 1062000 0 180 $X=868370 $Y=1057445
X1494 995 144 816 1 2 980 MUX2X1 $T=874400 1069840 0 180 $X=868370 $Y=1065285
X1495 985 144 943 1 2 997 MUX2X1 $T=870480 983600 1 0 $X=870050 $Y=979045
X1496 986 283 233 1 2 1006 MUX2X1 $T=885600 1093360 0 180 $X=879570 $Y=1088805
X1497 1024 283 248 1 2 1019 MUX2X1 $T=893440 1093360 1 180 $X=887410 $Y=1092970
X1498 988 283 897 1 2 1022 MUX2X1 $T=895120 1124720 0 180 $X=889090 $Y=1120165
X1499 1067 283 272 1 2 1058 MUX2X1 $T=914160 1077680 1 180 $X=908130 $Y=1077290
X1500 1078 283 277 1 2 1072 MUX2X1 $T=920320 1007120 0 180 $X=914290 $Y=1002565
X1501 1079 283 981 1 2 1073 MUX2X1 $T=920880 983600 1 180 $X=914850 $Y=983210
X1502 1087 283 290 1 2 1098 MUX2X1 $T=924800 991440 1 0 $X=924370 $Y=986885
X1503 1095 283 738 1 2 1086 MUX2X1 $T=930400 1054160 0 180 $X=924370 $Y=1049605
X1504 1100 283 757 1 2 1091 MUX2X1 $T=932080 1046320 0 180 $X=926050 $Y=1041765
X1505 1101 283 966 1 2 1092 MUX2X1 $T=932640 1014960 1 180 $X=926610 $Y=1014570
X1506 1103 70 1088 1 2 306 MUX2X1 $T=932640 1101200 0 180 $X=926610 $Y=1096645
X1507 1107 283 1053 1 2 1112 MUX2X1 $T=937120 1038480 0 0 $X=936690 $Y=1038090
X1508 1127 70 1115 1 2 1121 MUX2X1 $T=951680 1085520 1 180 $X=945650 $Y=1085130
X1509 1129 283 269 1 2 1122 MUX2X1 $T=953360 975760 0 180 $X=947330 $Y=971205
X1510 1132 70 1109 1 2 314 MUX2X1 $T=953920 1109040 0 180 $X=947890 $Y=1104485
X1511 1134 283 1056 1 2 1123 MUX2X1 $T=954480 1030640 0 180 $X=948450 $Y=1026085
X1512 1137 283 1014 1 2 1130 MUX2X1 $T=957840 999280 1 180 $X=951810 $Y=998890
X1513 1138 283 307 1 2 1131 MUX2X1 $T=957840 1007120 1 180 $X=951810 $Y=1006730
X1514 1135 70 1126 1 2 1142 MUX2X1 $T=953920 1093360 1 0 $X=953490 $Y=1088805
X1515 1136 70 1143 1 2 1145 MUX2X1 $T=955040 1093360 0 0 $X=954610 $Y=1092970
X1516 1146 283 802 1 2 1140 MUX2X1 $T=962320 1030640 0 180 $X=956290 $Y=1026085
X1517 1148 70 1111 1 2 1141 MUX2X1 $T=962880 1116880 0 180 $X=956850 $Y=1112325
X1518 1150 70 1154 1 2 1157 MUX2X1 $T=962880 1062000 1 0 $X=962450 $Y=1057445
X1519 317 70 1158 1 2 1162 MUX2X1 $T=964560 1093360 1 0 $X=964130 $Y=1088805
X1520 1160 70 1108 1 2 1151 MUX2X1 $T=970720 1093360 1 180 $X=964690 $Y=1092970
X1521 318 283 251 1 2 1153 MUX2X1 $T=971840 952240 0 180 $X=965810 $Y=947685
X1522 1172 283 305 1 2 1163 MUX2X1 $T=979680 952240 0 180 $X=973650 $Y=947685
X1523 1173 70 1169 1 2 1167 MUX2X1 $T=981920 1077680 0 180 $X=975890 $Y=1073125
X1524 319 70 1174 1 2 1176 MUX2X1 $T=982480 967920 1 0 $X=982050 $Y=963365
X1525 1175 70 1177 1 2 1184 MUX2X1 $T=985840 1062000 1 0 $X=985410 $Y=1057445
X1526 1192 70 1181 1 2 1188 MUX2X1 $T=1001520 983600 1 180 $X=995490 $Y=983210
X1527 1193 70 1178 1 2 1190 MUX2X1 $T=1002640 1046320 0 180 $X=996610 $Y=1041765
X1528 1194 70 1185 1 2 1191 MUX2X1 $T=1003200 1014960 1 180 $X=997170 $Y=1014570
X1529 321 70 1183 1 2 1195 MUX2X1 $T=998160 991440 1 0 $X=997730 $Y=986885
X1530 1204 70 1186 1 2 322 MUX2X1 $T=1007680 975760 0 180 $X=1001650 $Y=971205
X1531 1199 70 324 1 2 1207 MUX2X1 $T=1004320 952240 1 0 $X=1003890 $Y=947685
X1532 1200 70 1203 1 2 1208 MUX2X1 $T=1004320 967920 1 0 $X=1003890 $Y=963365
X1533 1205 70 1179 1 2 1209 MUX2X1 $T=1004880 1046320 1 0 $X=1004450 $Y=1041765
X1534 1189 70 1182 1 2 1201 MUX2X1 $T=1011040 983600 1 180 $X=1005010 $Y=983210
X1535 1206 70 1196 1 2 1202 MUX2X1 $T=1011040 1014960 1 180 $X=1005010 $Y=1014570
X1536 348 347 4 1 2 3 NAND3X1 $T=592720 952240 0 0 $X=592290 $Y=951850
X1537 10 9 351 1 2 348 NAND3X1 $T=602240 952240 1 180 $X=597890 $Y=951850
X1538 10 354 12 1 2 355 NAND3X1 $T=606160 960080 0 180 $X=601810 $Y=955525
X1539 357 15 353 1 2 352 NAND3X1 $T=606720 952240 0 180 $X=602370 $Y=947685
X1540 10 16 356 1 2 357 NAND3X1 $T=603360 952240 0 0 $X=602930 $Y=951850
X1541 359 361 23 1 2 363 NAND3X1 $T=607280 975760 1 0 $X=606850 $Y=971205
X1542 21 363 367 1 2 364 NAND3X1 $T=609520 967920 0 0 $X=609090 $Y=967530
X1543 35 381 372 1 2 384 NAND3X1 $T=621280 960080 1 180 $X=616930 $Y=959690
X1544 378 380 387 1 2 385 NAND3X1 $T=617360 967920 0 0 $X=616930 $Y=967530
X1545 396 376 391 1 2 389 NAND3X1 $T=625760 991440 1 180 $X=621410 $Y=991050
X1546 414 408 398 1 2 411 NAND3X1 $T=631920 999280 0 180 $X=627570 $Y=994725
X1547 404 413 407 1 2 415 NAND3X1 $T=628560 967920 0 0 $X=628130 $Y=967530
X1548 393 410 426 1 2 420 NAND3X1 $T=630800 991440 1 0 $X=630370 $Y=986885
X1549 424 416 54 1 2 414 NAND3X1 $T=635280 975760 1 180 $X=630930 $Y=975370
X1550 402 444 448 1 2 69 NAND3X1 $T=636960 960080 1 0 $X=636530 $Y=955525
X1551 368 445 441 1 2 451 NAND3X1 $T=638080 991440 1 0 $X=637650 $Y=986885
X1552 446 452 41 1 2 450 NAND3X1 $T=639200 967920 0 0 $X=638770 $Y=967530
X1553 433 450 457 1 2 458 NAND3X1 $T=639200 999280 0 0 $X=638770 $Y=998890
X1554 76 459 41 1 2 424 NAND3X1 $T=644800 967920 0 180 $X=640450 $Y=963365
X1555 436 425 470 1 2 468 NAND3X1 $T=640880 999280 1 0 $X=640450 $Y=994725
X1556 463 471 477 1 2 476 NAND3X1 $T=642560 1014960 1 0 $X=642130 $Y=1010405
X1557 482 54 41 1 2 473 NAND3X1 $T=648160 967920 1 180 $X=643810 $Y=967530
X1558 401 479 419 1 2 480 NAND3X1 $T=644240 983600 1 0 $X=643810 $Y=979045
X1559 421 488 493 1 2 467 NAND3X1 $T=646480 1007120 0 0 $X=646050 $Y=1006730
X1560 495 492 469 1 2 486 NAND3X1 $T=652080 999280 0 180 $X=647730 $Y=994725
X1561 484 500 496 1 2 502 NAND3X1 $T=651520 1007120 1 0 $X=651090 $Y=1002565
X1562 483 93 503 1 2 507 NAND3X1 $T=653200 975760 1 0 $X=652770 $Y=971205
X1563 516 518 526 1 2 521 NAND3X1 $T=658240 967920 0 0 $X=657810 $Y=967530
X1564 508 525 528 1 2 523 NAND3X1 $T=659360 1007120 1 0 $X=658930 $Y=1002565
X1565 522 535 519 1 2 544 NAND3X1 $T=662160 983600 1 0 $X=661730 $Y=979045
X1566 498 537 547 1 2 545 NAND3X1 $T=662720 1007120 0 0 $X=662290 $Y=1006730
X1567 108 548 555 1 2 554 NAND3X1 $T=664960 975760 0 0 $X=664530 $Y=975370
X1568 559 556 512 1 2 549 NAND3X1 $T=670560 1007120 0 180 $X=666210 $Y=1002565
X1569 552 557 536 1 2 560 NAND3X1 $T=667200 991440 1 0 $X=666770 $Y=986885
X1570 388 567 575 1 2 120 NAND3X1 $T=670560 983600 0 0 $X=670130 $Y=983210
X1571 501 123 577 1 2 579 NAND3X1 $T=672240 1014960 1 0 $X=671810 $Y=1010405
X1572 443 583 585 1 2 561 NAND3X1 $T=674480 1007120 0 0 $X=674050 $Y=1006730
X1573 578 590 591 1 2 595 NAND3X1 $T=677840 999280 0 0 $X=677410 $Y=998890
X1574 576 473 593 1 2 598 NAND3X1 $T=678400 991440 0 0 $X=677970 $Y=991050
X1575 609 625 584 1 2 621 NAND3X1 $T=689040 999280 1 0 $X=688610 $Y=994725
X1576 151 617 614 1 2 637 NAND3X1 $T=692400 1007120 0 0 $X=691970 $Y=1006730
X1577 157 644 546 1 2 649 NAND3X1 $T=695760 999280 1 0 $X=695330 $Y=994725
X1578 627 641 640 1 2 650 NAND3X1 $T=695760 1007120 1 0 $X=695330 $Y=1002565
X1579 517 629 613 1 2 654 NAND3X1 $T=699120 999280 0 0 $X=698690 $Y=998890
X1580 655 657 653 1 2 155 NAND3X1 $T=705840 975760 0 180 $X=701490 $Y=971205
X1581 658 663 666 1 2 643 NAND3X1 $T=705280 983600 1 0 $X=704850 $Y=979045
X1582 661 663 667 1 2 466 NAND3X1 $T=705840 975760 0 0 $X=705410 $Y=975370
X1583 175 173 50 1 2 660 NAND3X1 $T=710880 952240 0 180 $X=706530 $Y=947685
X1584 656 616 506 1 2 669 NAND3X1 $T=706960 999280 1 0 $X=706530 $Y=994725
X1585 180 681 675 1 2 185 NAND3X1 $T=715920 952240 1 0 $X=715490 $Y=947685
X1586 193 191 687 1 2 612 NAND3X1 $T=724320 952240 1 180 $X=719970 $Y=951850
X1587 694 192 181 1 2 692 NAND3X1 $T=724320 1116880 0 180 $X=719970 $Y=1112325
X1588 692 693 698 1 2 695 NAND3X1 $T=720960 1101200 0 0 $X=720530 $Y=1100810
X1589 194 195 182 1 2 698 NAND3X1 $T=723200 1109040 1 0 $X=722770 $Y=1104485
X1590 719 209 182 1 2 729 NAND3X1 $T=736080 1101200 1 0 $X=735650 $Y=1096645
X1591 721 196 714 1 2 208 NAND3X1 $T=740000 1109040 0 180 $X=735650 $Y=1104485
X1592 732 728 209 1 2 708 NAND3X1 $T=741120 1109040 1 180 $X=736770 $Y=1108650
X1593 713 730 205 1 2 733 NAND3X1 $T=737200 1116880 0 0 $X=736770 $Y=1116490
X1594 735 733 690 1 2 734 NAND3X1 $T=743360 1101200 1 180 $X=739010 $Y=1100810
X1595 753 754 729 1 2 761 NAND3X1 $T=749520 1101200 0 0 $X=749090 $Y=1100810
X1596 787 792 806 1 2 808 NAND3X1 $T=782000 1101200 0 0 $X=781570 $Y=1100810
X1597 808 824 800 1 2 827 NAND3X1 $T=788720 1101200 0 0 $X=788290 $Y=1100810
X1598 849 854 838 1 2 853 NAND3X1 $T=807760 1109040 0 180 $X=803410 $Y=1104485
X1599 862 864 842 1 2 861 NAND3X1 $T=811120 1101200 0 180 $X=806770 $Y=1096645
X1600 871 882 841 1 2 887 NAND3X1 $T=816160 1101200 0 0 $X=815730 $Y=1100810
X1601 881 845 263 1 2 889 NAND3X1 $T=816720 1124720 1 0 $X=816290 $Y=1120165
X1602 895 900 843 1 2 906 NAND3X1 $T=823440 1101200 1 0 $X=823010 $Y=1096645
X1603 266 857 270 1 2 919 NAND3X1 $T=828480 1124720 0 0 $X=828050 $Y=1124330
X1604 927 858 273 1 2 934 NAND3X1 $T=839120 1124720 1 0 $X=838690 $Y=1120165
X1605 976 973 859 1 2 972 NAND3X1 $T=868240 1093360 1 180 $X=863890 $Y=1092970
X1606 1005 1003 957 1 2 1000 NAND3X1 $T=881120 1038480 1 180 $X=876770 $Y=1038090
X1607 1007 1001 1010 1 2 1012 NAND3X1 $T=882800 1062000 0 0 $X=882370 $Y=1061610
X1608 1013 1011 1002 1 2 1008 NAND3X1 $T=887280 999280 1 180 $X=882930 $Y=998890
X1609 1020 1015 1009 1 2 1017 NAND3X1 $T=889520 1022800 0 180 $X=885170 $Y=1018245
X1610 1031 1025 1016 1 2 1023 NAND3X1 $T=894560 960080 0 180 $X=890210 $Y=955525
X1611 1041 1039 1036 1 2 1040 NAND3X1 $T=902400 1022800 0 180 $X=898050 $Y=1018245
X1612 1042 1044 1004 1 2 1046 NAND3X1 $T=904640 1007120 1 180 $X=900290 $Y=1006730
X1613 1052 1051 1038 1 2 1050 NAND3X1 $T=908000 1038480 0 180 $X=903650 $Y=1033925
X1614 1060 1057 1021 1 2 1055 NAND3X1 $T=911360 991440 0 180 $X=907010 $Y=986885
X1615 1076 1071 998 1 2 1070 NAND3X1 $T=916960 1007120 1 180 $X=912610 $Y=1006730
X1616 1085 303 1034 1 2 1081 NAND3X1 $T=925920 975760 0 180 $X=921570 $Y=971205
X1617 1089 304 1037 1 2 1083 NAND3X1 $T=927600 952240 0 180 $X=923250 $Y=947685
X1618 1117 1114 1026 1 2 1110 NAND3X1 $T=944960 967920 0 180 $X=940610 $Y=963365
X1619 126 1 2 574 BUFX1 $T=676160 1109040 0 180 $X=672930 $Y=1104485
X1620 574 1 2 588 BUFX1 $T=677280 1101200 0 0 $X=676850 $Y=1100810
X1621 588 1 2 594 BUFX1 $T=682880 1062000 0 180 $X=679650 $Y=1057445
X1622 588 1 2 602 BUFX1 $T=681200 1101200 0 0 $X=680770 $Y=1100810
X1623 588 1 2 659 BUFX1 $T=703040 1077680 0 0 $X=702610 $Y=1077290
X1624 759 1 2 755 BUFX1 $T=752880 1022800 0 180 $X=749650 $Y=1018245
X1625 759 1 2 762 BUFX1 $T=756800 1022800 0 180 $X=753570 $Y=1018245
X1626 759 1 2 225 BUFX1 $T=775280 952240 0 180 $X=772050 $Y=947685
X1627 759 1 2 226 BUFX1 $T=775280 975760 0 180 $X=772050 $Y=971205
X1628 126 1 2 759 BUFX1 $T=777520 1030640 0 180 $X=774290 $Y=1026085
X1629 126 1 2 851 BUFX1 $T=801040 1109040 1 0 $X=800610 $Y=1104485
X1630 851 1 2 909 BUFX1 $T=825680 1109040 1 0 $X=825250 $Y=1104485
X1631 909 1 2 920 BUFX1 $T=834080 1101200 0 180 $X=830850 $Y=1096645
X1632 909 1 2 926 BUFX1 $T=834080 1109040 1 0 $X=833650 $Y=1104485
X1633 931 1 2 929 BUFX1 $T=840800 991440 0 180 $X=837570 $Y=986885
X1634 931 1 2 930 BUFX1 $T=841360 1022800 0 180 $X=838130 $Y=1018245
X1635 931 1 2 274 BUFX1 $T=841360 960080 0 0 $X=840930 $Y=959690
X1636 926 1 2 935 BUFX1 $T=844720 1109040 0 180 $X=841490 $Y=1104485
X1637 126 1 2 931 BUFX1 $T=845280 1022800 0 180 $X=842050 $Y=1018245
X1638 926 1 2 276 BUFX1 $T=851440 1116880 0 0 $X=851010 $Y=1116490
X1639 931 1 2 968 BUFX1 $T=863200 1022800 0 180 $X=859970 $Y=1018245
X1640 126 1 2 293 BUFX1 $T=888400 967920 1 0 $X=887970 $Y=963365
X1641 126 1 2 1032 BUFX1 $T=892880 1101200 0 0 $X=892450 $Y=1100810
X1642 1032 1 2 295 BUFX1 $T=899600 1101200 1 180 $X=896370 $Y=1100810
X1643 1032 1 2 1043 BUFX1 $T=899600 1093360 0 0 $X=899170 $Y=1092970
X1644 931 1 2 1047 BUFX1 $T=905200 1022800 0 180 $X=901970 $Y=1018245
X1645 1032 1 2 300 BUFX1 $T=914720 1093360 0 0 $X=914290 $Y=1092970
X1646 126 1 2 301 BUFX1 $T=916400 960080 0 0 $X=915970 $Y=959690
X1647 301 1 2 1084 BUFX1 $T=927040 960080 1 180 $X=923810 $Y=959690
X1648 301 1 2 1106 BUFX1 $T=934880 967920 1 0 $X=934450 $Y=963365
X1649 1032 1 2 1116 BUFX1 $T=946080 1062000 0 180 $X=942850 $Y=1057445
X1650 1120 1 2 1118 BUFX1 $T=947200 1046320 0 180 $X=943970 $Y=1041765
X1651 1032 1 2 1120 BUFX1 $T=948880 1054160 0 180 $X=945650 $Y=1049605
X1652 1032 1 2 1125 BUFX1 $T=947200 1062000 1 0 $X=946770 $Y=1057445
X1653 301 1 2 316 BUFX1 $T=961760 960080 0 0 $X=961330 $Y=959690
X1654 301 1 2 1152 BUFX1 $T=964000 967920 0 0 $X=963570 $Y=967530
X1655 1152 1 2 1159 BUFX1 $T=966800 975760 0 0 $X=966370 $Y=975370
X1679 1 126 ANTENNA $T=676720 1109040 1 0 $X=676290 $Y=1104485
X1680 1 126 ANTENNA $T=677840 1109040 1 0 $X=677410 $Y=1104485
X1681 350 349 1 2 347 AND2X1 $T=596080 960080 0 180 $X=592290 $Y=955525
X1682 382 30 1 2 366 AND2X1 $T=620160 952240 0 180 $X=616370 $Y=947685
X1683 36 53 1 2 429 AND2X1 $T=631920 967920 1 0 $X=631490 $Y=963365
X1684 432 29 1 2 423 AND2X1 $T=636960 991440 1 180 $X=633170 $Y=991050
X1685 409 54 1 2 437 AND2X1 $T=640320 975760 1 180 $X=636530 $Y=975370
X1686 472 26 1 2 481 AND2X1 $T=649840 967920 0 180 $X=646050 $Y=963365
X1687 487 491 1 2 492 AND2X1 $T=647600 991440 0 0 $X=647170 $Y=991050
X1688 85 59 1 2 369 AND2X1 $T=652640 952240 1 180 $X=648850 $Y=951850
X1689 85 55 1 2 499 AND2X1 $T=655440 960080 0 180 $X=651650 $Y=955525
X1690 71 94 1 2 510 AND2X1 $T=653760 991440 1 0 $X=653330 $Y=986885
X1691 612 38 1 2 610 AND2X1 $T=685120 991440 0 0 $X=684690 $Y=991050
X1692 514 29 1 2 628 AND2X1 $T=689600 991440 1 0 $X=689170 $Y=986885
X1693 611 624 1 2 641 AND2X1 $T=694080 999280 0 0 $X=693650 $Y=998890
X1694 714 204 1 2 195 AND2X1 $T=734400 1109040 0 180 $X=730610 $Y=1104485
X1695 200 736 1 2 746 AND2X1 $T=743920 1124720 0 0 $X=743490 $Y=1124330
X1696 768 221 1 2 220 AND2X1 $T=756800 1124720 1 180 $X=753010 $Y=1124330
X1697 817 247 1 2 847 AND2X1 $T=803280 1116880 1 180 $X=799490 $Y=1116490
X1698 873 262 1 2 881 AND2X1 $T=816720 1124720 0 0 $X=816290 $Y=1124330
X1699 268 915 1 2 913 AND2X1 $T=832400 999280 1 180 $X=828610 $Y=998890
X1700 1035 230 1 2 1030 AND2X1 $T=896800 991440 1 0 $X=896370 $Y=986885
X1701 298 1024 1 2 1045 AND2X1 $T=905200 1116880 1 180 $X=901410 $Y=1116490
X1702 298 986 1 2 1048 AND2X1 $T=907440 1085520 1 180 $X=903650 $Y=1085130
X1703 298 988 1 2 1065 AND2X1 $T=908000 1116880 0 0 $X=907570 $Y=1116490
X1704 298 987 1 2 1074 AND2X1 $T=913040 1116880 1 0 $X=912610 $Y=1112325
X1705 298 1068 1 2 1080 AND2X1 $T=924800 1109040 1 180 $X=921010 $Y=1108650
X1706 298 1067 1 2 1082 AND2X1 $T=926480 1085520 0 180 $X=922690 $Y=1080965
X1707 298 1066 1 2 1097 AND2X1 $T=932640 1069840 1 180 $X=928850 $Y=1069450
X1708 298 1102 1 2 1105 AND2X1 $T=938800 1069840 1 180 $X=935010 $Y=1069450
X1709 298 1101 1 2 1119 AND2X1 $T=943280 1022800 1 0 $X=942850 $Y=1018245
X1710 298 1095 1 2 1124 AND2X1 $T=952240 1054160 0 180 $X=948450 $Y=1049605
X1711 298 1099 1 2 1128 AND2X1 $T=953360 1046320 1 180 $X=949570 $Y=1045930
X1712 298 1069 1 2 1133 AND2X1 $T=950000 1062000 1 0 $X=949570 $Y=1057445
X1713 298 1138 1 2 1139 AND2X1 $T=959520 1046320 1 180 $X=955730 $Y=1045930
X1714 298 1079 1 2 1147 AND2X1 $T=958400 983600 0 0 $X=957970 $Y=983210
X1715 298 1078 1 2 1155 AND2X1 $T=970160 1007120 0 180 $X=966370 $Y=1002565
X1716 298 1134 1 2 1156 AND2X1 $T=970160 1030640 0 180 $X=966370 $Y=1026085
X1717 298 1100 1 2 1161 AND2X1 $T=972400 1046320 1 180 $X=968610 $Y=1045930
X1718 298 1146 1 2 1166 AND2X1 $T=972960 1030640 1 0 $X=972530 $Y=1026085
X1719 298 1137 1 2 1164 AND2X1 $T=978560 1007120 0 180 $X=974770 $Y=1002565
X1720 298 1107 1 2 1165 AND2X1 $T=978560 1046320 1 180 $X=974770 $Y=1045930
X1721 298 1129 1 2 1168 AND2X1 $T=980240 967920 1 180 $X=976450 $Y=967530
X1722 298 1172 1 2 1170 AND2X1 $T=980800 983600 0 180 $X=977010 $Y=979045
X1723 298 1087 1 2 1171 AND2X1 $T=980800 991440 0 180 $X=977010 $Y=986885
X1724 298 320 1 2 1180 AND2X1 $T=987520 952240 1 0 $X=987090 $Y=947685
X1794 1 2 373 378 32 ICV_59 $T=615680 960080 1 0 $X=615250 $Y=955525
X1795 1 2 42 381 48 ICV_59 $T=622960 960080 1 0 $X=622530 $Y=955525
X1796 1 2 31 402 48 ICV_59 $T=626320 960080 1 0 $X=625890 $Y=955525
X1797 1 2 25 403 417 ICV_59 $T=630240 952240 1 0 $X=629810 $Y=947685
X1798 1 2 453 80 82 ICV_59 $T=647040 952240 1 0 $X=646610 $Y=947685
X1799 1 2 51 491 53 ICV_59 $T=648160 983600 1 0 $X=647730 $Y=979045
X1800 1 2 85 512 99 ICV_59 $T=655440 960080 1 0 $X=655010 $Y=955525
X1801 1 2 81 616 146 ICV_59 $T=686240 983600 1 0 $X=685810 $Y=979045
X1802 1 2 563 119 148 ICV_59 $T=691280 960080 0 0 $X=690850 $Y=959690
X1803 1 2 619 14 153 ICV_59 $T=691840 967920 1 0 $X=691410 $Y=963365
X1804 1 2 134 137 165 ICV_59 $T=700240 952240 1 0 $X=699810 $Y=947685
X1805 1 2 45 172 382 ICV_59 $T=703600 952240 1 0 $X=703170 $Y=947685
X1806 1 2 831 833 834 ICV_59 $T=792640 1085520 0 0 $X=792210 $Y=1085130
X1807 1 2 814 834 836 ICV_59 $T=793200 1085520 1 0 $X=792770 $Y=1080965
X1808 1 2 232 895 896 ICV_59 $T=820080 1101200 0 0 $X=819650 $Y=1100810
X1809 1 2 224 915 903 ICV_59 $T=828480 999280 1 0 $X=828050 $Y=994725
X1810 1 2 990 993 992 ICV_59 $T=870480 1030640 0 0 $X=870050 $Y=1030250
X1811 1 2 991 990 229 ICV_59 $T=870480 1038480 1 0 $X=870050 $Y=1033925
X1812 1 2 245 1021 955 ICV_59 $T=887280 991440 0 0 $X=886850 $Y=991050
X1813 1 2 232 1020 863 ICV_59 $T=887280 1030640 0 0 $X=886850 $Y=1030250
X1814 1 2 232 1042 1014 ICV_59 $T=899600 999280 1 0 $X=899170 $Y=994725
X1815 1 2 375 377 379 ICV_55 $T=613440 983600 0 0 $X=613010 $Y=983210
X1816 1 2 86 487 91 ICV_55 $T=648720 999280 0 0 $X=648290 $Y=998890
X1817 1 2 71 426 520 ICV_55 $T=655440 991440 0 0 $X=655010 $Y=991050
X1818 1 2 43 591 91 ICV_55 $T=676160 1007120 1 0 $X=675730 $Y=1002565
X1819 1 2 45 585 138 ICV_55 $T=678400 1007120 0 0 $X=677970 $Y=1006730
X1820 1 2 78 617 138 ICV_55 $T=684000 1007120 0 0 $X=683570 $Y=1006730
X1821 1 2 136 570 665 ICV_55 $T=703600 960080 1 0 $X=703170 $Y=955525
X1822 1 2 45 675 374 ICV_55 $T=709200 960080 1 0 $X=708770 $Y=955525
X1823 1 2 176 687 632 ICV_55 $T=714800 960080 1 0 $X=714370 $Y=955525
X1824 1 2 164 666 154 ICV_55 $T=715360 975760 0 0 $X=714930 $Y=975370
X1825 1 2 696 705 709 ICV_55 $T=724320 1116880 1 0 $X=723890 $Y=1112325
X1826 1 2 718 732 736 ICV_55 $T=740000 1116880 1 0 $X=739570 $Y=1112325
X1827 1 2 817 858 254 ICV_55 $T=803280 1116880 0 0 $X=802850 $Y=1116490
X1828 1 2 224 923 272 ICV_55 $T=835760 1077680 1 0 $X=835330 $Y=1073125
X1829 1 2 1029 1031 229 ICV_55 $T=893440 952240 0 0 $X=893010 $Y=951850
X1830 1 2 232 1041 1056 ICV_55 $T=903520 1014960 0 0 $X=903090 $Y=1014570
X1831 1 2 229 1114 251 ICV_55 $T=947760 967920 1 0 $X=947330 $Y=963365
X1832 1 2 17 353 22 ICV_58 $T=608400 952240 1 0 $X=607970 $Y=947685
X1833 1 2 38 394 40 ICV_58 $T=621840 983600 1 0 $X=621410 $Y=979045
X1834 1 2 38 397 51 ICV_58 $T=626320 975760 0 0 $X=625890 $Y=975370
X1835 1 2 52 410 53 ICV_58 $T=628000 983600 0 0 $X=627570 $Y=983210
X1836 1 2 43 405 33 ICV_58 $T=628000 999280 0 0 $X=627570 $Y=998890
X1837 1 2 412 425 60 ICV_58 $T=633040 983600 0 0 $X=632610 $Y=983210
X1838 1 2 68 471 38 ICV_58 $T=644800 991440 1 0 $X=644370 $Y=986885
X1839 1 2 100 493 102 ICV_58 $T=657680 999280 0 0 $X=657250 $Y=998890
X1840 1 2 104 522 29 ICV_58 $T=659920 975760 0 0 $X=659490 $Y=975370
X1841 1 2 105 524 527 ICV_58 $T=659920 999280 1 0 $X=659490 $Y=994725
X1842 1 2 98 104 106 ICV_58 $T=661040 952240 1 0 $X=660610 $Y=947685
X1843 1 2 85 546 112 ICV_58 $T=664960 952240 0 0 $X=664530 $Y=951850
X1844 1 2 86 557 520 ICV_58 $T=667760 991440 0 0 $X=667330 $Y=991050
X1845 1 2 529 110 117 ICV_58 $T=668880 960080 1 0 $X=668450 $Y=955525
X1846 1 2 78 575 127 ICV_58 $T=673920 983600 1 0 $X=673490 $Y=979045
X1847 1 2 45 590 37 ICV_58 $T=678400 999280 1 0 $X=677970 $Y=994725
X1848 1 2 597 31 137 ICV_58 $T=681200 960080 1 0 $X=680770 $Y=955525
X1849 1 2 134 600 606 ICV_58 $T=682320 975760 0 0 $X=681890 $Y=975370
X1850 1 2 514 625 60 ICV_58 $T=690160 983600 0 0 $X=689730 $Y=983210
X1851 1 2 136 563 632 ICV_58 $T=691280 960080 1 0 $X=690850 $Y=955525
X1852 1 2 136 558 647 ICV_58 $T=696880 975760 1 0 $X=696450 $Y=971205
X1853 1 2 158 658 50 ICV_58 $T=703600 960080 0 0 $X=703170 $Y=959690
X1854 1 2 181 682 683 ICV_58 $T=715920 1101200 0 0 $X=715490 $Y=1100810
X1855 1 2 680 691 190 ICV_58 $T=719840 1124720 0 0 $X=719410 $Y=1124330
X1856 1 2 207 713 210 ICV_58 $T=736640 1124720 0 0 $X=736210 $Y=1124330
X1857 1 2 718 730 206 ICV_58 $T=738320 1124720 1 0 $X=737890 $Y=1120165
X1858 1 2 742 754 210 ICV_58 $T=748960 1109040 1 0 $X=748530 $Y=1104485
X1859 1 2 695 800 801 ICV_58 $T=776960 1101200 0 0 $X=776530 $Y=1100810
X1860 1 2 232 849 806 ICV_58 $T=801600 1101200 0 0 $X=801170 $Y=1100810
X1861 1 2 232 862 228 ICV_58 $T=806640 1101200 0 0 $X=806210 $Y=1100810
X1862 1 2 229 882 197 ICV_58 $T=816720 1101200 1 0 $X=816290 $Y=1096645
X1863 1 2 1027 1062 1063 ICV_58 $T=908000 952240 0 0 $X=907570 $Y=951850
X1864 1 2 224 1064 302 ICV_58 $T=916960 952240 1 0 $X=916530 $Y=947685
X1865 1 2 371 367 26 ICV_61 $T=613440 967920 1 0 $X=613010 $Y=963365
X1866 1 2 384 393 23 ICV_61 $T=621840 975760 0 0 $X=621410 $Y=975370
X1867 1 2 383 49 397 ICV_61 $T=624080 967920 0 0 $X=623650 $Y=967530
X1868 1 2 400 404 406 ICV_61 $T=627440 967920 1 0 $X=627010 $Y=963365
X1869 1 2 58 422 29 ICV_61 $T=632480 975760 1 0 $X=632050 $Y=971205
X1870 1 2 60 445 432 ICV_61 $T=638080 983600 0 0 $X=637650 $Y=983210
X1871 1 2 454 434 462 ICV_61 $T=640880 1007120 1 0 $X=640450 $Y=1002565
X1872 1 2 45 469 442 ICV_61 $T=643120 991440 0 0 $X=642690 $Y=991050
X1873 1 2 45 503 96 ICV_61 $T=653760 967920 0 0 $X=653330 $Y=967530
X1874 1 2 417 98 50 ICV_61 $T=656560 952240 1 0 $X=656130 $Y=947685
X1875 1 2 504 513 515 ICV_61 $T=656560 983600 0 0 $X=656130 $Y=983210
X1876 1 2 71 479 102 ICV_61 $T=657680 983600 1 0 $X=657250 $Y=979045
X1877 1 2 85 525 34 ICV_61 $T=660480 952240 0 0 $X=660050 $Y=951850
X1878 1 2 71 535 107 ICV_61 $T=662160 975760 1 0 $X=661730 $Y=971205
X1879 1 2 100 526 110 ICV_61 $T=664400 960080 1 0 $X=663970 $Y=955525
X1880 1 2 85 547 447 ICV_61 $T=665520 960080 0 0 $X=665090 $Y=959690
X1881 1 2 553 101 115 ICV_61 $T=667200 967920 1 0 $X=666770 $Y=963365
X1882 1 2 86 556 33 ICV_61 $T=667760 999280 0 0 $X=667330 $Y=998890
X1883 1 2 558 39 118 ICV_61 $T=668880 967920 0 0 $X=668450 $Y=967530
X1884 1 2 558 24 566 ICV_61 $T=670560 975760 1 0 $X=670130 $Y=971205
X1885 1 2 553 409 581 ICV_61 $T=673360 967920 0 0 $X=672930 $Y=967530
X1886 1 2 78 131 374 ICV_61 $T=676160 967920 1 0 $X=675730 $Y=963365
X1887 1 2 129 77 133 ICV_61 $T=677840 952240 1 0 $X=677410 $Y=947685
X1888 1 2 553 447 589 ICV_61 $T=677840 967920 0 0 $X=677410 $Y=967530
X1889 1 2 136 571 140 ICV_61 $T=682320 967920 0 0 $X=681890 $Y=967530
X1890 1 2 136 143 603 ICV_61 $T=684000 952240 0 0 $X=683570 $Y=951850
X1891 1 2 136 553 125 ICV_61 $T=684560 967920 1 0 $X=684130 $Y=963365
X1892 1 2 100 624 119 ICV_61 $T=689600 999280 0 0 $X=689170 $Y=998890
X1893 1 2 142 107 153 ICV_61 $T=692400 975760 1 0 $X=691970 $Y=971205
X1894 1 2 136 529 159 ICV_61 $T=696320 960080 1 0 $X=695890 $Y=955525
X1895 1 2 134 581 647 ICV_61 $T=696320 967920 0 0 $X=695890 $Y=967530
X1896 1 2 136 619 633 ICV_61 $T=696880 967920 1 0 $X=696450 $Y=963365
X1897 1 2 134 153 166 ICV_61 $T=700800 967920 0 0 $X=700370 $Y=967530
X1898 1 2 62 655 50 ICV_61 $T=701360 967920 1 0 $X=700930 $Y=963365
X1899 1 2 660 177 679 ICV_61 $T=712560 967920 0 0 $X=712130 $Y=967530
X1900 1 2 194 700 186 ICV_61 $T=724320 1124720 1 0 $X=723890 $Y=1120165
X1901 1 2 232 871 829 ICV_61 $T=811680 1101200 0 0 $X=811250 $Y=1100810
X1902 1 2 392 44 46 ICV_62 $T=622960 960080 0 0 $X=622530 $Y=959690
X1903 1 2 73 457 53 ICV_62 $T=640320 983600 1 0 $X=639890 $Y=979045
X1904 1 2 417 464 8 ICV_62 $T=642000 952240 0 0 $X=641570 $Y=951850
X1905 1 2 89 504 53 ICV_62 $T=653760 983600 1 0 $X=653330 $Y=979045
X1906 1 2 85 519 62 ICV_62 $T=658800 960080 0 0 $X=658370 $Y=959690
X1907 1 2 111 551 114 ICV_62 $T=666080 952240 1 0 $X=665650 $Y=947685
X1908 1 2 85 555 24 ICV_62 $T=666640 975760 1 0 $X=666210 $Y=971205
X1909 1 2 571 22 600 ICV_62 $T=679520 975760 1 0 $X=679090 $Y=971205
X1910 1 2 128 382 139 ICV_62 $T=682320 952240 1 0 $X=681890 $Y=947685
X1911 1 2 136 128 154 ICV_62 $T=693520 952240 1 0 $X=693090 $Y=947685
X1912 1 2 587 636 60 ICV_62 $T=694080 952240 0 0 $X=693650 $Y=951850
X1913 1 2 648 161 652 ICV_62 $T=698000 952240 0 0 $X=697570 $Y=951850
X1914 1 2 558 138 162 ICV_62 $T=699680 960080 0 0 $X=699250 $Y=959690
X1915 1 2 134 162 665 ICV_62 $T=706400 952240 0 0 $X=705970 $Y=951850
X1916 1 2 195 706 196 ICV_62 $T=727120 1109040 1 0 $X=726690 $Y=1104485
X1917 1 2 200 696 195 ICV_62 $T=728800 1116880 0 0 $X=728370 $Y=1116490
X1918 1 2 252 857 241 ICV_62 $T=804960 1124720 0 0 $X=804530 $Y=1124330
X1919 1 2 45 395 5 ICV_56 $T=625760 975760 0 180 $X=622530 $Y=971205
X1920 1 2 52 401 38 ICV_56 $T=629680 983600 0 180 $X=626450 $Y=979045
X1921 1 2 412 408 29 ICV_56 $T=631360 991440 1 180 $X=628130 $Y=991050
X1922 1 2 81 470 24 ICV_56 $T=649840 983600 1 180 $X=646610 $Y=983210
X1923 1 2 78 477 509 ICV_56 $T=660480 1007120 1 180 $X=657250 $Y=1006730
X1924 1 2 100 528 520 ICV_56 $T=665520 999280 1 180 $X=662290 $Y=998890
X1925 1 2 571 509 118 ICV_56 $T=674480 975760 1 180 $X=671250 $Y=975370
X1926 1 2 128 83 543 ICV_56 $T=677280 952240 1 180 $X=674050 $Y=951850
X1927 1 2 129 18 581 ICV_56 $T=677280 960080 1 180 $X=674050 $Y=959690
X1928 1 2 81 611 494 ICV_56 $T=687360 991440 0 180 $X=684130 $Y=986885
X1929 1 2 43 613 13 ICV_56 $T=687360 999280 1 180 $X=684130 $Y=998890
X1930 1 2 612 145 53 ICV_56 $T=689040 960080 0 180 $X=685810 $Y=955525
X1931 1 2 45 629 150 ICV_56 $T=694080 967920 1 180 $X=690850 $Y=967530
X1932 1 2 642 638 156 ICV_56 $T=698000 983600 1 180 $X=694770 $Y=983210
X1933 1 2 134 133 633 ICV_56 $T=713120 952240 1 180 $X=709890 $Y=951850
X1934 1 2 86 681 122 ICV_56 $T=718160 952240 1 180 $X=714930 $Y=951850
X1935 1 2 685 184 182 ICV_56 $T=719280 1116880 1 180 $X=716050 $Y=1116490
X1936 1 2 691 690 186 ICV_56 $T=722080 1124720 0 180 $X=718850 $Y=1120165
X1937 1 2 708 694 196 ICV_56 $T=729920 1109040 1 180 $X=726690 $Y=1108650
X1938 1 2 749 752 207 ICV_56 $T=751200 1124720 0 180 $X=747970 $Y=1120165
X1939 1 2 840 836 230 ICV_56 $T=798240 1077680 1 180 $X=795010 $Y=1077290
X1940 1 2 904 891 230 ICV_56 $T=827360 1077680 1 180 $X=824130 $Y=1077290
X1941 1 2 999 996 230 ICV_56 $T=877760 991440 0 180 $X=874530 $Y=986885
X1942 1 2 229 1015 269 ICV_56 $T=887840 1014960 1 180 $X=884610 $Y=1014570
X1943 1 2 245 1026 985 ICV_56 $T=894000 967920 1 180 $X=890770 $Y=967530
X1944 1 2 916 1033 1028 ICV_56 $T=898480 1014960 1 180 $X=895250 $Y=1014570
X1945 1 2 245 1037 289 ICV_56 $T=900720 952240 0 180 $X=897490 $Y=947685
X1946 1 2 245 1036 978 ICV_56 $T=900720 1030640 1 180 $X=897490 $Y=1030250
X1947 1 2 229 1071 296 ICV_56 $T=923680 1007120 1 180 $X=920450 $Y=1006730
X1948 1 2 33 380 11 ICV_60 $T=620160 975760 1 180 $X=616930 $Y=975370
X1949 1 2 385 383 26 ICV_60 $T=620720 967920 0 180 $X=617490 $Y=963365
X1950 1 2 403 400 358 ICV_60 $T=629680 960080 1 180 $X=626450 $Y=959690
X1951 1 2 409 407 48 ICV_60 $T=630800 975760 0 180 $X=627570 $Y=971205
X1952 1 2 418 416 56 ICV_60 $T=634160 960080 1 180 $X=630930 $Y=959690
X1953 1 2 60 419 57 ICV_60 $T=634720 983600 0 180 $X=631490 $Y=979045
X1954 1 2 415 64 6 ICV_60 $T=637520 967920 1 180 $X=634290 $Y=967530
X1955 1 2 71 396 409 ICV_60 $T=641440 991440 1 180 $X=638210 $Y=991050
X1956 1 2 466 75 53 ICV_60 $T=644240 975760 1 180 $X=641010 $Y=975370
X1957 1 2 466 454 38 ICV_60 $T=645360 983600 1 180 $X=642130 $Y=983210
X1958 1 2 81 490 83 ICV_60 $T=652080 967920 1 180 $X=648850 $Y=967530
X1959 1 2 60 500 373 ICV_60 $T=654880 983600 1 180 $X=651650 $Y=983210
X1960 1 2 78 518 101 ICV_60 $T=661040 967920 0 180 $X=657810 $Y=963365
X1961 1 2 100 536 42 ICV_60 $T=665520 967920 0 180 $X=662290 $Y=963365
X1962 1 2 81 537 97 ICV_60 $T=665520 991440 0 180 $X=662290 $Y=986885
X1963 1 2 563 417 115 ICV_60 $T=672800 952240 1 180 $X=669570 $Y=951850
X1964 1 2 563 5 117 ICV_60 $T=672800 960080 1 180 $X=669570 $Y=959690
X1965 1 2 570 90 115 ICV_60 $T=674480 967920 0 180 $X=671250 $Y=963365
X1966 1 2 571 33 566 ICV_60 $T=677840 975760 0 180 $X=674610 $Y=971205
X1967 1 2 597 42 133 ICV_60 $T=682320 952240 1 180 $X=679090 $Y=951850
X1968 1 2 597 37 589 ICV_60 $T=682320 960080 1 180 $X=679090 $Y=959690
X1969 1 2 142 442 600 ICV_60 $T=686240 975760 0 180 $X=683010 $Y=971205
X1970 1 2 136 597 606 ICV_60 $T=686800 960080 1 180 $X=683570 $Y=959690
X1971 1 2 134 139 603 ICV_60 $T=689040 952240 0 180 $X=685810 $Y=947685
X1972 1 2 134 589 140 ICV_60 $T=689600 967920 1 180 $X=686370 $Y=967530
X1973 1 2 619 127 566 ICV_60 $T=690720 975760 0 180 $X=687490 $Y=971205
X1974 1 2 176 657 166 ICV_60 $T=710880 967920 1 180 $X=707650 $Y=967530
X1975 1 2 196 683 199 ICV_60 $T=730480 1101200 1 180 $X=727250 $Y=1100810
X1976 1 2 752 751 700 ICV_60 $T=751200 1116880 1 180 $X=747970 $Y=1116490
X1977 1 2 799 798 795 ICV_60 $T=777520 1085520 1 180 $X=774290 $Y=1085130
X1978 1 2 893 905 890 ICV_60 $T=827920 1093360 0 180 $X=824690 $Y=1088805
X1979 1 2 908 917 229 ICV_60 $T=831840 1124720 0 180 $X=828610 $Y=1120165
X2049 1 2 430 428 327 326 ICV_52 $T=624640 1022800 0 0 $X=624210 $Y=1022410
X2050 1 2 664 676 327 326 ICV_52 $T=694080 1062000 0 0 $X=693650 $Y=1061610
X2051 1 2 712 711 327 326 ICV_52 $T=727680 1062000 1 0 $X=727250 $Y=1057445
X2052 1 2 748 747 327 326 ICV_52 $T=737200 1085520 0 0 $X=736770 $Y=1085130
X2053 1 2 876 884 327 326 ICV_52 $T=804400 1007120 1 0 $X=803970 $Y=1002565
X2054 1 2 911 899 327 930 ICV_52 $T=815600 1054160 0 0 $X=815170 $Y=1053770
X2055 1 2 896 906 327 935 ICV_52 $T=826240 1093360 0 0 $X=825810 $Y=1092970
X2056 1 2 944 936 327 929 ICV_52 $T=833520 983600 1 0 $X=833090 $Y=979045
X2057 1 2 951 937 327 929 ICV_52 $T=835760 991440 0 0 $X=835330 $Y=991050
X2058 1 2 953 939 327 930 ICV_52 $T=836320 1038480 1 0 $X=835890 $Y=1033925
X2059 1 2 897 972 327 935 ICV_52 $T=854800 1101200 0 0 $X=854370 $Y=1100810
X2060 1 2 983 974 327 274 ICV_52 $T=855920 960080 1 0 $X=855490 $Y=955525
X2061 1 2 966 1000 327 1043 ICV_52 $T=901280 1038480 0 0 $X=900850 $Y=1038090
X2062 1 2 1067 1058 327 1043 ICV_52 $T=901280 1077680 1 0 $X=900850 $Y=1073125
X2063 1 2 1109 1080 327 300 ICV_52 $T=916400 1116880 1 0 $X=915970 $Y=1112325
X2064 1 2 1113 1082 327 300 ICV_52 $T=917520 1093360 0 0 $X=917090 $Y=1092970
X2065 1 2 309 1083 327 1084 ICV_52 $T=923680 952240 0 0 $X=923250 $Y=951850
X2066 1 2 1137 1130 327 1106 ICV_52 $T=943840 999280 1 0 $X=943410 $Y=994725
X2067 1 2 1158 1128 327 1116 ICV_52 $T=944400 1062000 0 0 $X=943970 $Y=1061610
X2068 1 2 1174 1168 327 1159 ICV_52 $T=964560 975760 1 0 $X=964130 $Y=971205
X2069 1 2 1186 1147 327 1159 ICV_52 $T=969600 975760 0 0 $X=969170 $Y=975370
X2070 1 2 461 455 327 326 ICV_54 $T=624640 1038480 1 0 $X=624210 $Y=1033925
X2071 1 2 440 435 327 326 ICV_54 $T=625200 1085520 0 0 $X=624770 $Y=1085130
X2072 1 2 474 478 327 326 ICV_54 $T=630240 1046320 0 0 $X=629810 $Y=1045930
X2073 1 2 438 431 327 326 ICV_54 $T=631360 1062000 1 0 $X=630930 $Y=1057445
X2074 1 2 541 533 327 326 ICV_54 $T=648160 1069840 0 0 $X=647730 $Y=1069450
X2075 1 2 542 534 327 326 ICV_54 $T=653200 1101200 1 0 $X=652770 $Y=1096645
X2076 1 2 550 622 327 326 ICV_54 $T=678960 1077680 1 0 $X=678530 $Y=1073125
X2077 1 2 618 608 327 602 ICV_54 $T=678960 1093360 0 0 $X=678530 $Y=1092970
X2078 1 2 635 623 327 602 ICV_54 $T=678960 1109040 0 0 $X=678530 $Y=1108650
X2079 1 2 764 756 327 762 ICV_54 $T=748960 1022800 0 0 $X=748530 $Y=1022410
X2080 1 2 778 782 327 326 ICV_54 $T=755680 1054160 0 0 $X=755250 $Y=1053770
X2081 1 2 770 846 327 326 ICV_54 $T=789840 991440 1 0 $X=789410 $Y=986885
X2082 1 2 771 807 327 326 ICV_54 $T=789840 1007120 0 0 $X=789410 $Y=1006730
X2083 1 2 816 822 327 326 ICV_54 $T=789840 1069840 1 0 $X=789410 $Y=1065285
X2084 1 2 837 856 327 326 ICV_54 $T=796560 1046320 1 0 $X=796130 $Y=1041765
X2085 1 2 253 865 327 326 ICV_54 $T=804400 975760 0 0 $X=803970 $Y=975370
X2086 1 2 910 898 327 930 ICV_54 $T=818400 1038480 0 0 $X=817970 $Y=1038090
X2087 1 2 261 888 327 326 ICV_54 $T=821760 967920 1 0 $X=821330 $Y=963365
X2088 1 2 954 940 327 930 ICV_54 $T=836880 1014960 0 0 $X=836450 $Y=1014570
X2089 1 2 285 969 327 276 ICV_54 $T=853680 1116880 1 0 $X=853250 $Y=1112325
X2090 1 2 978 971 327 968 ICV_54 $T=858720 1046320 1 0 $X=858290 $Y=1041765
X2091 1 2 995 980 327 968 ICV_54 $T=859280 1069840 0 0 $X=858850 $Y=1069450
X2092 1 2 1053 1050 327 1047 ICV_54 $T=901280 1030640 1 0 $X=900850 $Y=1026085
X2093 1 2 1068 1059 327 295 ICV_54 $T=901280 1109040 1 0 $X=900850 $Y=1104485
X2094 1 2 1078 1072 327 1047 ICV_54 $T=902400 999280 0 0 $X=901970 $Y=998890
X2095 1 2 308 1081 327 1084 ICV_54 $T=913600 967920 0 0 $X=913170 $Y=967530
X2096 1 2 1126 1105 327 300 ICV_54 $T=924800 1077680 0 0 $X=924370 $Y=1077290
X2097 1 2 302 1075 327 1084 ICV_54 $T=932640 960080 1 0 $X=932210 $Y=955525
X2098 1 2 1134 1123 327 1118 ICV_54 $T=947200 1030640 0 0 $X=946770 $Y=1030250
X2099 1 2 1177 1124 327 1125 ICV_54 $T=964000 1054160 1 0 $X=963570 $Y=1049605
X2100 1 2 1172 1163 327 316 ICV_54 $T=964560 960080 0 0 $X=964130 $Y=959690
X2101 1 2 1179 1156 327 1125 ICV_54 $T=965120 1038480 1 0 $X=964690 $Y=1033925
X2102 1 2 70 399 440 435 ICV_50 $T=635840 1077680 0 0 $X=635410 $Y=1077290
X2103 1 2 50 465 449 67 ICV_50 $T=638640 960080 0 0 $X=638210 $Y=959690
X2104 1 2 50 97 92 432 ICV_50 $T=652640 952240 0 0 $X=652210 $Y=951850
X2105 1 2 72 475 540 532 ICV_50 $T=662720 1062000 0 0 $X=662290 $Y=1061610
X2106 1 2 72 550 542 534 ICV_50 $T=662720 1085520 1 0 $X=662290 $Y=1080965
X2107 1 2 144 615 438 605 ICV_50 $T=683440 1109040 1 0 $X=683010 $Y=1104485
X2108 1 2 130 633 540 620 ICV_50 $T=689600 1014960 0 0 $X=689170 $Y=1014570
X2109 1 2 72 645 673 671 ICV_50 $T=709200 1069840 1 0 $X=708770 $Y=1065285
X2110 1 2 72 750 707 743 ICV_50 $T=744480 1054160 0 0 $X=744050 $Y=1053770
X2111 1 2 144 785 673 780 ICV_50 $T=761280 1077680 0 0 $X=760850 $Y=1077290
X2112 1 2 144 954 772 940 ICV_50 $T=845280 1022800 1 0 $X=844850 $Y=1018245
X2113 1 2 283 285 197 969 ICV_50 $T=862640 1109040 1 0 $X=862210 $Y=1104485
X2114 1 2 144 977 769 970 ICV_50 $T=863200 975760 1 0 $X=862770 $Y=971205
X2115 1 2 283 987 806 1018 ICV_50 $T=886720 1109040 1 0 $X=886290 $Y=1104485
X2116 1 2 283 1066 961 1054 ICV_50 $T=906880 1069840 0 0 $X=906450 $Y=1069450
X2117 1 2 283 1068 264 1059 ICV_50 $T=908000 1101200 1 0 $X=907570 $Y=1096645
X2118 1 2 283 1069 863 1061 ICV_50 $T=908560 1062000 1 0 $X=908130 $Y=1057445
X2119 1 2 283 1099 296 1090 ICV_50 $T=925920 1038480 1 0 $X=925490 $Y=1033925
X2120 1 2 283 1102 879 1093 ICV_50 $T=926480 1062000 0 0 $X=926050 $Y=1061610
X2121 1 2 70 1149 1113 1144 ICV_50 $T=958400 1109040 1 0 $X=957970 $Y=1104485
X2122 1 2 70 1187 1197 1198 ICV_50 $T=1003760 1030640 0 0 $X=1003330 $Y=1030250
X2123 1 2 530 538 327 326 ICV_51 $T=644800 1030640 1 0 $X=644370 $Y=1026085
X2124 1 2 540 532 327 326 ICV_51 $T=644800 1054160 0 0 $X=644370 $Y=1053770
X2125 1 2 511 505 327 326 ICV_51 $T=644800 1093360 1 0 $X=644370 $Y=1088805
X2126 1 2 569 582 327 326 ICV_51 $T=644800 1109040 1 0 $X=644370 $Y=1104485
X2127 1 2 633 620 327 594 ICV_51 $T=684000 1022800 1 0 $X=683570 $Y=1018245
X2128 1 2 673 671 327 326 ICV_51 $T=695760 1069840 0 0 $X=695330 $Y=1069450
X2129 1 2 806 853 327 920 ICV_51 $T=786480 1116880 1 0 $X=786050 $Y=1112325
X2130 1 2 839 855 327 326 ICV_51 $T=799360 1014960 1 0 $X=798930 $Y=1010405
X2131 1 2 883 874 327 920 ICV_51 $T=802160 1062000 0 0 $X=801730 $Y=1061610
X2132 1 2 290 993 327 968 ICV_51 $T=855920 1030640 1 0 $X=855490 $Y=1026085
X2133 1 2 1108 1074 327 300 ICV_51 $T=913040 1101200 0 0 $X=912610 $Y=1100810
X2134 1 2 1102 1093 327 1116 ICV_51 $T=914720 1062000 1 0 $X=914290 $Y=1057445
X2135 1 2 1138 1131 327 1106 ICV_51 $T=941040 1014960 1 0 $X=940610 $Y=1010405
X2136 1 2 1107 1112 327 1118 ICV_51 $T=942720 1038480 0 0 $X=942290 $Y=1038090
X2137 1 2 1146 1140 327 1118 ICV_51 $T=946640 1022800 1 0 $X=946210 $Y=1018245
X2138 1 2 1175 1167 327 335 ICV_51 $T=974080 1069840 0 0 $X=973650 $Y=1069450
X2139 1 2 1196 1119 327 1125 ICV_51 $T=975200 1022800 1 0 $X=974770 $Y=1018245
X2140 1 2 1199 1202 327 335 ICV_51 $T=978000 999280 1 0 $X=977570 $Y=994725
X2141 1 2 601 604 327 326 ICV_53 $T=679520 1069840 1 0 $X=679090 $Y=1065285
X2142 1 2 615 605 327 602 ICV_53 $T=681200 1124720 0 0 $X=680770 $Y=1124330
X2143 1 2 639 631 327 602 ICV_53 $T=683440 1116880 0 0 $X=683010 $Y=1116490
X2144 1 2 684 678 327 659 ICV_53 $T=704720 1085520 0 0 $X=704290 $Y=1085130
X2145 1 2 785 780 327 659 ICV_53 $T=752320 1085520 1 0 $X=751890 $Y=1080965
X2146 1 2 786 781 327 659 ICV_53 $T=754000 1093360 0 0 $X=753570 $Y=1092970
X2147 1 2 216 745 327 326 ICV_53 $T=757360 1014960 0 0 $X=756930 $Y=1014570
X2148 1 2 197 833 327 920 ICV_53 $T=799360 1085520 0 0 $X=798930 $Y=1085130
X2149 1 2 860 866 327 326 ICV_53 $T=801040 983600 1 0 $X=800610 $Y=979045
X2150 1 2 872 885 327 326 ICV_53 $T=803840 1022800 0 0 $X=803410 $Y=1022410
X2151 1 2 912 901 327 930 ICV_53 $T=816160 1030640 1 0 $X=815730 $Y=1026085
X2152 1 2 829 887 327 935 ICV_53 $T=823440 1101200 0 0 $X=823010 $Y=1100810
X2153 1 2 943 948 327 326 ICV_53 $T=833520 975760 1 0 $X=833090 $Y=971205
X2154 1 2 955 941 327 930 ICV_53 $T=836320 1022800 0 0 $X=835890 $Y=1022410
X2155 1 2 1024 1019 327 295 ICV_53 $T=878320 1101200 1 0 $X=877890 $Y=1096645
X2156 1 2 305 333 327 1084 ICV_53 $T=902400 967920 1 0 $X=901970 $Y=963365
X2157 1 2 1095 1086 327 1116 ICV_53 $T=915280 1054160 0 0 $X=914850 $Y=1053770
X2158 1 2 310 1045 327 300 ICV_53 $T=915840 1124720 0 0 $X=915410 $Y=1124330
X2159 1 2 1079 1073 327 1106 ICV_53 $T=928720 983600 0 0 $X=928290 $Y=983210
X2160 1 2 1143 1139 327 1116 ICV_53 $T=944400 1069840 0 0 $X=943970 $Y=1069450
X2161 1 2 1178 1161 327 1125 ICV_53 $T=964560 1046320 1 0 $X=964130 $Y=1041765
X2162 1 2 1181 1170 327 1159 ICV_53 $T=966240 983600 0 0 $X=965810 $Y=983210
X2163 1 2 1183 1155 327 1159 ICV_53 $T=966240 999280 0 0 $X=965810 $Y=998890
.ENDS
***************************************
.SUBCKT ICV_28
** N=4 EP=0 IP=8 FDC=0
.ENDS
***************************************
.SUBCKT ICV_36 1 2 3 4 5 6 7 8 9 10 11 12 13 14 15 16 17 18 19 20
+ 21 22 23 24 25 26 27 28 29 30 31 32 33 34 35 36 37 38 39 40
+ 41 42 43 44 45 46 47 48 49 50 51 52 53 54 55 56 57 58 59 60
+ 61 62 63 64 65 66 67 68 70 71 72 73 74 75 76 77
** N=270 EP=76 IP=3218 FDC=1468
X279 70 72 68 2 1 2 60 DFFQSRX1 $T=851440 1140400 1 0 $X=851010 $Y=1135845
X280 228 72 68 2 1 2 229 DFFQSRX1 $T=851440 1148240 1 0 $X=851010 $Y=1143685
X281 71 72 68 2 1 2 61 DFFQSRX1 $T=852560 1132560 1 0 $X=852130 $Y=1128005
X282 234 73 68 2 1 2 231 DFFQSRX1 $T=895680 1132560 1 180 $X=870050 $Y=1132170
X283 230 73 68 2 1 2 232 DFFQSRX1 $T=895680 1140400 1 180 $X=870050 $Y=1140010
X284 235 73 68 2 1 2 233 DFFQSRX1 $T=895680 1148240 1 180 $X=870050 $Y=1147850
X285 236 74 68 2 1 2 239 DFFQSRX1 $T=901840 1156080 1 0 $X=901410 $Y=1151525
X286 237 74 68 2 1 2 242 DFFQSRX1 $T=914160 1148240 0 0 $X=913730 $Y=1147850
X287 76 74 68 2 1 2 238 DFFQSRX1 $T=941600 1132560 1 180 $X=915970 $Y=1132170
X288 240 75 68 2 1 2 243 DFFQSRX1 $T=916960 1140400 0 0 $X=916530 $Y=1140010
X289 241 74 68 2 1 2 66 DFFQSRX1 $T=944960 1148240 0 0 $X=944530 $Y=1147850
X290 77 74 68 2 1 2 245 DFFQSRX1 $T=946080 1148240 1 0 $X=945650 $Y=1143685
X291 244 74 68 2 1 2 246 DFFQSRX1 $T=946640 1132560 0 0 $X=946210 $Y=1132170
X292 82 84 1 2 80 NOR2X1 $T=714800 1132560 0 0 $X=714370 $Y=1132170
X293 6 85 1 2 81 NOR2X1 $T=716480 1140400 0 0 $X=716050 $Y=1140010
X294 85 86 1 2 82 NOR2X1 $T=717600 1148240 1 0 $X=717170 $Y=1143685
X295 8 81 1 2 9 NOR2X1 $T=722080 1140400 0 180 $X=718850 $Y=1135845
X296 93 27 1 2 87 NOR2X1 $T=744480 1148240 1 0 $X=744050 $Y=1143685
X297 26 118 1 2 24 NOR2X1 $T=744480 1156080 1 0 $X=744050 $Y=1151525
X298 93 118 1 2 22 NOR2X1 $T=748960 1148240 1 0 $X=748530 $Y=1143685
X299 119 9 1 2 31 NOR2X1 $T=755680 1132560 1 180 $X=752450 $Y=1132170
X300 30 83 1 2 127 NOR2X1 $T=753440 1132560 1 0 $X=753010 $Y=1128005
X301 135 132 1 2 130 NOR2X1 $T=780880 1156080 1 180 $X=777650 $Y=1155690
X302 147 149 1 2 131 NOR2X1 $T=783120 1148240 0 0 $X=782690 $Y=1147850
X303 36 141 1 2 135 NOR2X1 $T=783120 1156080 0 0 $X=782690 $Y=1155690
X304 160 147 1 2 157 NOR2X1 $T=790960 1163920 0 180 $X=787730 $Y=1159365
X305 37 34 1 2 153 NOR2X1 $T=790960 1140400 1 0 $X=790530 $Y=1135845
X306 152 34 1 2 158 NOR2X1 $T=791520 1140400 0 0 $X=791090 $Y=1140010
X307 36 167 1 2 165 NOR2X1 $T=792640 1132560 1 0 $X=792210 $Y=1128005
X308 155 157 1 2 166 NOR2X1 $T=795440 1163920 0 180 $X=792210 $Y=1159365
X309 41 169 1 2 167 NOR2X1 $T=793200 1132560 0 0 $X=792770 $Y=1132170
X310 163 41 1 2 151 NOR2X1 $T=797120 1148240 1 180 $X=793890 $Y=1147850
X311 152 172 1 2 169 NOR2X1 $T=796000 1140400 1 0 $X=795570 $Y=1135845
X312 172 168 1 2 171 NOR2X1 $T=797120 1140400 0 0 $X=796690 $Y=1140010
X313 162 43 1 2 155 NOR2X1 $T=797680 1163920 1 0 $X=797250 $Y=1159365
X314 163 168 1 2 175 NOR2X1 $T=798800 1148240 0 0 $X=798370 $Y=1147850
X315 37 172 1 2 178 NOR2X1 $T=801040 1140400 1 0 $X=800610 $Y=1135845
X316 160 43 1 2 145 NOR2X1 $T=801600 1163920 1 0 $X=801170 $Y=1159365
X317 41 47 1 2 187 NOR2X1 $T=807200 1132560 1 0 $X=806770 $Y=1128005
X318 41 43 1 2 188 NOR2X1 $T=811120 1156080 1 180 $X=807890 $Y=1155690
X319 36 188 1 2 191 NOR2X1 $T=808880 1156080 1 0 $X=808450 $Y=1151525
X320 36 194 1 2 197 NOR2X1 $T=811680 1148240 0 0 $X=811250 $Y=1147850
X321 40 185 1 2 202 NOR2X1 $T=815040 1140400 1 0 $X=814610 $Y=1135845
X322 42 202 1 2 204 NOR2X1 $T=818400 1132560 1 180 $X=815170 $Y=1132170
X323 197 196 1 2 206 NOR2X1 $T=816160 1148240 1 0 $X=815730 $Y=1143685
X324 36 153 1 2 207 NOR2X1 $T=818960 1148240 1 180 $X=815730 $Y=1147850
X325 191 204 1 2 209 NOR2X1 $T=816720 1132560 1 0 $X=816290 $Y=1128005
X326 180 203 1 2 200 NOR2X1 $T=818960 1163920 0 0 $X=818530 $Y=1163530
X327 40 199 1 2 217 NOR2X1 $T=826800 1148240 0 180 $X=823570 $Y=1143685
X328 217 205 1 2 219 NOR2X1 $T=824560 1140400 0 0 $X=824130 $Y=1140010
X329 168 219 1 2 220 NOR2X1 $T=825120 1148240 0 0 $X=824690 $Y=1147850
X330 218 207 1 2 221 NOR2X1 $T=827360 1156080 0 0 $X=826930 $Y=1155690
X331 223 216 1 2 227 NOR2X1 $T=831840 1156080 1 0 $X=831410 $Y=1151525
X391 16 13 2 1 99 XOR2X1 $T=723200 1156080 1 0 $X=722770 $Y=1151525
X392 189 40 2 1 47 XOR2X1 $T=813920 1140400 1 180 $X=807330 $Y=1140010
X393 189 152 2 1 199 XOR2X1 $T=809440 1148240 1 0 $X=809010 $Y=1143685
X394 89 8 1 2 88 NAND2X1 $T=722640 1132560 1 180 $X=719410 $Y=1132170
X395 87 10 1 2 86 NAND2X1 $T=719840 1148240 0 0 $X=719410 $Y=1147850
X396 10 93 1 2 11 NAND2X1 $T=722640 1148240 1 0 $X=722210 $Y=1143685
X397 15 6 1 2 94 NAND2X1 $T=727120 1132560 1 180 $X=723890 $Y=1132170
X398 87 13 1 2 95 NAND2X1 $T=727120 1148240 1 180 $X=723890 $Y=1147850
X399 96 14 1 2 90 NAND2X1 $T=727680 1132560 0 180 $X=724450 $Y=1128005
X400 97 102 1 2 96 NAND2X1 $T=728800 1132560 1 0 $X=728370 $Y=1128005
X401 92 16 1 2 100 NAND2X1 $T=728800 1140400 1 0 $X=728370 $Y=1135845
X402 103 13 1 2 105 NAND2X1 $T=731600 1156080 1 0 $X=731170 $Y=1151525
X403 19 85 1 2 106 NAND2X1 $T=735520 1148240 0 180 $X=732290 $Y=1143685
X404 20 18 1 2 102 NAND2X1 $T=736080 1132560 0 180 $X=732850 $Y=1128005
X405 19 14 1 2 101 NAND2X1 $T=736080 1140400 1 180 $X=732850 $Y=1140010
X406 85 16 1 2 21 NAND2X1 $T=733840 1148240 0 0 $X=733410 $Y=1147850
X407 22 107 1 2 91 NAND2X1 $T=740000 1140400 1 180 $X=736770 $Y=1140010
X408 109 24 1 2 115 NAND2X1 $T=738880 1156080 0 0 $X=738450 $Y=1155690
X409 113 87 1 2 117 NAND2X1 $T=740560 1148240 1 0 $X=740130 $Y=1143685
X410 107 118 1 2 98 NAND2X1 $T=741120 1140400 0 0 $X=740690 $Y=1140010
X411 122 107 1 2 121 NAND2X1 $T=747280 1140400 1 180 $X=744050 $Y=1140010
X412 116 107 1 2 124 NAND2X1 $T=747840 1132560 0 0 $X=747410 $Y=1132170
X413 120 125 1 2 28 NAND2X1 $T=748400 1140400 1 0 $X=747970 $Y=1135845
X414 131 34 1 2 134 NAND2X1 $T=778080 1148240 1 0 $X=777650 $Y=1143685
X415 139 145 1 2 137 NAND2X1 $T=780880 1163920 1 0 $X=780450 $Y=1159365
X416 142 146 1 2 35 NAND2X1 $T=781440 1132560 1 0 $X=781010 $Y=1128005
X417 36 151 1 2 146 NAND2X1 $T=788160 1140400 0 180 $X=784930 $Y=1135845
X418 154 155 1 2 133 NAND2X1 $T=785920 1163920 0 0 $X=785490 $Y=1163530
X419 36 152 1 2 147 NAND2X1 $T=787040 1140400 0 0 $X=786610 $Y=1140010
X420 41 40 1 2 160 NAND2X1 $T=796000 1156080 1 180 $X=792770 $Y=1155690
X421 171 163 1 2 164 NAND2X1 $T=797120 1148240 0 180 $X=793890 $Y=1143685
X422 176 173 1 2 161 NAND2X1 $T=801040 1156080 1 180 $X=797810 $Y=1155690
X423 178 145 1 2 179 NAND2X1 $T=801040 1156080 1 0 $X=800610 $Y=1151525
X424 43 41 1 2 168 NAND2X1 $T=804960 1140400 1 180 $X=801730 $Y=1140010
X425 46 163 1 2 162 NAND2X1 $T=804960 1171760 0 180 $X=801730 $Y=1167205
X426 153 151 1 2 48 NAND2X1 $T=808320 1148240 0 180 $X=805090 $Y=1143685
X427 186 43 1 2 140 NAND2X1 $T=808880 1163920 0 180 $X=805650 $Y=1159365
X428 190 180 1 2 193 NAND2X1 $T=809440 1171760 1 0 $X=809010 $Y=1167205
X429 189 40 1 2 174 NAND2X1 $T=812800 1163920 0 180 $X=809570 $Y=1159365
X430 193 189 1 2 182 NAND2X1 $T=810560 1163920 0 0 $X=810130 $Y=1163530
X431 34 42 1 2 198 NAND2X1 $T=811680 1132560 1 0 $X=811250 $Y=1128005
X432 153 189 1 2 201 NAND2X1 $T=817280 1163920 0 180 $X=814050 $Y=1159365
X433 153 46 1 2 190 NAND2X1 $T=817280 1171760 0 180 $X=814050 $Y=1167205
X434 201 203 1 2 210 NAND2X1 $T=818960 1163920 1 0 $X=818530 $Y=1159365
X435 147 180 1 2 211 NAND2X1 $T=822320 1140400 0 180 $X=819090 $Y=1135845
X436 199 41 1 2 213 NAND2X1 $T=822320 1140400 1 180 $X=819090 $Y=1140010
X437 175 199 1 2 51 NAND2X1 $T=819520 1148240 1 0 $X=819090 $Y=1143685
X438 211 42 1 2 214 NAND2X1 $T=822880 1132560 1 180 $X=819650 $Y=1132170
X439 207 40 1 2 212 NAND2X1 $T=822880 1156080 0 0 $X=822450 $Y=1155690
X440 224 40 1 2 226 NAND2X1 $T=832400 1140400 1 180 $X=829170 $Y=1140010
X441 81 1 2 4 INVX2 $T=714800 1140400 1 0 $X=714370 $Y=1135845
X442 15 1 2 85 INVX2 $T=726560 1140400 0 0 $X=726130 $Y=1140010
X443 94 1 2 103 INVX2 $T=729920 1140400 0 0 $X=729490 $Y=1140010
X444 9 1 2 108 INVX2 $T=733280 1140400 1 0 $X=732850 $Y=1135845
X445 24 1 2 122 INVX2 $T=745040 1156080 0 0 $X=744610 $Y=1155690
X446 26 1 2 93 INVX2 $T=748960 1148240 0 0 $X=748530 $Y=1147850
X447 27 1 2 118 INVX2 $T=755120 1148240 1 180 $X=753010 $Y=1147850
X448 114 1 2 126 INVX2 $T=753440 1156080 1 0 $X=753010 $Y=1151525
X449 37 1 2 152 INVX2 $T=790960 1132560 1 180 $X=788850 $Y=1132170
X450 40 1 2 163 INVX2 $T=793200 1163920 1 180 $X=791090 $Y=1163530
X451 34 1 2 172 INVX2 $T=797680 1132560 0 0 $X=797250 $Y=1132170
X452 175 1 2 173 INVX2 $T=799920 1156080 0 180 $X=797810 $Y=1151525
X453 151 1 2 180 INVX2 $T=804400 1148240 0 180 $X=802290 $Y=1143685
X454 46 1 2 41 INVX2 $T=805520 1132560 0 180 $X=803410 $Y=1128005
X455 36 1 2 189 INVX2 $T=811680 1148240 1 180 $X=809570 $Y=1147850
X456 47 1 2 195 INVX2 $T=811680 1132560 0 0 $X=811250 $Y=1132170
X457 188 1 2 194 INVX2 $T=811680 1156080 1 0 $X=811250 $Y=1151525
X458 169 1 2 203 INVX2 $T=815600 1163920 0 0 $X=815170 $Y=1163530
X459 145 1 2 218 INVX2 $T=825120 1163920 1 0 $X=824690 $Y=1159365
X460 147 1 2 224 INVX2 $T=829600 1148240 1 0 $X=829170 $Y=1143685
X461 67 1 2 68 INVX2 $T=1009360 1156080 1 0 $X=1008930 $Y=1151525
X515 15 10 1 2 92 OR2X1 $T=727120 1140400 0 180 $X=723330 $Y=1135845
X516 19 104 1 2 113 OR2X1 $T=736080 1148240 1 0 $X=735650 $Y=1143685
X517 87 24 1 2 110 OR2X1 $T=741680 1148240 1 180 $X=737890 $Y=1147850
X518 107 19 1 2 119 OR2X1 $T=741680 1132560 0 0 $X=741250 $Y=1132170
X519 16 24 1 2 123 OR2X1 $T=743360 1148240 0 0 $X=742930 $Y=1147850
X520 118 119 1 2 129 OR2X1 $T=753440 1140400 1 0 $X=753010 $Y=1135845
X521 138 143 1 2 139 OR2X1 $T=780880 1156080 1 0 $X=780450 $Y=1151525
X522 152 150 1 2 142 OR2X1 $T=787040 1132560 1 180 $X=783250 $Y=1132170
X523 162 36 1 2 150 OR2X1 $T=791520 1156080 1 180 $X=787730 $Y=1155690
X524 34 166 1 2 177 OR2X1 $T=798240 1148240 1 0 $X=797810 $Y=1143685
X525 46 47 1 2 159 OR2X1 $T=807200 1132560 1 180 $X=803410 $Y=1132170
X526 178 158 1 2 185 OR2X1 $T=804960 1140400 1 0 $X=804530 $Y=1135845
X527 203 206 1 2 208 OR2X1 $T=820640 1156080 0 180 $X=816850 $Y=1151525
X528 198 195 1 2 222 OR2X1 $T=824560 1132560 0 0 $X=824130 $Y=1132170
X529 221 220 1 2 223 OR2X1 $T=826800 1156080 1 0 $X=826370 $Y=1151525
X530 207 215 1 2 54 OR2X1 $T=830720 1132560 0 180 $X=826930 $Y=1128005
X531 198 225 1 2 55 OR2X1 $T=829040 1132560 0 0 $X=828610 $Y=1132170
X532 100 17 94 1 2 97 MUX2X1 $T=732720 1132560 1 180 $X=726690 $Y=1132170
X533 110 15 22 1 2 116 MUX2X1 $T=736080 1140400 1 0 $X=735650 $Y=1135845
X534 121 9 129 1 2 128 MUX2X1 $T=752880 1140400 0 0 $X=752450 $Y=1140010
X535 34 36 153 1 2 154 MUX2X1 $T=782560 1148240 1 0 $X=782130 $Y=1143685
X536 150 37 159 1 2 39 MUX2X1 $T=785920 1132560 1 0 $X=785490 $Y=1128005
X537 171 37 165 1 2 44 MUX2X1 $T=796560 1132560 1 0 $X=796130 $Y=1128005
X538 229 58 57 1 2 228 MUX2X1 $T=866560 1140400 1 180 $X=860530 $Y=1140010
X539 238 63 232 1 2 236 MUX2X1 $T=918080 1140400 0 180 $X=912050 $Y=1135845
X540 239 63 231 1 2 237 MUX2X1 $T=918080 1148240 0 180 $X=912050 $Y=1143685
X541 242 63 233 1 2 241 MUX2X1 $T=938800 1156080 0 180 $X=932770 $Y=1151525
X542 245 63 243 1 2 244 MUX2X1 $T=960640 1140400 0 180 $X=954610 $Y=1135845
X543 246 63 65 1 2 64 MUX2X1 $T=961200 1132560 0 180 $X=955170 $Y=1128005
X544 80 3 5 1 2 83 NAND3X1 $T=713680 1132560 1 0 $X=713250 $Y=1128005
X545 90 88 7 1 2 84 NAND3X1 $T=723760 1132560 0 180 $X=719410 $Y=1128005
X546 86 91 94 1 2 12 NAND3X1 $T=721520 1140400 0 0 $X=721090 $Y=1140010
X547 101 95 98 1 2 89 NAND3X1 $T=731600 1148240 0 180 $X=727250 $Y=1143685
X548 106 105 21 1 2 109 NAND3X1 $T=732720 1156080 0 0 $X=732290 $Y=1155690
X549 108 87 17 1 2 112 NAND3X1 $T=740560 1132560 1 180 $X=736210 $Y=1132170
X550 115 23 111 1 2 114 NAND3X1 $T=741680 1156080 0 180 $X=737330 $Y=1151525
X551 21 14 18 1 2 111 NAND3X1 $T=742240 1132560 0 180 $X=737890 $Y=1128005
X552 119 87 103 1 2 120 NAND3X1 $T=747280 1140400 0 180 $X=742930 $Y=1135845
X553 123 107 27 1 2 125 NAND3X1 $T=747840 1140400 0 0 $X=747410 $Y=1140010
X554 126 128 117 1 2 32 NAND3X1 $T=753440 1148240 1 0 $X=753010 $Y=1143685
X555 127 112 124 1 2 33 NAND3X1 $T=757920 1132560 1 0 $X=757490 $Y=1128005
X556 140 137 133 1 2 132 NAND3X1 $T=782560 1163920 1 180 $X=778210 $Y=1163530
X557 161 158 150 1 2 156 NAND3X1 $T=792080 1148240 1 180 $X=787730 $Y=1147850
X558 153 160 162 1 2 144 NAND3X1 $T=788720 1171760 1 0 $X=788290 $Y=1167205
X559 136 156 164 1 2 38 NAND3X1 $T=789280 1148240 1 0 $X=788850 $Y=1143685
X560 143 168 163 1 2 170 NAND3X1 $T=792640 1156080 1 0 $X=792210 $Y=1151525
X561 169 42 163 1 2 148 NAND3X1 $T=799360 1171760 0 180 $X=795010 $Y=1167205
X562 174 42 160 1 2 176 NAND3X1 $T=798240 1163920 0 0 $X=797810 $Y=1163530
X563 36 172 180 1 2 45 NAND3X1 $T=799360 1132560 0 0 $X=798930 $Y=1132170
X564 169 36 46 1 2 181 NAND3X1 $T=802720 1156080 0 0 $X=802290 $Y=1155690
X565 158 151 43 1 2 184 NAND3X1 $T=803840 1148240 0 0 $X=803410 $Y=1147850
X566 170 183 179 1 2 49 NAND3X1 $T=804400 1156080 1 0 $X=803970 $Y=1151525
X567 182 181 48 1 2 186 NAND3X1 $T=804960 1163920 0 0 $X=804530 $Y=1163530
X568 187 43 152 1 2 192 NAND3X1 $T=807760 1132560 0 0 $X=807330 $Y=1132170
X569 200 189 42 1 2 183 NAND3X1 $T=816160 1156080 1 180 $X=811810 $Y=1155690
X570 212 210 149 1 2 50 NAND3X1 $T=821760 1156080 1 180 $X=817410 $Y=1155690
X571 209 214 198 1 2 215 NAND3X1 $T=821200 1132560 1 0 $X=820770 $Y=1128005
X572 208 177 184 1 2 216 NAND3X1 $T=821200 1156080 1 0 $X=820770 $Y=1151525
X573 227 192 222 1 2 56 NAND3X1 $T=834640 1132560 0 0 $X=834210 $Y=1132170
X574 99 85 1 2 104 AND2X1 $T=728800 1148240 0 0 $X=728370 $Y=1147850
X575 17 13 1 2 107 AND2X1 $T=736640 1132560 1 180 $X=732850 $Y=1132170
X576 9 107 1 2 25 AND2X1 $T=746720 1132560 0 180 $X=742930 $Y=1128005
X577 107 26 1 2 29 AND2X1 $T=747840 1132560 1 0 $X=747410 $Y=1128005
X578 130 134 1 2 136 AND2X1 $T=777520 1148240 0 0 $X=777090 $Y=1147850
X579 147 34 1 2 138 AND2X1 $T=784240 1140400 1 180 $X=780450 $Y=1140010
X580 148 144 1 2 141 AND2X1 $T=784800 1171760 0 180 $X=781010 $Y=1167205
X581 153 36 1 2 143 AND2X1 $T=786480 1156080 1 0 $X=786050 $Y=1151525
X582 47 46 1 2 196 AND2X1 $T=810000 1140400 1 0 $X=809570 $Y=1135845
X583 168 194 1 2 149 AND2X1 $T=817280 1156080 0 180 $X=813490 $Y=1151525
X584 185 189 1 2 205 AND2X1 $T=814480 1140400 0 0 $X=814050 $Y=1140010
X585 217 52 1 2 53 AND2X1 $T=824560 1140400 1 0 $X=824130 $Y=1135845
X586 213 226 1 2 225 AND2X1 $T=829600 1140400 1 0 $X=829170 $Y=1135845
X587 59 229 1 2 230 AND2X1 $T=867120 1140400 0 0 $X=866690 $Y=1140010
X588 59 62 1 2 234 AND2X1 $T=880000 1140400 0 180 $X=876210 $Y=1135845
X589 59 60 1 2 235 AND2X1 $T=878880 1148240 1 0 $X=878450 $Y=1143685
X590 59 61 1 2 240 AND2X1 $T=914720 1132560 1 0 $X=914290 $Y=1128005
.ENDS
***************************************
.SUBCKT ICV_3 VSS VDD
** N=46 EP=2 IP=1 FDC=1
D0 VSS VDD ndio_m AREA=9e-10 PJ=0.00012 $X=10780 $Y=193610 $D=30
.ENDS
***************************************
.SUBCKT ICV_18
** N=4 EP=0 IP=4 FDC=0
.ENDS
***************************************
.SUBCKT ICV_17
** N=4 EP=0 IP=20 FDC=0
.ENDS
***************************************
.SUBCKT ICV_9
** N=4 EP=0 IP=4 FDC=0
.ENDS
***************************************
.SUBCKT ICV_16
** N=4 EP=0 IP=20 FDC=0
.ENDS
***************************************
.SUBCKT ICV_15
** N=4 EP=0 IP=88 FDC=0
.ENDS
***************************************
.SUBCKT ICV_1 VDD DataOut pad VSS
** N=25 EP=4 IP=1 FDC=96
M0 VSS VDD 7 VSS N L=3.5e-07 W=9e-06 $X=5700 $Y=147100 $D=0
M1 8 7 VSS VSS N L=3.5e-07 W=9e-06 $X=8100 $Y=147100 $D=0
M2 VSS DataOut 10 VSS N L=3.5e-07 W=9e-06 $X=13200 $Y=147100 $D=0
M3 10 DataOut VSS VSS N L=3.5e-07 W=9e-06 $X=15600 $Y=147100 $D=0
M4 pad 10 VSS VSS N L=3.5e-07 W=2e-05 $X=15770 $Y=191300 $D=0
M5 VSS 10 pad VSS N L=3.5e-07 W=2e-05 $X=15770 $Y=196210 $D=0
M6 pad 10 VSS VSS N L=3.5e-07 W=2e-05 $X=15770 $Y=197780 $D=0
M7 VSS 10 pad VSS N L=3.5e-07 W=2e-05 $X=15770 $Y=202690 $D=0
M8 pad 10 VSS VSS N L=3.5e-07 W=2e-05 $X=15770 $Y=204260 $D=0
M9 VSS 10 pad VSS N L=3.5e-07 W=2e-05 $X=15770 $Y=209170 $D=0
M10 pad 10 VSS VSS N L=3.5e-07 W=2e-05 $X=15770 $Y=210740 $D=0
M11 VSS 10 pad VSS N L=3.5e-07 W=2e-05 $X=15770 $Y=215650 $D=0
M12 pad 10 VSS VSS N L=3.5e-07 W=2e-05 $X=15770 $Y=217220 $D=0
M13 VSS 10 pad VSS N L=3.5e-07 W=2e-05 $X=15770 $Y=222130 $D=0
M14 VSS DataOut 10 VSS N L=3.5e-07 W=9e-06 $X=18000 $Y=147100 $D=0
M15 10 DataOut VSS VSS N L=3.5e-07 W=9e-06 $X=20400 $Y=147100 $D=0
M16 VSS DataOut 10 VSS N L=3.5e-07 W=9e-06 $X=22800 $Y=147100 $D=0
M17 10 7 VSS VSS N L=3.5e-07 W=9e-06 $X=25200 $Y=147100 $D=0
M18 VSS 7 10 VSS N L=3.5e-07 W=9e-06 $X=27600 $Y=147100 $D=0
M19 10 7 VSS VSS N L=3.5e-07 W=9e-06 $X=30000 $Y=147100 $D=0
M20 VSS 7 10 VSS N L=3.5e-07 W=9e-06 $X=32400 $Y=147100 $D=0
M21 10 7 VSS VSS N L=3.5e-07 W=9e-06 $X=34800 $Y=147100 $D=0
M22 9 8 10 VSS N L=3.5e-07 W=9e-06 $X=37200 $Y=147100 $D=0
M23 10 8 9 VSS N L=3.5e-07 W=9e-06 $X=39600 $Y=147100 $D=0
M24 9 8 10 VSS N L=3.5e-07 W=9e-06 $X=42000 $Y=147100 $D=0
M25 10 8 9 VSS N L=3.5e-07 W=9e-06 $X=44400 $Y=147100 $D=0
M26 pad 10 VSS VSS N L=3.5e-07 W=2e-05 $X=54230 $Y=191300 $D=0
M27 VSS 10 pad VSS N L=3.5e-07 W=2e-05 $X=54230 $Y=196210 $D=0
M28 pad 10 VSS VSS N L=3.5e-07 W=2e-05 $X=54230 $Y=197780 $D=0
M29 VSS 10 pad VSS N L=3.5e-07 W=2e-05 $X=54230 $Y=202690 $D=0
M30 pad 10 VSS VSS N L=3.5e-07 W=2e-05 $X=54230 $Y=204260 $D=0
M31 VSS 10 pad VSS N L=3.5e-07 W=2e-05 $X=54230 $Y=209170 $D=0
M32 pad 10 VSS VSS N L=3.5e-07 W=2e-05 $X=54230 $Y=210740 $D=0
M33 VSS 10 pad VSS N L=3.5e-07 W=2e-05 $X=54230 $Y=215650 $D=0
M34 pad 10 VSS VSS N L=3.5e-07 W=2e-05 $X=54230 $Y=217220 $D=0
M35 VSS 10 pad VSS N L=3.5e-07 W=2e-05 $X=54230 $Y=222130 $D=0
M36 11 pad VSS VSS N L=3.5e-07 W=9e-06 $X=59400 $Y=146950 $D=0
M37 VSS pad 11 VSS N L=3.5e-07 W=9e-06 $X=61800 $Y=146950 $D=0
M38 11 pad VSS VSS N L=3.5e-07 W=9e-06 $X=64200 $Y=146950 $D=0
M39 VSS pad 11 VSS N L=3.5e-07 W=9e-06 $X=66600 $Y=146950 $D=0
M40 11 pad VSS VSS N L=3.5e-07 W=9e-06 $X=69000 $Y=146950 $D=0
M41 VSS pad 11 VSS N L=3.5e-07 W=9e-06 $X=71400 $Y=146950 $D=0
M42 12 11 VSS VSS N L=3.5e-07 W=9e-06 $X=73800 $Y=146950 $D=0
M43 VSS 11 12 VSS N L=3.5e-07 W=9e-06 $X=76200 $Y=146950 $D=0
M44 12 11 VSS VSS N L=3.5e-07 W=9e-06 $X=78600 $Y=146950 $D=0
M45 VSS 11 12 VSS N L=3.5e-07 W=9e-06 $X=81000 $Y=146950 $D=0
M46 12 11 VSS VSS N L=3.5e-07 W=9e-06 $X=83400 $Y=146950 $D=0
M47 VSS 11 12 VSS N L=3.5e-07 W=9e-06 $X=85800 $Y=146950 $D=0
M48 VDD VDD 7 VDD P L=3.5e-07 W=1.56e-05 $X=5700 $Y=165550 $D=16
M49 8 7 VDD VDD P L=3.5e-07 W=1.56e-05 $X=8100 $Y=165550 $D=16
M50 VDD DataOut 9 VDD P L=3.5e-07 W=1.56e-05 $X=13200 $Y=165550 $D=16
M51 9 DataOut VDD VDD P L=3.5e-07 W=1.56e-05 $X=15600 $Y=165550 $D=16
M52 pad 9 VDD VDD P L=3.5e-07 W=2e-05 $X=15795 $Y=97085 $D=16
M53 VDD 9 pad VDD P L=3.5e-07 W=2e-05 $X=15795 $Y=101995 $D=16
M54 pad 9 VDD VDD P L=3.5e-07 W=2e-05 $X=15795 $Y=103565 $D=16
M55 VDD 9 pad VDD P L=3.5e-07 W=2e-05 $X=15795 $Y=108475 $D=16
M56 pad 9 VDD VDD P L=3.5e-07 W=2e-05 $X=15795 $Y=110045 $D=16
M57 VDD 9 pad VDD P L=3.5e-07 W=2e-05 $X=15795 $Y=114955 $D=16
M58 pad 9 VDD VDD P L=3.5e-07 W=2e-05 $X=15795 $Y=116525 $D=16
M59 VDD 9 pad VDD P L=3.5e-07 W=2e-05 $X=15795 $Y=121435 $D=16
M60 pad 9 VDD VDD P L=3.5e-07 W=2e-05 $X=15795 $Y=123005 $D=16
M61 VDD 9 pad VDD P L=3.5e-07 W=2e-05 $X=15795 $Y=127915 $D=16
M62 VDD DataOut 9 VDD P L=3.5e-07 W=1.56e-05 $X=18000 $Y=165550 $D=16
M63 9 DataOut VDD VDD P L=3.5e-07 W=1.56e-05 $X=20400 $Y=165550 $D=16
M64 VDD DataOut 9 VDD P L=3.5e-07 W=1.56e-05 $X=22800 $Y=165550 $D=16
M65 9 8 VDD VDD P L=3.5e-07 W=1.56e-05 $X=25200 $Y=165550 $D=16
M66 VDD 8 9 VDD P L=3.5e-07 W=1.56e-05 $X=27600 $Y=165550 $D=16
M67 9 8 VDD VDD P L=3.5e-07 W=1.56e-05 $X=30000 $Y=165550 $D=16
M68 VDD 8 9 VDD P L=3.5e-07 W=1.56e-05 $X=32400 $Y=165550 $D=16
M69 9 8 VDD VDD P L=3.5e-07 W=1.56e-05 $X=34800 $Y=165550 $D=16
M70 10 7 9 VDD P L=3.5e-07 W=1.56e-05 $X=37200 $Y=165550 $D=16
M71 9 7 10 VDD P L=3.5e-07 W=1.56e-05 $X=39600 $Y=165550 $D=16
M72 10 7 9 VDD P L=3.5e-07 W=1.56e-05 $X=42000 $Y=165550 $D=16
M73 9 7 10 VDD P L=3.5e-07 W=1.56e-05 $X=44400 $Y=165550 $D=16
M74 pad 9 VDD VDD P L=3.5e-07 W=2e-05 $X=53330 $Y=97085 $D=16
M75 VDD 9 pad VDD P L=3.5e-07 W=2e-05 $X=53330 $Y=101995 $D=16
M76 pad 9 VDD VDD P L=3.5e-07 W=2e-05 $X=53330 $Y=103565 $D=16
M77 VDD 9 pad VDD P L=3.5e-07 W=2e-05 $X=53330 $Y=108475 $D=16
M78 pad 9 VDD VDD P L=3.5e-07 W=2e-05 $X=53330 $Y=110045 $D=16
M79 VDD 9 pad VDD P L=3.5e-07 W=2e-05 $X=53330 $Y=114955 $D=16
M80 pad 9 VDD VDD P L=3.5e-07 W=2e-05 $X=53330 $Y=116525 $D=16
M81 VDD 9 pad VDD P L=3.5e-07 W=2e-05 $X=53330 $Y=121435 $D=16
M82 pad 9 VDD VDD P L=3.5e-07 W=2e-05 $X=53330 $Y=123005 $D=16
M83 VDD 9 pad VDD P L=3.5e-07 W=2e-05 $X=53330 $Y=127915 $D=16
M84 11 pad VDD VDD P L=3.5e-07 W=1.56e-05 $X=59400 $Y=165550 $D=16
M85 VDD pad 11 VDD P L=3.5e-07 W=1.56e-05 $X=61800 $Y=165550 $D=16
M86 11 pad VDD VDD P L=3.5e-07 W=1.56e-05 $X=64200 $Y=165550 $D=16
M87 VDD pad 11 VDD P L=3.5e-07 W=1.56e-05 $X=66600 $Y=165550 $D=16
M88 11 pad VDD VDD P L=3.5e-07 W=1.56e-05 $X=69000 $Y=165550 $D=16
M89 VDD pad 11 VDD P L=3.5e-07 W=1.56e-05 $X=71400 $Y=165550 $D=16
M90 12 11 VDD VDD P L=3.5e-07 W=1.56e-05 $X=73800 $Y=165550 $D=16
M91 VDD 11 12 VDD P L=3.5e-07 W=1.56e-05 $X=76200 $Y=165550 $D=16
M92 12 11 VDD VDD P L=3.5e-07 W=1.56e-05 $X=78600 $Y=165550 $D=16
M93 VDD 11 12 VDD P L=3.5e-07 W=1.56e-05 $X=81000 $Y=165550 $D=16
M94 12 11 VDD VDD P L=3.5e-07 W=1.56e-05 $X=83400 $Y=165550 $D=16
M95 VDD 11 12 VDD P L=3.5e-07 W=1.56e-05 $X=85800 $Y=165550 $D=16
.ENDS
***************************************
.SUBCKT ICV_14
** N=4 EP=0 IP=16 FDC=0
.ENDS
***************************************
.SUBCKT ICV_6
** N=4 EP=0 IP=4 FDC=0
.ENDS
***************************************
.SUBCKT ICV_13
** N=4 EP=0 IP=16 FDC=0
.ENDS
***************************************
.SUBCKT ICV_5
** N=4 EP=0 IP=4 FDC=0
.ENDS
***************************************
.SUBCKT ICV_12
** N=4 EP=0 IP=24 FDC=0
.ENDS
***************************************
.SUBCKT ICV_11
** N=4 EP=0 IP=68 FDC=0
.ENDS
***************************************
.SUBCKT top_pad VSS VDD cs_n mosi clk sclk rst miso
** N=518 EP=8 IP=1188 FDC=42382
X2 VSS VDD 18 cs_n ICV_140 $T=0 0 0 0 $X=0 $Y=403800
X4 VSS VDD 14 mosi ICV_138 $T=0 0 0 0 $X=0 $Y=722380
X6 VSS VDD ICV_2 $T=0 1103320 0 270 $X=0 $Y=1012420
X15 VSS VDD 15 16 17 clk sclk rst ICV_22 $T=0 0 0 0 $X=232600 $Y=1302460
X17 VSS VDD 18 234 22 21 20 23 26 16 221 19 24 25 ICV_129 $T=0 0 0 0 $X=234100 $Y=403050
X18 VSS VDD 225 243 244 3 246 36 233 218 31 39 14 273 18 272 270 271 282 274
+ 275 276 278 277 5 171 281 284 279 280 283 15 37 285 16 287 38 292 19 286
+ 20 288 290 234 161 56 41 42 304 45 43 289 44 291 40 170 46 293 51 47
+ 57 294 48 21 299 22 296 298 297 49 300 50 23 301 79 52 303 302 309 53
+ 54 305 55 24 306 308 311 295 26 313 312 314 59 58 310 60 318 317 316 315
+ 62 63 319 64 65 66 67 68 70 69 321 71 72 322 73 74 75 76 77 320
+ 78 323 80 81 84 83 325 82 6 12 10 7 8 4 11 9 239 221 30 248
+ 32 34 269 35 307 223 25 61 224 324
+ ICV_122 $T=0 0 0 0 $X=234100 $Y=583370
X19 VSS VDD 86 88 27 90 89 91 28 328 368 92 331 93 29 236 333 237 94 240
+ 95 337 339 338 96 103 330 335 97 341 227 125 235 343 345 332 107 98 241 99
+ 346 230 347 344 242 129 348 121 143 340 329 363 101 243 350 349 225 356 244 351
+ 354 102 334 352 336 228 106 239 245 359 358 132 357 326 104 355 353 30 263 361
+ 362 246 105 100 247 327 3 57 85 108 364 226 87 367 365 248 119 366 152 79
+ 409 111 342 249 110 109 373 371 372 255 384 250 251 374 112 370 113 31 238 377
+ 390 252 383 114 260 378 369 33 254 253 171 32 256 116 229 379 258 382 257 380
+ 375 267 115 381 4 118 387 259 262 385 360 393 264 261 400 388 394 404 389 170
+ 265 386 133 139 266 391 141 122 392 398 376 395 396 435 123 124 397 268 422 433
+ 120 135 431 411 117 126 429 403 127 15 399 128 402 401 437 270 269 34 432 271
+ 134 131 138 426 428 5 130 36 282 406 424 405 275 273 274 417 436 407 408 430
+ 413 278 276 279 416 136 137 277 284 154 419 438 434 427 415 421 149 151 6 140
+ 425 410 153 418 414 281 142 232 412 145 37 231 144 420 280 35 423 148 147 285
+ 150 272 292 7 38 283 155 454 158 451 450 440 157 39 287 146 8 306 18 288
+ 443 444 446 447 445 40 156 42 48 290 291 303 289 41 51 43 448 44 449 9
+ 293 45 47 294 300 296 46 304 297 453 295 159 452 50 298 439 49 233 53 456
+ 462 312 301 286 161 52 54 55 307 10 305 299 56 160 223 468 310 458 302 308
+ 311 11 16 25 457 309 320 313 58 163 59 165 459 314 166 167 318 60 164 61
+ 169 174 317 316 461 168 470 62 172 70 63 69 64 175 65 319 173 465 321 463
+ 464 66 68 67 466 71 78 176 72 322 74 75 467 460 76 469 177 323 73 77
+ 80 81 324 224 12 178 471 218 475 472 82 83 180 477 325 476 179 221 441 442
+ 455 162 315 473 474
+ ICV_112 $T=0 0 0 0 $X=234100 $Y=723900
X20 VSS VDD 93 333 328 94 227 335 338 99 92 96 389 336 97 102 98 346 428 402
+ 345 100 90 226 229 347 353 344 339 121 337 101 352 228 357 103 104 86 371 362
+ 359 356 143 354 230 363 105 106 360 107 376 349 340 88 365 364 95 108 366 341
+ 87 384 342 375 326 369 367 111 110 18 400 39 373 374 113 397 392 261 120 115
+ 393 116 379 118 383 89 380 117 114 394 327 132 351 387 381 378 331 109 119 133
+ 348 386 385 390 372 144 350 391 150 368 122 125 91 123 408 388 405 128 412 429
+ 431 422 433 343 410 15 152 126 137 36 399 396 420 135 432 134 401 413 124 232
+ 437 139 403 233 127 329 130 407 131 404 85 416 406 417 377 382 435 411 276 136
+ 409 138 415 149 140 421 434 151 426 424 430 414 231 418 142 425 419 181 300 145
+ 478 185 423 182 146 183 482 427 436 184 147 479 148 186 480 481 457 439 188 485
+ 155 189 187 483 193 192 190 484 196 191 306 154 438 487 194 443 486 195 153 197
+ 198 199 156 171 441 442 200 494 57 170 312 161 448 203 201 489 495 444 202 204
+ 491 446 299 490 56 13 209 459 205 206 452 207 449 208 447 450 440 493 492 157
+ 159 210 211 165 488 212 454 286 468 213 214 458 215 455 451 497 456 160 217 216
+ 167 498 79 499 500 162 496 158 163 453 164 166 460 463 501 462 169 218 461 502
+ 466 470 172 173 174 503 464 465 175 222 467 176 469 219 177 474 504 471 475 178
+ 472 473 476 477 180 16 221 445 168 220 25 179
+ ICV_64 $T=0 0 0 0 $X=234100 $Y=947685
X21 VSS VDD 181 478 182 185 187 183 198 480 184 479 483 186 481 482 188 189 193 190
+ 192 191 484 485 194 487 196 486 195 197 199 488 200 203 201 489 13 204 202 491
+ 490 209 208 207 205 493 206 215 492 210 211 495 214 212 213 496 494 79 218 498
+ 499 500 18 220 222 504 17 221 217 216 497 501 25 502 503 219
+ ICV_36 $T=0 0 0 0 $X=234100 $Y=1128005
X22 VSS VDD ICV_3 $T=497265 1536560 0 180 $X=406365 $Y=1302460
X28 VDD 84 miso VSS ICV_1 $T=1696720 723280 0 90 $X=1462620 $Y=722380
.ENDS
***************************************
