* SPICE NETLIST
***************************************

*.CALIBRE ABORT_INFO SOFTCHK
.SUBCKT crtmom PLUS MINUS BULK
.ENDS
***************************************
.SUBCKT cfmom PLUS MINUS BULK
.ENDS
***************************************
.SUBCKT cfmom_rf PLUS MINUS BULK
.ENDS
***************************************
.SUBCKT cfmom_mx PLUS1 MINUS1 PLUS2 MINUS2 BULK
.ENDS
***************************************
.SUBCKT lcesd1_rf PLUS MINUS
.ENDS
***************************************
.SUBCKT lcesd2_rf PLUS MINUS
.ENDS
***************************************
.SUBCKT mimcap_2p0_shield PLUS MINUS BULK
.ENDS
***************************************
.SUBCKT mimcap_2p0_sin TOP BOT
.ENDS
***************************************
.SUBCKT mimcap_2p0_sin_3t PLUS MINUS BULK
.ENDS
***************************************
.SUBCKT mimcap_2p0_wos PLUS MINUS BULK
.ENDS
***************************************
.SUBCKT moscap_rf PLUS MINUS BULK
.ENDS
***************************************
.SUBCKT moscap_rf33 PLUS MINUS BULK
.ENDS
***************************************
.SUBCKT moscap_rf33_nw PLUS MINUS BULK
.ENDS
***************************************
.SUBCKT moscap_rf_nw PLUS MINUS BULK
.ENDS
***************************************
.SUBCKT nmos_rf D G S B
.ENDS
***************************************
.SUBCKT nmos_rf33 D G S B
.ENDS
***************************************
.SUBCKT nmos_rf33_6t D G S B NG PG
.ENDS
***************************************
.SUBCKT nmos_rf_6t D G S B NG PG
.ENDS
***************************************
.SUBCKT nmoscap PLUS MINUS
.ENDS
***************************************
.SUBCKT nmoscap_33 PLUS MINUS
.ENDS
***************************************
.SUBCKT pmos_rf D G S B
.ENDS
***************************************
.SUBCKT pmos_rf33 D G S B
.ENDS
***************************************
.SUBCKT pmos_rf33_5t D G S B PG
.ENDS
***************************************
.SUBCKT pmos_rf33_nw D G S B
.ENDS
***************************************
.SUBCKT pmos_rf33_nw_5t D G S B PG
.ENDS
***************************************
.SUBCKT pmos_rf_5t D G S B PG
.ENDS
***************************************
.SUBCKT pmos_rf_nw D G S B
.ENDS
***************************************
.SUBCKT pmos_rf_nw_5t D G S B PG
.ENDS
***************************************
.SUBCKT rnod_m PLUS MINUS B
.ENDS
***************************************
.SUBCKT rnodrpo_m PLUS MINUS B
.ENDS
***************************************
.SUBCKT rnodw_m PLUS MINUS B
.ENDS
***************************************
.SUBCKT rnpo1_dis PLUS MINUS B
.ENDS
***************************************
.SUBCKT rnpo1rpo_dis PLUS MINUS B
.ENDS
***************************************
.SUBCKT rnpo1w_dis PLUS MINUS B
.ENDS
***************************************
.SUBCKT rnwod_m PLUS MINUS B
.ENDS
***************************************
.SUBCKT rnwsti_m PLUS MINUS B
.ENDS
***************************************
.SUBCKT rpod_m PLUS MINUS B
.ENDS
***************************************
.SUBCKT rpodrpo_m PLUS MINUS B
.ENDS
***************************************
.SUBCKT rpodw_m PLUS MINUS B
.ENDS
***************************************
.SUBCKT rppo1_dis PLUS MINUS B
.ENDS
***************************************
.SUBCKT rppo1rpo_dis PLUS MINUS B
.ENDS
***************************************
.SUBCKT rppo1w_dis PLUS MINUS B
.ENDS
***************************************
.SUBCKT rppolyhri_dis PLUS MINUS B
.ENDS
***************************************
.SUBCKT rppolyhri_rf PLUS MINUS BULK
.ENDS
***************************************
.SUBCKT rppolyl_rf PLUS MINUS BULK
.ENDS
***************************************
.SUBCKT rppolys_rf PLUS MINUS BULK
.ENDS
***************************************
.SUBCKT rppolywo_rf PLUS MINUS BULK
.ENDS
***************************************
.SUBCKT sbd_rf PLUS MINUS BULK
.ENDS
***************************************
.SUBCKT sbd_rf_nw PLUS MINUS BULK
.ENDS
***************************************
.SUBCKT spiral_std_mu_x_40k PLUS MINUS BULK
.ENDS
***************************************
.SUBCKT spiral_sym_ct_mu_x_40k PLUS MINUS BULK CTAP
.ENDS
***************************************
.SUBCKT spiral_sym_mu_x_40k PLUS MINUS BULK
.ENDS
***************************************
.SUBCKT xjvar_nr36 PLUS MINUS BULK
.ENDS
***************************************
.SUBCKT xjvar_w40 PLUS MINUS BULK
.ENDS
***************************************
.SUBCKT tsmc_c018_sealring_corner_1p6m
** N=3 EP=0 IP=0 FDC=0
.ENDS
***************************************
.SUBCKT tsmc_c018_seal_ring_edge_1p6m
** N=3 EP=0 IP=0 FDC=0
.ENDS
***************************************
.SUBCKT ICV_4
** N=3 EP=0 IP=6 FDC=0
.ENDS
***************************************
.SUBCKT ICV_5
** N=3 EP=0 IP=6 FDC=0
.ENDS
***************************************
.SUBCKT ICV_6
** N=3 EP=0 IP=6 FDC=0
.ENDS
***************************************
.SUBCKT ICV_7
** N=3 EP=0 IP=6 FDC=0
.ENDS
***************************************
.SUBCKT ICV_8
** N=3 EP=0 IP=6 FDC=0
.ENDS
***************************************
.SUBCKT ICV_9
** N=3 EP=0 IP=6 FDC=0
.ENDS
***************************************
.SUBCKT ICV_10
** N=3 EP=0 IP=6 FDC=0
.ENDS
***************************************
.SUBCKT ICV_11
** N=3 EP=0 IP=6 FDC=0
.ENDS
***************************************
.SUBCKT ICV_12
** N=3 EP=0 IP=6 FDC=0
.ENDS
***************************************
.SUBCKT ICV_13
** N=3 EP=0 IP=6 FDC=0
.ENDS
***************************************
.SUBCKT ICV_14
** N=3 EP=0 IP=6 FDC=0
.ENDS
***************************************
.SUBCKT ICV_15
** N=3 EP=0 IP=6 FDC=0
.ENDS
***************************************
.SUBCKT ICV_16
** N=3 EP=0 IP=6 FDC=0
.ENDS
***************************************
.SUBCKT ICV_17
** N=3 EP=0 IP=6 FDC=0
.ENDS
***************************************
.SUBCKT ICV_18
** N=3 EP=0 IP=6 FDC=0
.ENDS
***************************************
.SUBCKT ICV_19
** N=3 EP=0 IP=6 FDC=0
.ENDS
***************************************
.SUBCKT ICV_20
** N=3 EP=0 IP=6 FDC=0
.ENDS
***************************************
.SUBCKT ICV_21
** N=3 EP=0 IP=6 FDC=0
.ENDS
***************************************
.SUBCKT ICV_22
** N=3 EP=0 IP=6 FDC=0
.ENDS
***************************************
.SUBCKT ICV_129
** N=3 EP=0 IP=6 FDC=0
.ENDS
***************************************
.SUBCKT padbox
** N=1 EP=0 IP=0 FDC=0
.ENDS
***************************************
.SUBCKT pad_in VSS pad VDD DataIn
** N=24 EP=4 IP=1 FDC=96
M0 VSS VSS 7 VSS N L=3.5e-07 W=9e-06 $X=5700 $Y=147100 $D=0
M1 8 7 VSS VSS N L=3.5e-07 W=9e-06 $X=8100 $Y=147100 $D=0
M2 VSS VSS 10 VSS N L=3.5e-07 W=9e-06 $X=13200 $Y=147100 $D=0
M3 10 VSS VSS VSS N L=3.5e-07 W=9e-06 $X=15600 $Y=147100 $D=0
M4 pad 10 VSS VSS N L=3.5e-07 W=2e-05 $X=15770 $Y=191300 $D=0
M5 VSS 10 pad VSS N L=3.5e-07 W=2e-05 $X=15770 $Y=196210 $D=0
M6 pad 10 VSS VSS N L=3.5e-07 W=2e-05 $X=15770 $Y=197780 $D=0
M7 VSS 10 pad VSS N L=3.5e-07 W=2e-05 $X=15770 $Y=202690 $D=0
M8 pad 10 VSS VSS N L=3.5e-07 W=2e-05 $X=15770 $Y=204260 $D=0
M9 VSS 10 pad VSS N L=3.5e-07 W=2e-05 $X=15770 $Y=209170 $D=0
M10 pad 10 VSS VSS N L=3.5e-07 W=2e-05 $X=15770 $Y=210740 $D=0
M11 VSS 10 pad VSS N L=3.5e-07 W=2e-05 $X=15770 $Y=215650 $D=0
M12 pad 10 VSS VSS N L=3.5e-07 W=2e-05 $X=15770 $Y=217220 $D=0
M13 VSS 10 pad VSS N L=3.5e-07 W=2e-05 $X=15770 $Y=222130 $D=0
M14 VSS VSS 10 VSS N L=3.5e-07 W=9e-06 $X=18000 $Y=147100 $D=0
M15 10 VSS VSS VSS N L=3.5e-07 W=9e-06 $X=20400 $Y=147100 $D=0
M16 VSS VSS 10 VSS N L=3.5e-07 W=9e-06 $X=22800 $Y=147100 $D=0
M17 10 7 VSS VSS N L=3.5e-07 W=9e-06 $X=25200 $Y=147100 $D=0
M18 VSS 7 10 VSS N L=3.5e-07 W=9e-06 $X=27600 $Y=147100 $D=0
M19 10 7 VSS VSS N L=3.5e-07 W=9e-06 $X=30000 $Y=147100 $D=0
M20 VSS 7 10 VSS N L=3.5e-07 W=9e-06 $X=32400 $Y=147100 $D=0
M21 10 7 VSS VSS N L=3.5e-07 W=9e-06 $X=34800 $Y=147100 $D=0
M22 9 8 10 VSS N L=3.5e-07 W=9e-06 $X=37200 $Y=147100 $D=0
M23 10 8 9 VSS N L=3.5e-07 W=9e-06 $X=39600 $Y=147100 $D=0
M24 9 8 10 VSS N L=3.5e-07 W=9e-06 $X=42000 $Y=147100 $D=0
M25 10 8 9 VSS N L=3.5e-07 W=9e-06 $X=44400 $Y=147100 $D=0
M26 pad 10 VSS VSS N L=3.5e-07 W=2e-05 $X=54230 $Y=191300 $D=0
M27 VSS 10 pad VSS N L=3.5e-07 W=2e-05 $X=54230 $Y=196210 $D=0
M28 pad 10 VSS VSS N L=3.5e-07 W=2e-05 $X=54230 $Y=197780 $D=0
M29 VSS 10 pad VSS N L=3.5e-07 W=2e-05 $X=54230 $Y=202690 $D=0
M30 pad 10 VSS VSS N L=3.5e-07 W=2e-05 $X=54230 $Y=204260 $D=0
M31 VSS 10 pad VSS N L=3.5e-07 W=2e-05 $X=54230 $Y=209170 $D=0
M32 pad 10 VSS VSS N L=3.5e-07 W=2e-05 $X=54230 $Y=210740 $D=0
M33 VSS 10 pad VSS N L=3.5e-07 W=2e-05 $X=54230 $Y=215650 $D=0
M34 pad 10 VSS VSS N L=3.5e-07 W=2e-05 $X=54230 $Y=217220 $D=0
M35 VSS 10 pad VSS N L=3.5e-07 W=2e-05 $X=54230 $Y=222130 $D=0
M36 11 pad VSS VSS N L=3.5e-07 W=9e-06 $X=59400 $Y=146950 $D=0
M37 VSS pad 11 VSS N L=3.5e-07 W=9e-06 $X=61800 $Y=146950 $D=0
M38 11 pad VSS VSS N L=3.5e-07 W=9e-06 $X=64200 $Y=146950 $D=0
M39 VSS pad 11 VSS N L=3.5e-07 W=9e-06 $X=66600 $Y=146950 $D=0
M40 11 pad VSS VSS N L=3.5e-07 W=9e-06 $X=69000 $Y=146950 $D=0
M41 VSS pad 11 VSS N L=3.5e-07 W=9e-06 $X=71400 $Y=146950 $D=0
M42 DataIn 11 VSS VSS N L=3.5e-07 W=9e-06 $X=73800 $Y=146950 $D=0
M43 VSS 11 DataIn VSS N L=3.5e-07 W=9e-06 $X=76200 $Y=146950 $D=0
M44 DataIn 11 VSS VSS N L=3.5e-07 W=9e-06 $X=78600 $Y=146950 $D=0
M45 VSS 11 DataIn VSS N L=3.5e-07 W=9e-06 $X=81000 $Y=146950 $D=0
M46 DataIn 11 VSS VSS N L=3.5e-07 W=9e-06 $X=83400 $Y=146950 $D=0
M47 VSS 11 DataIn VSS N L=3.5e-07 W=9e-06 $X=85800 $Y=146950 $D=0
M48 VDD VSS 7 VDD P L=3.5e-07 W=1.56e-05 $X=5700 $Y=165550 $D=16
M49 8 7 VDD VDD P L=3.5e-07 W=1.56e-05 $X=8100 $Y=165550 $D=16
M50 VDD VSS 9 VDD P L=3.5e-07 W=1.56e-05 $X=13200 $Y=165550 $D=16
M51 9 VSS VDD VDD P L=3.5e-07 W=1.56e-05 $X=15600 $Y=165550 $D=16
M52 pad 9 VDD VDD P L=3.5e-07 W=2e-05 $X=15795 $Y=97085 $D=16
M53 VDD 9 pad VDD P L=3.5e-07 W=2e-05 $X=15795 $Y=101995 $D=16
M54 pad 9 VDD VDD P L=3.5e-07 W=2e-05 $X=15795 $Y=103565 $D=16
M55 VDD 9 pad VDD P L=3.5e-07 W=2e-05 $X=15795 $Y=108475 $D=16
M56 pad 9 VDD VDD P L=3.5e-07 W=2e-05 $X=15795 $Y=110045 $D=16
M57 VDD 9 pad VDD P L=3.5e-07 W=2e-05 $X=15795 $Y=114955 $D=16
M58 pad 9 VDD VDD P L=3.5e-07 W=2e-05 $X=15795 $Y=116525 $D=16
M59 VDD 9 pad VDD P L=3.5e-07 W=2e-05 $X=15795 $Y=121435 $D=16
M60 pad 9 VDD VDD P L=3.5e-07 W=2e-05 $X=15795 $Y=123005 $D=16
M61 VDD 9 pad VDD P L=3.5e-07 W=2e-05 $X=15795 $Y=127915 $D=16
M62 VDD VSS 9 VDD P L=3.5e-07 W=1.56e-05 $X=18000 $Y=165550 $D=16
M63 9 VSS VDD VDD P L=3.5e-07 W=1.56e-05 $X=20400 $Y=165550 $D=16
M64 VDD VSS 9 VDD P L=3.5e-07 W=1.56e-05 $X=22800 $Y=165550 $D=16
M65 9 8 VDD VDD P L=3.5e-07 W=1.56e-05 $X=25200 $Y=165550 $D=16
M66 VDD 8 9 VDD P L=3.5e-07 W=1.56e-05 $X=27600 $Y=165550 $D=16
M67 9 8 VDD VDD P L=3.5e-07 W=1.56e-05 $X=30000 $Y=165550 $D=16
M68 VDD 8 9 VDD P L=3.5e-07 W=1.56e-05 $X=32400 $Y=165550 $D=16
M69 9 8 VDD VDD P L=3.5e-07 W=1.56e-05 $X=34800 $Y=165550 $D=16
M70 10 7 9 VDD P L=3.5e-07 W=1.56e-05 $X=37200 $Y=165550 $D=16
M71 9 7 10 VDD P L=3.5e-07 W=1.56e-05 $X=39600 $Y=165550 $D=16
M72 10 7 9 VDD P L=3.5e-07 W=1.56e-05 $X=42000 $Y=165550 $D=16
M73 9 7 10 VDD P L=3.5e-07 W=1.56e-05 $X=44400 $Y=165550 $D=16
M74 pad 9 VDD VDD P L=3.5e-07 W=2e-05 $X=53330 $Y=97085 $D=16
M75 VDD 9 pad VDD P L=3.5e-07 W=2e-05 $X=53330 $Y=101995 $D=16
M76 pad 9 VDD VDD P L=3.5e-07 W=2e-05 $X=53330 $Y=103565 $D=16
M77 VDD 9 pad VDD P L=3.5e-07 W=2e-05 $X=53330 $Y=108475 $D=16
M78 pad 9 VDD VDD P L=3.5e-07 W=2e-05 $X=53330 $Y=110045 $D=16
M79 VDD 9 pad VDD P L=3.5e-07 W=2e-05 $X=53330 $Y=114955 $D=16
M80 pad 9 VDD VDD P L=3.5e-07 W=2e-05 $X=53330 $Y=116525 $D=16
M81 VDD 9 pad VDD P L=3.5e-07 W=2e-05 $X=53330 $Y=121435 $D=16
M82 pad 9 VDD VDD P L=3.5e-07 W=2e-05 $X=53330 $Y=123005 $D=16
M83 VDD 9 pad VDD P L=3.5e-07 W=2e-05 $X=53330 $Y=127915 $D=16
M84 11 pad VDD VDD P L=3.5e-07 W=1.56e-05 $X=59400 $Y=165550 $D=16
M85 VDD pad 11 VDD P L=3.5e-07 W=1.56e-05 $X=61800 $Y=165550 $D=16
M86 11 pad VDD VDD P L=3.5e-07 W=1.56e-05 $X=64200 $Y=165550 $D=16
M87 VDD pad 11 VDD P L=3.5e-07 W=1.56e-05 $X=66600 $Y=165550 $D=16
M88 11 pad VDD VDD P L=3.5e-07 W=1.56e-05 $X=69000 $Y=165550 $D=16
M89 VDD pad 11 VDD P L=3.5e-07 W=1.56e-05 $X=71400 $Y=165550 $D=16
M90 DataIn 11 VDD VDD P L=3.5e-07 W=1.56e-05 $X=73800 $Y=165550 $D=16
M91 VDD 11 DataIn VDD P L=3.5e-07 W=1.56e-05 $X=76200 $Y=165550 $D=16
M92 DataIn 11 VDD VDD P L=3.5e-07 W=1.56e-05 $X=78600 $Y=165550 $D=16
M93 VDD 11 DataIn VDD P L=3.5e-07 W=1.56e-05 $X=81000 $Y=165550 $D=16
M94 DataIn 11 VDD VDD P L=3.5e-07 W=1.56e-05 $X=83400 $Y=165550 $D=16
M95 VDD 11 DataIn VDD P L=3.5e-07 W=1.56e-05 $X=85800 $Y=165550 $D=16
.ENDS
***************************************
.SUBCKT pad_fill_32
** N=4 EP=0 IP=0 FDC=0
*.CALIBRE ISOLATED NETS: VSS VDD
.ENDS
***************************************
.SUBCKT pad_fill_8
** N=4 EP=0 IP=0 FDC=0
*.CALIBRE ISOLATED NETS: VSS VDD
.ENDS
***************************************
.SUBCKT pad_fill_01
** N=4 EP=0 IP=0 FDC=0
*.CALIBRE ISOLATED NETS: VSS VDD
.ENDS
***************************************
.SUBCKT pad_fill_005
** N=4 EP=0 IP=0 FDC=0
*.CALIBRE ISOLATED NETS: VSS VDD
.ENDS
***************************************
.SUBCKT ICV_126 1 2 3 4
** N=6 EP=4 IP=62 FDC=96
X0 1 4 2 3 pad_in $T=0 619920 0 270 $X=0 $Y=529020
.ENDS
***************************************
.SUBCKT ICV_125
** N=4 EP=0 IP=24 FDC=0
.ENDS
***************************************
.SUBCKT ICV_124
** N=4 EP=0 IP=60 FDC=0
.ENDS
***************************************
.SUBCKT ICV_1 VSS VDD
** N=38 EP=2 IP=1 FDC=1
D0 VSS VDD pdio_m AREA=9e-10 PJ=0.00012 $X=8570 $Y=96300 $D=31
.ENDS
***************************************
.SUBCKT pad_corner
** N=4 EP=0 IP=0 FDC=0
*.CALIBRE ISOLATED NETS: VSS VDD
.ENDS
***************************************
.SUBCKT ICV_128
** N=4 EP=0 IP=4 FDC=0
.ENDS
***************************************
.SUBCKT ICV_127
** N=4 EP=0 IP=24 FDC=0
.ENDS
***************************************
.SUBCKT ICV_26
** N=4 EP=0 IP=4 FDC=0
.ENDS
***************************************
.SUBCKT ICV_123
** N=4 EP=0 IP=24 FDC=0
.ENDS
***************************************
.SUBCKT ICV_24
** N=4 EP=0 IP=4 FDC=0
.ENDS
***************************************
.SUBCKT ICV_122
** N=4 EP=0 IP=60 FDC=0
.ENDS
***************************************
.SUBCKT ICV_120
** N=4 EP=0 IP=8 FDC=0
.ENDS
***************************************
.SUBCKT pad_fill_16
** N=4 EP=0 IP=0 FDC=0
*.CALIBRE ISOLATED NETS: VSS VDD
.ENDS
***************************************
.SUBCKT pad_fill_4
** N=4 EP=0 IP=0 FDC=0
*.CALIBRE ISOLATED NETS: VSS VDD
.ENDS
***************************************
.SUBCKT pad_fill_2
** N=4 EP=0 IP=0 FDC=0
*.CALIBRE ISOLATED NETS: VSS VDD
.ENDS
***************************************
.SUBCKT ICV_121 1 2 3 4 5 6
** N=8 EP=6 IP=136 FDC=192
X0 1 5 2 3 pad_in $T=583310 0 0 0 $X=582410 $Y=0
X1 1 6 2 4 pad_in $T=1023415 0 0 0 $X=1022515 $Y=0
.ENDS
***************************************
.SUBCKT ICV_34
** N=4 EP=0 IP=8 FDC=0
.ENDS
***************************************
.SUBCKT ICV_35 1 2 3 4
** N=6 EP=4 IP=130 FDC=96
X0 1 4 2 3 pad_in $T=1113415 1536560 0 180 $X=1022515 $Y=1302460
.ENDS
***************************************
.SUBCKT FILL32
** N=8 EP=0 IP=0 FDC=0
.ENDS
***************************************
.SUBCKT ICV_41
** N=4 EP=0 IP=8 FDC=0
.ENDS
***************************************
.SUBCKT ICV_42
** N=5 EP=0 IP=8 FDC=0
.ENDS
***************************************
.SUBCKT ICV_45
** N=5 EP=0 IP=10 FDC=0
.ENDS
***************************************
.SUBCKT ICV_46
** N=7 EP=0 IP=10 FDC=0
.ENDS
***************************************
.SUBCKT ICV_47
** N=11 EP=0 IP=14 FDC=0
.ENDS
***************************************
.SUBCKT ICV_48
** N=19 EP=0 IP=22 FDC=0
.ENDS
***************************************
.SUBCKT FILL16
** N=8 EP=0 IP=0 FDC=0
.ENDS
***************************************
.SUBCKT FILL8
** N=8 EP=0 IP=0 FDC=0
.ENDS
***************************************
.SUBCKT FILL4
** N=4 EP=0 IP=0 FDC=0
.ENDS
***************************************
.SUBCKT FILL2
** N=4 EP=0 IP=0 FDC=0
.ENDS
***************************************
.SUBCKT FILL1
** N=4 EP=0 IP=0 FDC=0
.ENDS
***************************************
.SUBCKT ICV_36
** N=4 EP=0 IP=8 FDC=0
.ENDS
***************************************
.SUBCKT OR2X1 A B VSS VDD Z
** N=12 EP=5 IP=0 FDC=6
M0 8 A VSS VSS N L=1.8e-07 W=2.2e-07 $X=835 $Y=760 $D=0
M1 VSS B 8 VSS N L=1.8e-07 W=2.2e-07 $X=1635 $Y=760 $D=0
M2 Z 8 VSS VSS N L=1.8e-07 W=2.2e-07 $X=2435 $Y=760 $D=0
M3 9 A 8 VDD P L=1.8e-07 W=8.8e-07 $X=835 $Y=2300 $D=16
M4 VDD B 9 VDD P L=1.8e-07 W=8.8e-07 $X=1555 $Y=2300 $D=16
M5 Z 8 VDD VDD P L=1.8e-07 W=4.4e-07 $X=2315 $Y=2520 $D=16
.ENDS
***************************************
.SUBCKT NAND3X1 A B C VSS VDD Z
** N=10 EP=6 IP=0 FDC=6
M0 9 A VSS VSS N L=1.8e-07 W=6.6e-07 $X=1210 $Y=745 $D=0
M1 10 B 9 VSS N L=1.8e-07 W=6.6e-07 $X=1930 $Y=745 $D=0
M2 Z C 10 VSS N L=1.8e-07 W=6.6e-07 $X=2650 $Y=745 $D=0
M3 Z A VDD VDD P L=1.8e-07 W=4.4e-07 $X=1210 $Y=2670 $D=16
M4 VDD B Z VDD P L=1.8e-07 W=4.4e-07 $X=1930 $Y=2670 $D=16
M5 Z C VDD VDD P L=1.8e-07 W=4.4e-07 $X=2650 $Y=2670 $D=16
.ENDS
***************************************
.SUBCKT NOR2X1 A B VSS VDD Z
** N=10 EP=5 IP=0 FDC=4
M0 Z A VSS VSS N L=1.8e-07 W=2.2e-07 $X=925 $Y=760 $D=0
M1 VSS B Z VSS N L=1.8e-07 W=2.2e-07 $X=1725 $Y=760 $D=0
M2 8 A VDD VDD P L=1.8e-07 W=8.8e-07 $X=925 $Y=2300 $D=16
M3 Z B 8 VDD P L=1.8e-07 W=8.8e-07 $X=1645 $Y=2300 $D=16
.ENDS
***************************************
.SUBCKT NAND2X1 A B VSS VDD Z
** N=9 EP=5 IP=0 FDC=4
M0 9 A VSS VSS N L=1.8e-07 W=4.4e-07 $X=985 $Y=745 $D=0
M1 Z B 9 VSS N L=1.8e-07 W=4.4e-07 $X=1705 $Y=745 $D=0
M2 Z A VDD VDD P L=1.8e-07 W=4.4e-07 $X=985 $Y=2670 $D=16
M3 VDD B Z VDD P L=1.8e-07 W=4.4e-07 $X=1705 $Y=2670 $D=16
.ENDS
***************************************
.SUBCKT MUX2X1 A S B VSS VDD Z
** N=16 EP=6 IP=0 FDC=12
M0 VSS S 9 VSS N L=1.8e-07 W=4.4e-07 $X=940 $Y=960 $D=0
M1 15 A VSS VSS N L=1.8e-07 W=4.4e-07 $X=1660 $Y=960 $D=0
M2 10 9 15 VSS N L=1.8e-07 W=4.4e-07 $X=2380 $Y=960 $D=0
M3 16 S 10 VSS N L=1.8e-07 W=4.4e-07 $X=3100 $Y=960 $D=0
M4 VSS B 16 VSS N L=1.8e-07 W=4.4e-07 $X=3920 $Y=740 $D=0
M5 Z 10 VSS VSS N L=1.8e-07 W=4.4e-07 $X=4640 $Y=740 $D=0
M6 VDD S 9 VDD P L=1.8e-07 W=4.4e-07 $X=940 $Y=2520 $D=16
M7 11 A VDD VDD P L=1.8e-07 W=4.4e-07 $X=1660 $Y=2520 $D=16
M8 10 S 11 VDD P L=1.8e-07 W=4.4e-07 $X=2380 $Y=2520 $D=16
M9 12 9 10 VDD P L=1.8e-07 W=4.4e-07 $X=3100 $Y=2520 $D=16
M10 VDD B 12 VDD P L=1.8e-07 W=4.4e-07 $X=3920 $Y=2735 $D=16
M11 Z 10 VDD VDD P L=1.8e-07 W=4.4e-07 $X=4640 $Y=2735 $D=16
.ENDS
***************************************
.SUBCKT ICV_51
** N=4 EP=0 IP=8 FDC=0
.ENDS
***************************************
.SUBCKT AND2X1 A B VSS VDD Z
** N=10 EP=5 IP=0 FDC=6
M0 10 A 8 VSS N L=1.8e-07 W=4.4e-07 $X=905 $Y=750 $D=0
M1 VSS B 10 VSS N L=1.8e-07 W=4.4e-07 $X=1625 $Y=750 $D=0
M2 Z 8 VSS VSS N L=1.8e-07 W=2.2e-07 $X=2385 $Y=860 $D=0
M3 8 A VDD VDD P L=1.8e-07 W=4.4e-07 $X=905 $Y=2670 $D=16
M4 VDD B 8 VDD P L=1.8e-07 W=4.4e-07 $X=1625 $Y=2670 $D=16
M5 Z 8 VDD VDD P L=1.8e-07 W=4.4e-07 $X=2385 $Y=2670 $D=16
.ENDS
***************************************
.SUBCKT ICV_37
** N=4 EP=0 IP=8 FDC=0
.ENDS
***************************************
.SUBCKT INVX2 A VSS VDD Z
** N=6 EP=4 IP=0 FDC=2
M0 Z A VSS VSS N L=1.8e-07 W=4.4e-07 $X=740 $Y=740 $D=0
M1 Z A VDD VDD P L=1.8e-07 W=8.8e-07 $X=740 $Y=2300 $D=16
.ENDS
***************************************
.SUBCKT ICV_40
** N=4 EP=0 IP=8 FDC=0
.ENDS
***************************************
.SUBCKT DFFQSRX1 D CLK SETB RESETB VSS VDD Q
** N=34 EP=7 IP=0 FDC=40
M0 VSS D 20 VSS N L=1.8e-07 W=2.2e-07 $X=945 $Y=750 $D=0
M1 10 CLK VSS VSS N L=1.8e-07 W=2.2e-07 $X=1745 $Y=750 $D=0
M2 11 10 20 VSS N L=1.8e-07 W=2.2e-07 $X=3245 $Y=755 $D=0
M3 12 11 VSS VSS N L=1.8e-07 W=2.2e-07 $X=4745 $Y=755 $D=0
M4 13 12 VSS VSS N L=1.8e-07 W=2.2e-07 $X=6250 $Y=760 $D=0
M5 VSS 14 13 VSS N L=1.8e-07 W=2.2e-07 $X=7050 $Y=760 $D=0
M6 15 13 VSS VSS N L=1.8e-07 W=2.2e-07 $X=7850 $Y=1120 $D=0
M7 VSS SETB 14 VSS N L=1.8e-07 W=2.2e-07 $X=9355 $Y=755 $D=0
M8 22 CLK 11 VSS N L=1.8e-07 W=2.2e-07 $X=10860 $Y=750 $D=0
M9 33 15 VSS VSS N L=1.8e-07 W=4.4e-07 $X=12320 $Y=965 $D=0
M10 22 RESETB 33 VSS N L=1.8e-07 W=4.4e-07 $X=13040 $Y=965 $D=0
M11 16 CLK 15 VSS N L=1.8e-07 W=2.2e-07 $X=14500 $Y=755 $D=0
M12 34 16 VSS VSS N L=1.8e-07 W=4.4e-07 $X=15960 $Y=740 $D=0
M13 17 RESETB 34 VSS N L=1.8e-07 W=4.4e-07 $X=16680 $Y=740 $D=0
M14 18 17 VSS VSS N L=1.8e-07 W=2.2e-07 $X=18140 $Y=755 $D=0
M15 19 18 VSS VSS N L=1.8e-07 W=2.2e-07 $X=19640 $Y=755 $D=0
M16 VSS 14 19 VSS N L=1.8e-07 W=2.2e-07 $X=20440 $Y=755 $D=0
M17 24 19 VSS VSS N L=1.8e-07 W=2.2e-07 $X=21240 $Y=755 $D=0
M18 16 10 24 VSS N L=1.8e-07 W=2.2e-07 $X=22740 $Y=755 $D=0
M19 Q 17 VSS VSS N L=1.8e-07 W=2.2e-07 $X=24240 $Y=755 $D=0
M20 VDD D 20 VDD P L=1.8e-07 W=4.4e-07 $X=945 $Y=2705 $D=16
M21 10 CLK VDD VDD P L=1.8e-07 W=4.4e-07 $X=1665 $Y=2705 $D=16
M22 11 CLK 20 VDD P L=1.8e-07 W=4.4e-07 $X=3245 $Y=2725 $D=16
M23 12 11 VDD VDD P L=1.8e-07 W=4.4e-07 $X=4745 $Y=2725 $D=16
M24 21 12 13 VDD P L=1.8e-07 W=8.8e-07 $X=6250 $Y=2300 $D=16
M25 VDD 14 21 VDD P L=1.8e-07 W=8.8e-07 $X=6970 $Y=2300 $D=16
M26 15 13 VDD VDD P L=1.8e-07 W=4.4e-07 $X=7730 $Y=2520 $D=16
M27 VDD SETB 14 VDD P L=1.8e-07 W=4.4e-07 $X=9355 $Y=2535 $D=16
M28 22 10 11 VDD P L=1.8e-07 W=4.4e-07 $X=10815 $Y=2505 $D=16
M29 22 15 VDD VDD P L=1.8e-07 W=4.4e-07 $X=12320 $Y=2505 $D=16
M30 VDD RESETB 22 VDD P L=1.8e-07 W=4.4e-07 $X=13040 $Y=2505 $D=16
M31 16 10 15 VDD P L=1.8e-07 W=4.4e-07 $X=14500 $Y=2505 $D=16
M32 17 16 VDD VDD P L=1.8e-07 W=4.4e-07 $X=15960 $Y=2665 $D=16
M33 VDD RESETB 17 VDD P L=1.8e-07 W=4.4e-07 $X=16680 $Y=2665 $D=16
M34 18 17 VDD VDD P L=1.8e-07 W=4.4e-07 $X=18140 $Y=2725 $D=16
M35 23 18 19 VDD P L=1.8e-07 W=8.8e-07 $X=19640 $Y=2285 $D=16
M36 VDD 14 23 VDD P L=1.8e-07 W=8.8e-07 $X=20360 $Y=2285 $D=16
M37 24 19 VDD VDD P L=1.8e-07 W=4.4e-07 $X=21120 $Y=2505 $D=16
M38 16 CLK 24 VDD P L=1.8e-07 W=4.4e-07 $X=22740 $Y=2505 $D=16
M39 Q 17 VDD VDD P L=1.8e-07 W=4.4e-07 $X=24200 $Y=2505 $D=16
.ENDS
***************************************
.SUBCKT ICV_117
** N=5 EP=0 IP=8 FDC=0
.ENDS
***************************************
.SUBCKT ICV_118
** N=7 EP=0 IP=10 FDC=0
.ENDS
***************************************
.SUBCKT ICV_55
** N=4 EP=0 IP=8 FDC=0
.ENDS
***************************************
.SUBCKT ICV_58
** N=4 EP=0 IP=8 FDC=0
.ENDS
***************************************
.SUBCKT BUFX1 A VSS VDD Z
** N=7 EP=4 IP=0 FDC=4
M0 VSS A 7 VSS N L=1.8e-07 W=2.2e-07 $X=925 $Y=760 $D=0
M1 Z 7 VSS VSS N L=1.8e-07 W=2.2e-07 $X=1725 $Y=760 $D=0
M2 VDD A 7 VDD P L=1.8e-07 W=4.4e-07 $X=925 $Y=2715 $D=16
M3 Z 7 VDD VDD P L=1.8e-07 W=4.4e-07 $X=1645 $Y=2715 $D=16
.ENDS
***************************************
.SUBCKT ICV_113
** N=4 EP=0 IP=8 FDC=0
.ENDS
***************************************
.SUBCKT ICV_114
** N=4 EP=0 IP=8 FDC=0
.ENDS
***************************************
.SUBCKT ICV_115
** N=5 EP=0 IP=8 FDC=0
.ENDS
***************************************
.SUBCKT ICV_116
** N=7 EP=0 IP=10 FDC=0
.ENDS
***************************************
.SUBCKT ICV_119 1 2 3 4 5 6 7 8 9 10 11 12 13 14 15 16 17 18 19 20
+ 21 22 23 24 25 26 27 28 29 30 31 32 33 34 35 36 37 38 39 40
+ 41 42 43 44 45 46 47 48 49 50 51 52 53 54 55 56 57 58 59 60
+ 61 62 63 64 65 66 67 68 69 70 71 72 73 74 75 76 77 78 79 80
+ 81 82 83 84 85 86 87 88 89 90 91 92 93 94 95 96 97 98 99 100
+ 101 102 103 104 105 106 107 108 109 110 111 112 113 114 115 116 117 118 119 120
+ 121 122 123 124 125 126 127 128 129 130 131 132 133 134 135 136 137 138 139 140
+ 141 142 143 144 145 148 149 150 151 152 153 154 155 156
** N=368 EP=154 IP=3503 FDC=1536
X304 6 165 1 2 3 OR2X1 $T=820080 426960 0 180 $X=816290 $Y=422405
X305 6 166 1 2 4 OR2X1 $T=820640 426960 1 180 $X=816850 $Y=426570
X306 6 167 1 2 5 OR2X1 $T=821200 411280 1 180 $X=817410 $Y=410890
X307 6 9 1 2 10 OR2X1 $T=820080 426960 1 0 $X=819650 $Y=422405
X308 74 81 1 2 249 OR2X1 $T=930960 419120 0 0 $X=930530 $Y=418730
X309 244 247 1 2 252 OR2X1 $T=933200 411280 1 0 $X=932770 $Y=406725
X310 104 99 1 2 288 OR2X1 $T=974640 426960 1 180 $X=970850 $Y=426570
X311 112 24 1 2 292 OR2X1 $T=983600 426960 1 180 $X=979810 $Y=426570
X312 137 135 1 2 136 OR2X1 $T=1063680 426960 1 180 $X=1059890 $Y=426570
X313 141 142 1 2 337 OR2X1 $T=1083840 426960 0 0 $X=1083410 $Y=426570
X314 170 8 7 1 2 168 NAND3X1 $T=824000 419120 0 180 $X=819650 $Y=414565
X315 176 173 171 1 2 172 NAND3X1 $T=827920 411280 1 180 $X=823570 $Y=410890
X316 178 182 180 1 2 169 NAND3X1 $T=834640 411280 0 180 $X=830290 $Y=406725
X317 183 184 181 1 2 174 NAND3X1 $T=838560 419120 1 180 $X=834210 $Y=418730
X318 190 186 188 1 2 189 NAND3X1 $T=844160 419120 0 180 $X=839810 $Y=414565
X319 192 36 38 1 2 35 NAND3X1 $T=844160 426960 0 0 $X=843730 $Y=426570
X320 198 40 194 1 2 177 NAND3X1 $T=852000 426960 1 180 $X=847650 $Y=426570
X321 200 197 193 1 2 199 NAND3X1 $T=853680 403440 1 180 $X=849330 $Y=403050
X322 204 196 201 1 2 41 NAND3X1 $T=856480 419120 0 180 $X=852130 $Y=414565
X323 49 211 213 1 2 52 NAND3X1 $T=859280 419120 0 0 $X=858850 $Y=418730
X324 221 220 218 1 2 59 NAND3X1 $T=872720 411280 1 180 $X=868370 $Y=410890
X325 61 217 223 1 2 214 NAND3X1 $T=876080 426960 0 180 $X=871730 $Y=422405
X326 224 62 226 1 2 225 NAND3X1 $T=873840 419120 1 0 $X=873410 $Y=414565
X327 233 227 207 1 2 229 NAND3X1 $T=887280 411280 0 180 $X=882930 $Y=406725
X328 230 232 228 1 2 65 NAND3X1 $T=887280 419120 1 180 $X=882930 $Y=418730
X329 234 69 236 1 2 237 NAND3X1 $T=892880 419120 0 180 $X=888530 $Y=414565
X330 238 240 235 1 2 239 NAND3X1 $T=896240 419120 1 180 $X=891890 $Y=418730
X331 77 32 79 1 2 241 NAND3X1 $T=918640 411280 0 0 $X=918210 $Y=410890
X332 82 249 244 1 2 246 NAND3X1 $T=934880 426960 0 180 $X=930530 $Y=422405
X333 246 251 253 1 2 256 NAND3X1 $T=937120 419120 0 0 $X=936690 $Y=418730
X334 255 252 258 1 2 257 NAND3X1 $T=939360 403440 0 0 $X=938930 $Y=403050
X335 260 88 262 1 2 264 NAND3X1 $T=947200 426960 0 0 $X=946770 $Y=426570
X336 268 272 274 1 2 266 NAND3X1 $T=954480 403440 0 0 $X=954050 $Y=403050
X337 93 271 267 1 2 270 NAND3X1 $T=958400 426960 1 180 $X=954050 $Y=426570
X338 265 97 275 1 2 281 NAND3X1 $T=962320 426960 1 0 $X=961890 $Y=422405
X339 279 100 102 1 2 98 NAND3X1 $T=965120 426960 0 0 $X=964690 $Y=426570
X340 283 278 286 1 2 285 NAND3X1 $T=967920 411280 1 0 $X=967490 $Y=406725
X341 290 289 284 1 2 287 NAND3X1 $T=974640 426960 0 180 $X=970290 $Y=422405
X342 292 288 248 1 2 283 NAND3X1 $T=975760 411280 1 180 $X=971410 $Y=410890
X343 114 305 308 1 2 307 NAND3X1 $T=983040 426960 1 0 $X=982610 $Y=422405
X344 294 306 303 1 2 309 NAND3X1 $T=984160 403440 0 0 $X=983730 $Y=403050
X345 311 116 273 1 2 313 NAND3X1 $T=992560 419120 0 180 $X=988210 $Y=414565
X346 302 317 121 1 2 120 NAND3X1 $T=992560 426960 0 0 $X=992130 $Y=426570
X347 327 324 322 1 2 316 NAND3X1 $T=1003760 411280 0 180 $X=999410 $Y=406725
X348 328 329 330 1 2 331 NAND3X1 $T=1005440 419120 1 0 $X=1005010 $Y=414565
X349 334 333 259 1 2 131 NAND3X1 $T=1016080 419120 1 180 $X=1011730 $Y=418730
X350 168 169 1 2 167 NOR2X1 $T=820640 411280 1 0 $X=820210 $Y=406725
X351 11 172 1 2 166 NOR2X1 $T=822320 426960 0 0 $X=821890 $Y=426570
X352 174 177 1 2 165 NOR2X1 $T=825120 426960 1 0 $X=824690 $Y=422405
X353 29 189 1 2 9 NOR2X1 $T=840240 426960 0 0 $X=839810 $Y=426570
X354 199 42 1 2 202 NOR2X1 $T=852000 419120 0 0 $X=851570 $Y=418730
X355 6 202 1 2 205 NOR2X1 $T=857600 426960 0 180 $X=854370 $Y=422405
X356 214 205 1 2 55 NOR2X1 $T=864320 426960 0 180 $X=861090 $Y=422405
X357 78 32 1 2 74 NOR2X1 $T=921440 419120 1 180 $X=918210 $Y=418730
X358 6 70 1 2 72 NOR2X1 $T=920320 426960 1 0 $X=919890 $Y=422405
X359 79 78 1 2 14 NOR2X1 $T=921440 419120 0 0 $X=921010 $Y=418730
X360 244 32 1 2 67 NOR2X1 $T=927600 419120 0 180 $X=924370 $Y=414565
X361 244 70 1 2 12 NOR2X1 $T=928160 411280 0 180 $X=924930 $Y=406725
X362 18 244 1 2 68 NOR2X1 $T=925360 419120 0 0 $X=924930 $Y=418730
X363 18 78 1 2 66 NOR2X1 $T=928160 426960 1 180 $X=924930 $Y=426570
X364 264 91 1 2 90 NOR2X1 $T=951120 426960 0 0 $X=950690 $Y=426570
X365 266 269 1 2 92 NOR2X1 $T=953360 411280 0 0 $X=952930 $Y=410890
X366 287 285 1 2 293 NOR2X1 $T=974080 403440 0 0 $X=973650 $Y=403050
X367 295 293 1 2 108 NOR2X1 $T=978560 411280 1 180 $X=975330 $Y=410890
X368 113 304 1 2 269 NOR2X1 $T=983040 419120 1 0 $X=982610 $Y=414565
X369 307 281 1 2 310 NOR2X1 $T=987520 426960 1 0 $X=987090 $Y=422405
X370 6 310 1 2 118 NOR2X1 $T=993680 426960 0 180 $X=990450 $Y=422405
X371 309 316 1 2 119 NOR2X1 $T=992000 403440 0 0 $X=991570 $Y=403050
X372 326 313 1 2 333 NOR2X1 $T=1009360 419120 0 0 $X=1008930 $Y=418730
X373 331 129 1 2 304 NOR2X1 $T=1011040 411280 0 0 $X=1010610 $Y=410890
X374 335 133 1 2 247 NOR2X1 $T=1022800 419120 1 0 $X=1022370 $Y=414565
X375 32 134 1 2 335 NOR2X1 $T=1026160 419120 0 0 $X=1025730 $Y=418730
X376 138 137 1 2 332 NOR2X1 $T=1063680 419120 1 180 $X=1060450 $Y=418730
X377 175 14 1 2 170 NAND2X1 $T=825680 419120 0 0 $X=825250 $Y=418730
X378 179 12 1 2 178 NAND2X1 $T=829040 403440 1 180 $X=825810 $Y=403050
X379 175 12 1 2 176 NAND2X1 $T=826240 411280 1 0 $X=825810 $Y=406725
X380 13 14 1 2 15 NAND2X1 $T=826800 426960 0 0 $X=826370 $Y=426570
X381 19 17 1 2 171 NAND2X1 $T=831840 411280 1 180 $X=828610 $Y=410890
X382 19 21 1 2 181 NAND2X1 $T=832960 419120 1 180 $X=829730 $Y=418730
X383 19 23 1 2 180 NAND2X1 $T=831840 411280 0 0 $X=831410 $Y=410890
X384 25 14 1 2 183 NAND2X1 $T=837440 426960 1 180 $X=834210 $Y=426570
X385 24 26 1 2 182 NAND2X1 $T=835200 411280 1 0 $X=834770 $Y=406725
X386 24 22 1 2 173 NAND2X1 $T=838000 419120 0 180 $X=834770 $Y=414565
X387 24 17 1 2 186 NAND2X1 $T=839680 411280 1 180 $X=836450 $Y=410890
X388 19 27 1 2 187 NAND2X1 $T=840240 426960 1 180 $X=837010 $Y=426570
X389 24 28 1 2 184 NAND2X1 $T=838560 419120 0 0 $X=838130 $Y=418730
X390 179 14 1 2 30 NAND2X1 $T=839680 426960 1 0 $X=839250 $Y=422405
X391 19 34 1 2 33 NAND2X1 $T=842480 426960 1 0 $X=842050 $Y=422405
X392 191 14 1 2 190 NAND2X1 $T=844160 419120 1 0 $X=843730 $Y=414565
X393 19 28 1 2 193 NAND2X1 $T=848080 403440 1 180 $X=844850 $Y=403050
X394 191 12 1 2 192 NAND2X1 $T=845280 426960 1 0 $X=844850 $Y=422405
X395 19 39 1 2 188 NAND2X1 $T=846960 419120 1 0 $X=846530 $Y=414565
X396 24 16 1 2 196 NAND2X1 $T=849200 419120 0 0 $X=848770 $Y=418730
X397 24 39 1 2 197 NAND2X1 $T=849760 419120 1 0 $X=849330 $Y=414565
X398 195 12 1 2 198 NAND2X1 $T=850320 411280 1 0 $X=849890 $Y=406725
X399 19 26 1 2 201 NAND2X1 $T=853120 411280 0 0 $X=852690 $Y=410890
X400 44 43 1 2 194 NAND2X1 $T=855920 426960 1 180 $X=852690 $Y=426570
X401 195 45 1 2 203 NAND2X1 $T=853680 403440 1 0 $X=853250 $Y=398885
X402 206 12 1 2 200 NAND2X1 $T=858160 403440 1 180 $X=854930 $Y=403050
X403 208 203 1 2 48 NAND2X1 $T=860960 403440 0 180 $X=857730 $Y=398885
X404 209 14 1 2 204 NAND2X1 $T=860960 411280 1 180 $X=857730 $Y=410890
X405 209 54 1 2 212 NAND2X1 $T=860400 411280 1 0 $X=859970 $Y=406725
X406 53 50 1 2 51 NAND2X1 $T=863200 426960 1 180 $X=859970 $Y=426570
X407 185 54 1 2 208 NAND2X1 $T=863200 403440 1 0 $X=862770 $Y=398885
X408 53 56 1 2 217 NAND2X1 $T=864320 426960 0 0 $X=863890 $Y=426570
X409 219 45 1 2 210 NAND2X1 $T=867680 403440 1 180 $X=864450 $Y=403050
X410 219 54 1 2 218 NAND2X1 $T=867680 411280 0 180 $X=864450 $Y=406725
X411 58 50 1 2 215 NAND2X1 $T=867120 419120 0 0 $X=866690 $Y=418730
X412 185 45 1 2 221 NAND2X1 $T=869360 403440 0 0 $X=868930 $Y=403050
X413 222 50 1 2 220 NAND2X1 $T=872160 419120 0 180 $X=868930 $Y=414565
X414 222 56 1 2 216 NAND2X1 $T=872720 419120 1 180 $X=869490 $Y=418730
X415 206 45 1 2 224 NAND2X1 $T=873840 411280 1 0 $X=873410 $Y=406725
X416 34 63 1 2 226 NAND2X1 $T=874960 419120 0 0 $X=874530 $Y=418730
X417 64 50 1 2 223 NAND2X1 $T=877760 426960 1 0 $X=877330 $Y=422405
X418 64 12 1 2 227 NAND2X1 $T=878320 411280 0 0 $X=877890 $Y=410890
X419 229 6 1 2 230 NAND2X1 $T=882800 419120 1 0 $X=882370 $Y=414565
X420 20 66 1 2 231 NAND2X1 $T=882800 426960 1 0 $X=882370 $Y=422405
X421 57 67 1 2 234 NAND2X1 $T=886160 419120 1 0 $X=885730 $Y=414565
X422 37 68 1 2 235 NAND2X1 $T=886720 426960 1 0 $X=886290 $Y=422405
X423 43 68 1 2 236 NAND2X1 $T=887280 426960 0 0 $X=886850 $Y=426570
X424 237 70 1 2 233 NAND2X1 $T=890080 411280 1 0 $X=889650 $Y=406725
X425 39 67 1 2 240 NAND2X1 $T=894000 419120 1 0 $X=893570 $Y=414565
X426 239 72 1 2 232 NAND2X1 $T=898480 426960 1 0 $X=898050 $Y=422405
X427 241 243 1 2 242 NAND2X1 $T=920320 403440 1 0 $X=919890 $Y=398885
X428 245 70 1 2 243 NAND2X1 $T=928160 403440 1 180 $X=924930 $Y=403050
X429 78 70 1 2 80 NAND2X1 $T=930400 419120 0 180 $X=927170 $Y=414565
X430 83 68 1 2 250 NAND2X1 $T=936000 426960 1 180 $X=932770 $Y=426570
X431 84 68 1 2 251 NAND2X1 $T=937120 419120 1 180 $X=933890 $Y=418730
X432 85 67 1 2 253 NAND2X1 $T=938800 419120 0 180 $X=935570 $Y=414565
X433 250 86 1 2 254 NAND2X1 $T=937680 426960 0 0 $X=937250 $Y=426570
X434 77 76 1 2 255 NAND2X1 $T=940480 411280 0 0 $X=940050 $Y=410890
X435 256 72 1 2 259 NAND2X1 $T=941600 419120 0 0 $X=941170 $Y=418730
X436 254 72 1 2 260 NAND2X1 $T=942160 426960 0 0 $X=941730 $Y=426570
X437 248 18 1 2 261 NAND2X1 $T=945520 411280 0 0 $X=945090 $Y=410890
X438 63 87 1 2 262 NAND2X1 $T=946640 426960 1 0 $X=946210 $Y=422405
X439 263 45 1 2 89 NAND2X1 $T=950560 426960 1 0 $X=950130 $Y=422405
X440 263 12 1 2 265 NAND2X1 $T=951680 419120 1 0 $X=951250 $Y=414565
X441 84 63 1 2 267 NAND2X1 $T=954480 426960 1 0 $X=954050 $Y=422405
X442 83 63 1 2 273 NAND2X1 $T=958960 419120 0 180 $X=955730 $Y=414565
X443 276 45 1 2 274 NAND2X1 $T=961200 403440 1 180 $X=957970 $Y=403050
X444 277 45 1 2 94 NAND2X1 $T=961200 411280 1 180 $X=957970 $Y=410890
X445 84 76 1 2 275 NAND2X1 $T=958400 419120 0 0 $X=957970 $Y=418730
X446 277 54 1 2 272 NAND2X1 $T=961760 411280 0 180 $X=958530 $Y=406725
X447 95 73 1 2 271 NAND2X1 $T=962320 426960 0 180 $X=959090 $Y=422405
X448 276 12 1 2 278 NAND2X1 $T=962320 403440 0 0 $X=961890 $Y=403050
X449 280 12 1 2 279 NAND2X1 $T=966240 411280 1 180 $X=963010 $Y=410890
X450 280 45 1 2 282 NAND2X1 $T=966800 403440 1 0 $X=966370 $Y=398885
X451 95 76 1 2 284 NAND2X1 $T=967360 426960 1 0 $X=966930 $Y=422405
X452 19 101 1 2 291 NAND2X1 $T=975760 419120 0 180 $X=972530 $Y=414565
X453 103 75 1 2 289 NAND2X1 $T=974640 426960 0 0 $X=974210 $Y=426570
X454 110 296 1 2 111 NAND2X1 $T=977440 426960 0 0 $X=977010 $Y=426570
X455 299 54 1 2 297 NAND2X1 $T=981360 403440 0 180 $X=978130 $Y=398885
X456 103 19 1 2 298 NAND2X1 $T=981360 411280 1 180 $X=978130 $Y=410890
X457 24 95 1 2 296 NAND2X1 $T=981360 419120 1 180 $X=978130 $Y=418730
X458 298 301 1 2 300 NAND2X1 $T=979120 411280 1 0 $X=978690 $Y=406725
X459 24 85 1 2 301 NAND2X1 $T=981360 411280 0 0 $X=980930 $Y=410890
X460 300 113 1 2 303 NAND2X1 $T=983600 411280 1 0 $X=983170 $Y=406725
X461 99 19 1 2 305 NAND2X1 $T=986400 419120 1 180 $X=983170 $Y=418730
X462 299 45 1 2 306 NAND2X1 $T=984160 403440 1 0 $X=983730 $Y=398885
X463 24 115 1 2 308 NAND2X1 $T=987520 426960 1 180 $X=984290 $Y=426570
X464 312 45 1 2 311 NAND2X1 $T=991440 411280 0 180 $X=988210 $Y=406725
X465 312 54 1 2 314 NAND2X1 $T=992560 403440 0 180 $X=989330 $Y=398885
X466 117 56 1 2 315 NAND2X1 $T=989760 426960 0 0 $X=989330 $Y=426570
X467 319 50 1 2 318 NAND2X1 $T=994800 419120 1 0 $X=994370 $Y=414565
X468 75 124 1 2 123 NAND2X1 $T=996480 426960 0 0 $X=996050 $Y=426570
X469 323 50 1 2 320 NAND2X1 $T=1001520 411280 1 180 $X=998290 $Y=410890
X470 319 56 1 2 322 NAND2X1 $T=998720 419120 1 0 $X=998290 $Y=414565
X471 321 50 1 2 324 NAND2X1 $T=1004320 411280 1 180 $X=1001090 $Y=410890
X472 323 12 1 2 328 NAND2X1 $T=1007120 411280 0 180 $X=1003890 $Y=406725
X473 24 125 1 2 329 NAND2X1 $T=1009360 419120 1 180 $X=1006130 $Y=418730
X474 19 128 1 2 330 NAND2X1 $T=1009360 426960 1 180 $X=1006130 $Y=426570
X475 332 12 1 2 258 NAND2X1 $T=1011040 411280 0 180 $X=1007810 $Y=406725
X476 130 6 1 2 334 NAND2X1 $T=1012720 426960 0 0 $X=1012290 $Y=426570
X477 132 113 1 2 325 NAND2X1 $T=1019440 426960 0 0 $X=1019010 $Y=426570
X478 21 18 16 1 2 13 MUX2X1 $T=833520 426960 0 180 $X=827490 $Y=422405
X479 20 18 22 1 2 179 MUX2X1 $T=829600 419120 1 0 $X=829170 $Y=414565
X480 28 32 22 1 2 185 MUX2X1 $T=843600 403440 1 180 $X=837570 $Y=403050
X481 31 32 28 1 2 175 MUX2X1 $T=844160 411280 0 180 $X=838130 $Y=406725
X482 37 32 34 1 2 191 MUX2X1 $T=849200 419120 1 180 $X=843170 $Y=418730
X483 23 32 31 1 2 195 MUX2X1 $T=844160 411280 1 0 $X=843730 $Y=406725
X484 26 32 46 1 2 206 MUX2X1 $T=854240 411280 1 0 $X=853810 $Y=406725
X485 46 32 39 1 2 209 MUX2X1 $T=856480 419120 1 0 $X=856050 $Y=414565
X486 20 32 26 1 2 219 MUX2X1 $T=862080 419120 1 0 $X=861650 $Y=414565
X487 57 18 60 1 2 222 MUX2X1 $T=865440 426960 1 0 $X=865010 $Y=422405
X488 83 32 87 1 2 263 MUX2X1 $T=944400 419120 0 0 $X=943970 $Y=418730
X489 81 32 96 1 2 276 MUX2X1 $T=960080 419120 1 0 $X=959650 $Y=414565
X490 85 18 99 1 2 277 MUX2X1 $T=971280 419120 0 180 $X=965250 $Y=414565
X491 103 18 101 1 2 280 MUX2X1 $T=971840 411280 1 180 $X=965810 $Y=410890
X492 81 18 95 1 2 299 MUX2X1 $T=976880 419120 1 0 $X=976450 $Y=414565
X493 96 32 99 1 2 312 MUX2X1 $T=995360 411280 1 180 $X=989330 $Y=410890
X494 125 18 122 1 2 319 MUX2X1 $T=1000960 419120 1 180 $X=994930 $Y=418730
X495 127 18 126 1 2 321 MUX2X1 $T=1004880 426960 1 180 $X=998850 $Y=426570
X496 122 18 127 1 2 323 MUX2X1 $T=1000400 426960 1 0 $X=999970 $Y=422405
X497 77 32 133 1 2 336 MUX2X1 $T=1025600 419120 1 0 $X=1025170 $Y=414565
X519 47 187 1 2 207 AND2X1 $T=857040 426960 0 0 $X=856610 $Y=426570
X520 210 212 1 2 213 AND2X1 $T=859840 403440 0 0 $X=859410 $Y=403050
X521 216 215 1 2 211 AND2X1 $T=866560 419120 1 180 $X=862770 $Y=418730
X522 231 71 1 2 238 AND2X1 $T=895120 426960 1 180 $X=891330 $Y=426570
X523 66 72 1 2 73 AND2X1 $T=905200 426960 1 180 $X=901410 $Y=426570
X524 74 70 1 2 75 AND2X1 $T=908000 426960 0 0 $X=907570 $Y=426570
X525 66 70 1 2 76 AND2X1 $T=914160 426960 0 0 $X=913730 $Y=426570
X526 106 291 1 2 290 AND2X1 $T=977440 419120 1 180 $X=973650 $Y=418730
X527 282 297 1 2 302 AND2X1 $T=979120 395600 0 0 $X=978690 $Y=395210
X528 315 318 1 2 317 AND2X1 $T=997040 426960 0 180 $X=993250 $Y=422405
X529 320 6 1 2 295 AND2X1 $T=998720 411280 1 180 $X=994930 $Y=410890
X530 314 325 1 2 327 AND2X1 $T=999840 403440 1 0 $X=999410 $Y=398885
X531 321 56 1 2 326 AND2X1 $T=1005440 419120 0 180 $X=1001650 $Y=414565
X532 139 6 1 2 140 AND2X1 $T=1078800 426960 0 0 $X=1078370 $Y=426570
X540 225 1 2 228 INVX2 $T=879440 419120 1 0 $X=879010 $Y=414565
X541 70 1 2 79 INVX2 $T=920880 411280 1 0 $X=920450 $Y=406725
X542 78 1 2 244 INVX2 $T=928720 403440 0 0 $X=928290 $Y=403050
X543 247 1 2 245 INVX2 $T=933200 403440 1 180 $X=931090 $Y=403050
X544 80 1 2 248 INVX2 $T=931520 411280 0 0 $X=931090 $Y=410890
X545 261 1 2 24 INVX2 $T=950000 411280 0 0 $X=949570 $Y=410890
X546 270 1 2 268 INVX2 $T=956160 411280 0 180 $X=954050 $Y=406725
X547 50 1 2 286 INVX2 $T=971840 411280 1 0 $X=971410 $Y=406725
X548 105 1 2 294 INVX2 $T=974640 411280 1 0 $X=974210 $Y=406725
X549 332 1 2 134 INVX2 $T=1055840 419120 1 0 $X=1055410 $Y=414565
X553 242 107 2 148 1 2 70 DFFQSRX1 $T=934880 395600 0 180 $X=909250 $Y=391045
X554 257 107 2 148 1 2 78 DFFQSRX1 $T=953360 395600 1 180 $X=927730 $Y=395210
X555 336 107 2 148 1 2 32 DFFQSRX1 $T=1014960 411280 1 0 $X=1014530 $Y=406725
X556 150 107 2 148 1 2 135 DFFQSRX1 $T=1054160 419120 1 180 $X=1028530 $Y=418730
X557 337 152 2 148 1 2 113 DFFQSRX1 $T=1090560 419120 0 180 $X=1064930 $Y=414565
X558 151 152 2 148 1 2 137 DFFQSRX1 $T=1090560 426960 0 180 $X=1064930 $Y=422405
X559 149 152 2 148 1 2 338 DFFQSRX1 $T=1092240 419120 1 0 $X=1091810 $Y=414565
X560 154 153 2 148 1 2 143 DFFQSRX1 $T=1117440 426960 0 180 $X=1091810 $Y=422405
X561 338 153 2 148 1 2 145 DFFQSRX1 $T=1123600 426960 1 0 $X=1123170 $Y=422405
X562 156 155 2 148 1 2 144 DFFQSRX1 $T=1159440 426960 1 180 $X=1133810 $Y=426570
X592 109 1 2 107 BUFX1 $T=979120 411280 0 180 $X=975890 $Y=406725
.ENDS
***************************************
.SUBCKT ICV_71
** N=4 EP=0 IP=8 FDC=0
.ENDS
***************************************
.SUBCKT ICV_82
** N=4 EP=0 IP=8 FDC=0
.ENDS
***************************************
.SUBCKT ICV_54
** N=4 EP=0 IP=8 FDC=0
.ENDS
***************************************
.SUBCKT ICV_61 1 2 3 4 5
** N=7 EP=5 IP=11 FDC=4
X1 3 4 1 2 5 NAND2X1 $T=560 0 0 0 $X=130 $Y=-390
.ENDS
***************************************
.SUBCKT ICV_62 1 2 3 4 5
** N=7 EP=5 IP=11 FDC=4
X1 3 4 1 2 5 NAND2X1 $T=1680 0 0 0 $X=1250 $Y=-390
.ENDS
***************************************
.SUBCKT ICV_87 1 2 3 4 5
** N=7 EP=5 IP=11 FDC=4
X1 3 4 1 2 5 NAND2X1 $T=1120 0 0 0 $X=690 $Y=-390
.ENDS
***************************************
.SUBCKT ICV_111 1 2 3 4 5 6 7 8
** N=10 EP=8 IP=14 FDC=8
X0 2 3 1 5 4 NAND2X1 $T=0 0 0 0 $X=-430 $Y=-390
X1 6 7 1 5 8 NAND2X1 $T=5600 0 1 180 $X=2370 $Y=-390
.ENDS
***************************************
.SUBCKT ICV_65
** N=4 EP=0 IP=8 FDC=0
.ENDS
***************************************
.SUBCKT ICV_101
** N=4 EP=0 IP=8 FDC=0
.ENDS
***************************************
.SUBCKT ICV_52
** N=4 EP=0 IP=8 FDC=0
.ENDS
***************************************
.SUBCKT ICV_96
** N=4 EP=0 IP=8 FDC=0
.ENDS
***************************************
.SUBCKT ICV_69 1 2 3 4 5
** N=7 EP=5 IP=11 FDC=4
X1 3 4 1 2 5 NAND2X1 $T=0 0 0 0 $X=-430 $Y=-390
.ENDS
***************************************
.SUBCKT ICV_110 1 2 3 4 5
** N=7 EP=5 IP=11 FDC=4
X1 3 4 1 2 5 NAND2X1 $T=0 0 0 0 $X=-430 $Y=-390
.ENDS
***************************************
.SUBCKT ICV_93 1 2 3 4 5
** N=7 EP=5 IP=11 FDC=4
X0 2 3 1 5 4 NAND2X1 $T=6160 0 1 180 $X=2930 $Y=-390
.ENDS
***************************************
.SUBCKT ICV_104 1 2 3 4 5
** N=7 EP=5 IP=11 FDC=4
X1 3 4 1 2 5 NAND2X1 $T=5040 0 1 180 $X=1810 $Y=-390
.ENDS
***************************************
.SUBCKT ICV_53
** N=4 EP=0 IP=8 FDC=0
.ENDS
***************************************
.SUBCKT ICV_80
** N=4 EP=0 IP=8 FDC=0
.ENDS
***************************************
.SUBCKT ICV_91 1 2 3 4 5
** N=7 EP=5 IP=11 FDC=4
X1 3 4 1 2 5 NAND2X1 $T=4480 0 1 180 $X=1250 $Y=-390
.ENDS
***************************************
.SUBCKT XOR2X1 B A VDD VSS Z
** N=11 EP=5 IP=0 FDC=10
M0 VSS B 10 VSS N L=1.8e-07 W=4.4e-07 $X=630 $Y=985 $D=0
M1 8 A VSS VSS N L=1.8e-07 W=4.4e-07 $X=1350 $Y=985 $D=0
M2 9 8 10 VSS N L=1.8e-07 W=4.4e-07 $X=3205 $Y=1000 $D=0
M3 B A 9 VSS N L=1.8e-07 W=4.4e-07 $X=3925 $Y=1000 $D=0
M4 Z 9 VSS VSS N L=1.8e-07 W=4.4e-07 $X=5345 $Y=1000 $D=0
M5 VDD B 10 VDD P L=1.8e-07 W=4.4e-07 $X=630 $Y=2435 $D=16
M6 8 A VDD VDD P L=1.8e-07 W=4.4e-07 $X=1350 $Y=2435 $D=16
M7 9 A 10 VDD P L=1.8e-07 W=4.4e-07 $X=3205 $Y=2435 $D=16
M8 B 8 9 VDD P L=1.8e-07 W=4.4e-07 $X=3925 $Y=2435 $D=16
M9 Z 9 VDD VDD P L=1.8e-07 W=4.4e-07 $X=5345 $Y=2435 $D=16
.ENDS
***************************************
.SUBCKT ICV_72
** N=4 EP=0 IP=8 FDC=0
.ENDS
***************************************
.SUBCKT ICV_59 1 2 3 4 5
** N=7 EP=5 IP=11 FDC=4
X1 3 4 1 2 5 NAND2X1 $T=3360 0 1 180 $X=130 $Y=-390
.ENDS
***************************************
.SUBCKT ICV_68 1 2 3 4 5
** N=7 EP=5 IP=11 FDC=4
X1 3 4 1 2 5 NAND2X1 $T=2240 0 0 0 $X=1810 $Y=-390
.ENDS
***************************************
.SUBCKT ICV_60 1 2 3 4 5 6
** N=8 EP=6 IP=13 FDC=40
X1 4 6 2 5 1 2 3 DFFQSRX1 $T=560 0 0 0 $X=130 $Y=-390
.ENDS
***************************************
.SUBCKT ICV_79
** N=4 EP=0 IP=8 FDC=0
.ENDS
***************************************
.SUBCKT ICV_92 1 2 3 4 5
** N=7 EP=5 IP=11 FDC=4
X1 3 4 1 2 5 NAND2X1 $T=0 0 0 0 $X=-430 $Y=-390
.ENDS
***************************************
.SUBCKT ICV_66
** N=4 EP=0 IP=8 FDC=0
.ENDS
***************************************
.SUBCKT ICV_90 1 2 3 4 5
** N=7 EP=5 IP=11 FDC=4
X0 2 3 1 5 4 NAND2X1 $T=3360 0 0 0 $X=2930 $Y=-390
.ENDS
***************************************
.SUBCKT ICV_78
** N=4 EP=0 IP=8 FDC=0
.ENDS
***************************************
.SUBCKT ICV_100
** N=4 EP=0 IP=8 FDC=0
.ENDS
***************************************
.SUBCKT ICV_105 1 2 3 4 5 6 7 8
** N=10 EP=8 IP=14 FDC=8
X0 2 3 1 5 4 NAND2X1 $T=-2800 0 0 0 $X=-3230 $Y=-390
X1 6 7 1 5 8 NAND2X1 $T=0 0 0 0 $X=-430 $Y=-390
.ENDS
***************************************
.SUBCKT ICV_99
** N=4 EP=0 IP=8 FDC=0
.ENDS
***************************************
.SUBCKT ICV_108 1 2 3 4 5 6 7 8
** N=10 EP=8 IP=14 FDC=8
X0 2 3 1 5 4 NAND2X1 $T=0 0 0 0 $X=-430 $Y=-390
X1 6 7 1 5 8 NAND2X1 $T=2800 0 0 0 $X=2370 $Y=-390
.ENDS
***************************************
.SUBCKT ICV_70 1 2 3 4 5
** N=7 EP=5 IP=11 FDC=4
X1 3 4 1 2 5 NAND2X1 $T=0 0 0 0 $X=-430 $Y=-390
.ENDS
***************************************
.SUBCKT ICV_106 1 2 3 4 5
** N=7 EP=5 IP=11 FDC=4
X0 2 3 1 5 4 NAND2X1 $T=5600 0 1 180 $X=2370 $Y=-390
.ENDS
***************************************
.SUBCKT ICV_89 1 2 3 4 5
** N=7 EP=5 IP=11 FDC=4
X1 3 4 1 2 5 NAND2X1 $T=3920 0 1 180 $X=690 $Y=-390
.ENDS
***************************************
.SUBCKT ICV_109 1 2 3 4 5 6 7 8
** N=10 EP=8 IP=14 FDC=8
X0 2 3 1 5 4 NAND2X1 $T=0 0 1 180 $X=-3230 $Y=-390
X1 6 7 1 5 8 NAND2X1 $T=0 0 0 0 $X=-430 $Y=-390
.ENDS
***************************************
.SUBCKT ICV_102 1 2 3 4 5
** N=7 EP=5 IP=11 FDC=4
X1 3 4 1 2 5 NAND2X1 $T=0 0 0 0 $X=-430 $Y=-390
.ENDS
***************************************
.SUBCKT ICV_103 1 2 3 4 5 6
** N=8 EP=6 IP=12 FDC=6
X1 3 4 6 1 2 5 NAND3X1 $T=0 0 0 0 $X=-430 $Y=-390
.ENDS
***************************************
.SUBCKT ANTENNA VSS A
** N=5 EP=2 IP=0 FDC=1
*.CALIBRE ISOLATED NETS: VDD
D0 VSS A DN AREA=3.9e-13 PJ=2.54e-06 $X=300 $Y=655 $D=26
.ENDS
***************************************
.SUBCKT INVX4 A VSS VDD Z
** N=6 EP=4 IP=0 FDC=4
M0 Z A VSS VSS N L=1.8e-07 W=4.4e-07 $X=670 $Y=760 $D=0
M1 VSS A Z VSS N L=1.8e-07 W=4.4e-07 $X=1390 $Y=760 $D=0
M2 Z A VDD VDD P L=1.8e-07 W=8.8e-07 $X=670 $Y=2300 $D=16
M3 VDD A Z VDD P L=1.8e-07 W=8.8e-07 $X=1390 $Y=2300 $D=16
.ENDS
***************************************
.SUBCKT ICV_107
** N=4 EP=0 IP=8 FDC=0
.ENDS
***************************************
.SUBCKT ICV_112 1 2 3 4 5 6 7 8 9 10 11 12 13 14 15 16 17 18 19 20
+ 21 22 23 24 25 26 27 28 29 30 31 32 33 34 35 36 37 38 39 40
+ 41 42 43 44 45 46 47 48 49 50 51 52 53 54 55 56 57 58 59 60
+ 61 62 63 64 65 66 67 68 69 70 71 72 73 74 75 76 77 78 79 80
+ 81 82 83 84 85 86 87 88 89 90 91 92 93 94 95 96 97 98 99 100
+ 101 102 103 104 105 106 107 108 109 110 111 112 113 114 115 116 117 118 119 120
+ 121 122 123 124 125 126 127 128 129 130 131 132 133 134 135 136 137 138 139 140
+ 141 142 143 144 145 146 147 148 149 150 151 152 153 154 155 156 157 158 159 160
+ 161 162 163 164 165 166 167 168 169 170 171 172 173 174 175 176 177 178 179 180
+ 181 182 183 184 185 186 187 188 189 190 191 192 193 194 195 196 197 198 199 200
+ 201 202 203 204 205 206 207 208 209 210 211 212 213 214 215 216 217 218 219 220
+ 221 222 223 224 225 226 227 228 229 230 231 232 233 234 235 236 237 238 239 240
+ 241 242 243 244 245 246 247 248 249 250 251 252 253 254 255 256 257 258 259 260
+ 261 262 263 264 265 266 267 268 269 270 271 272 273 274 275 276 277 278 279 280
+ 281 282 283 284 285 286 287 288 289 290 291 292 293 294 295 296 297 298 299 300
+ 301 302 303 304 305 306 307 308 309 310 311 312 313 314 315 316 317 318 319 320
+ 321 322 323 324 325 326 327 328 329 330 331 332 333 334 335 336 337 338 339 340
+ 341 342 343 344 345 346 347 348 349 350 351 352 353 354 355 356 357 358 359 360
+ 361 362 363 364 365 366 367 368 369 370 372 373 376 377 378 379
** N=2209 EP=376 IP=20738 FDC=17110
X782 391 389 1 2 385 OR2X1 $T=627440 599440 0 180 $X=623650 $Y=594885
X783 11 14 1 2 393 OR2X1 $T=628560 607280 0 0 $X=628130 $Y=606890
X784 403 18 1 2 392 OR2X1 $T=636960 607280 1 180 $X=633170 $Y=606890
X785 20 405 1 2 404 OR2X1 $T=639760 591600 1 180 $X=635970 $Y=591210
X786 403 410 1 2 412 OR2X1 $T=644240 599440 1 0 $X=643810 $Y=594885
X787 14 410 1 2 406 OR2X1 $T=648160 591600 1 180 $X=644370 $Y=591210
X788 411 29 1 2 30 OR2X1 $T=647600 615120 0 0 $X=647170 $Y=614730
X789 81 651 1 2 620 OR2X1 $T=816160 434800 0 180 $X=812370 $Y=430245
X790 81 791 1 2 752 OR2X1 $T=836880 575920 1 180 $X=833090 $Y=575530
X791 130 866 1 2 853 OR2X1 $T=845840 568080 1 180 $X=842050 $Y=567690
X792 130 915 1 2 922 OR2X1 $T=849760 575920 0 0 $X=849330 $Y=575530
X793 81 914 1 2 951 OR2X1 $T=854240 434800 1 0 $X=853810 $Y=430245
X794 712 667 1 2 968 OR2X1 $T=856480 544560 0 0 $X=856050 $Y=544170
X795 896 667 1 2 978 OR2X1 $T=857600 544560 1 0 $X=857170 $Y=540005
X796 81 987 1 2 966 OR2X1 $T=863200 575920 1 180 $X=859410 $Y=575530
X797 900 696 1 2 1013 OR2X1 $T=863760 474000 1 0 $X=863330 $Y=469445
X798 891 696 1 2 1024 OR2X1 $T=863760 544560 0 0 $X=863330 $Y=544170
X799 106 891 1 2 1046 OR2X1 $T=866560 552400 1 0 $X=866130 $Y=547845
X800 1051 667 1 2 1028 OR2X1 $T=870480 466160 0 180 $X=866690 $Y=461605
X801 1087 1078 1 2 1066 OR2X1 $T=874960 450480 1 180 $X=871170 $Y=450090
X802 905 1088 1 2 1110 OR2X1 $T=874960 489680 1 0 $X=874530 $Y=485125
X803 717 1061 1 2 1132 OR2X1 $T=878320 489680 1 0 $X=877890 $Y=485125
X804 1099 696 1 2 1133 OR2X1 $T=878320 505360 1 0 $X=877890 $Y=500805
X805 940 696 1 2 1136 OR2X1 $T=878880 466160 1 0 $X=878450 $Y=461605
X806 764 707 1 2 1141 OR2X1 $T=886160 450480 0 180 $X=882370 $Y=445925
X807 775 1167 1 2 1173 OR2X1 $T=884480 458320 0 0 $X=884050 $Y=457930
X808 852 1167 1 2 1179 OR2X1 $T=885600 481840 1 0 $X=885170 $Y=477285
X809 919 719 1 2 1150 OR2X1 $T=889520 458320 0 180 $X=885730 $Y=453765
X810 749 1186 1 2 1189 OR2X1 $T=887280 450480 1 0 $X=886850 $Y=445925
X811 733 114 1 2 1180 OR2X1 $T=891200 544560 0 180 $X=887410 $Y=540005
X812 1167 1075 1 2 1204 OR2X1 $T=889520 458320 1 0 $X=889090 $Y=453765
X813 1012 1186 1 2 1215 OR2X1 $T=896240 442640 1 180 $X=892450 $Y=442250
X814 1213 1224 1 2 1201 OR2X1 $T=897360 474000 1 180 $X=893570 $Y=473610
X815 1235 1220 1 2 1223 OR2X1 $T=901840 489680 1 180 $X=898050 $Y=489290
X816 183 197 1 2 1231 OR2X1 $T=900720 615120 0 0 $X=900290 $Y=614730
X817 1088 1061 1 2 1160 OR2X1 $T=914160 481840 0 0 $X=913730 $Y=481450
X818 1238 1194 1 2 1246 OR2X1 $T=918080 583760 0 0 $X=917650 $Y=583370
X819 1021 1193 1 2 1250 OR2X1 $T=922000 583760 0 0 $X=921570 $Y=583370
X820 209 1265 1 2 1261 OR2X1 $T=930400 528880 1 180 $X=926610 $Y=528490
X821 599 1266 1 2 1251 OR2X1 $T=930400 568080 1 180 $X=926610 $Y=567690
X822 185 1283 1 2 1270 OR2X1 $T=932640 489680 0 180 $X=928850 $Y=485125
X823 180 1292 1 2 213 OR2X1 $T=930960 442640 1 0 $X=930530 $Y=438085
X824 1316 1186 1 2 1300 OR2X1 $T=937120 544560 1 180 $X=933330 $Y=544170
X825 190 1317 1 2 1284 OR2X1 $T=938800 497520 0 180 $X=935010 $Y=492965
X826 1292 696 1 2 1323 OR2X1 $T=940480 458320 1 180 $X=936690 $Y=457930
X827 1357 1321 1 2 1254 OR2X1 $T=943280 583760 1 180 $X=939490 $Y=583370
X828 130 1360 1 2 1348 OR2X1 $T=944960 450480 0 180 $X=941170 $Y=445925
X829 1395 1352 1 2 1372 OR2X1 $T=947200 544560 1 180 $X=943410 $Y=544170
X830 1021 1194 1 2 1398 OR2X1 $T=944400 583760 0 0 $X=943970 $Y=583370
X831 130 1416 1 2 1369 OR2X1 $T=947760 552400 0 0 $X=947330 $Y=552010
X832 1448 1061 1 2 1435 OR2X1 $T=954480 505360 0 180 $X=950690 $Y=500805
X833 1418 1061 1 2 1456 OR2X1 $T=951680 481840 1 0 $X=951250 $Y=477285
X834 1454 1321 1 2 1362 OR2X1 $T=956720 575920 1 180 $X=952930 $Y=575530
X835 1088 1467 1 2 1477 OR2X1 $T=953920 489680 1 0 $X=953490 $Y=485125
X836 1365 1453 1 2 1479 OR2X1 $T=954480 536720 1 0 $X=954050 $Y=532165
X837 225 1266 1 2 1376 OR2X1 $T=960080 575920 1 180 $X=956290 $Y=575530
X838 696 1471 1 2 1489 OR2X1 $T=961760 450480 0 180 $X=957970 $Y=445925
X839 1262 1428 1 2 1508 OR2X1 $T=960080 458320 0 0 $X=959650 $Y=457930
X840 1418 719 1 2 1511 OR2X1 $T=960640 474000 0 0 $X=960210 $Y=473610
X841 1313 667 1 2 1501 OR2X1 $T=966240 466160 1 180 $X=962450 $Y=465770
X842 1445 696 1 2 1504 OR2X1 $T=969600 466160 1 180 $X=965810 $Y=465770
X843 1167 245 1 2 1535 OR2X1 $T=966800 458320 1 0 $X=966370 $Y=453765
X844 1528 1554 1 2 246 OR2X1 $T=969040 442640 1 0 $X=968610 $Y=438085
X845 245 707 1 2 1559 OR2X1 $T=970160 458320 1 0 $X=969730 $Y=453765
X846 1550 707 1 2 1565 OR2X1 $T=970160 474000 0 0 $X=969730 $Y=473610
X847 1589 1061 1 2 1563 OR2X1 $T=975200 497520 0 180 $X=971410 $Y=492965
X848 130 1575 1 2 1457 OR2X1 $T=975760 434800 0 180 $X=971970 $Y=430245
X849 130 1576 1 2 1458 OR2X1 $T=975760 442640 0 180 $X=971970 $Y=438085
X850 1061 1578 1 2 1588 OR2X1 $T=972400 481840 0 0 $X=971970 $Y=481450
X851 1377 696 1 2 1593 OR2X1 $T=972960 528880 0 0 $X=972530 $Y=528490
X852 1347 667 1 2 1629 OR2X1 $T=976880 489680 1 0 $X=976450 $Y=485125
X853 1527 1218 1 2 1605 OR2X1 $T=980240 544560 1 180 $X=976450 $Y=544170
X854 1652 667 1 2 1613 OR2X1 $T=983600 521040 1 180 $X=979810 $Y=520650
X855 1294 696 1 2 1658 OR2X1 $T=981360 474000 1 0 $X=980930 $Y=469445
X856 1609 667 1 2 1633 OR2X1 $T=981360 536720 0 0 $X=980930 $Y=536330
X857 1589 696 1 2 1666 OR2X1 $T=982480 497520 0 0 $X=982050 $Y=497130
X858 261 707 1 2 1604 OR2X1 $T=986400 458320 0 180 $X=982610 $Y=453765
X859 667 261 1 2 1665 OR2X1 $T=983040 466160 1 0 $X=982610 $Y=461605
X860 263 696 1 2 1655 OR2X1 $T=986400 528880 1 180 $X=982610 $Y=528490
X861 1361 707 1 2 1680 OR2X1 $T=984720 458320 0 0 $X=984290 $Y=457930
X862 1674 1675 1 2 262 OR2X1 $T=988640 591600 0 180 $X=984850 $Y=587045
X863 1361 164 1 2 1684 OR2X1 $T=986400 450480 1 0 $X=985970 $Y=445925
X864 707 1685 1 2 1635 OR2X1 $T=986400 458320 1 0 $X=985970 $Y=453765
X865 1370 154 1 2 1693 OR2X1 $T=988640 450480 0 0 $X=988210 $Y=450090
X866 1727 719 1 2 1702 OR2X1 $T=994800 466160 1 180 $X=991010 $Y=465770
X867 154 1687 1 2 1750 OR2X1 $T=995360 505360 0 0 $X=994930 $Y=504970
X868 81 1823 1 2 1787 OR2X1 $T=1012160 583760 0 180 $X=1008370 $Y=579205
X869 130 1859 1 2 1738 OR2X1 $T=1017760 560240 1 180 $X=1013970 $Y=559850
X870 1527 1866 1 2 1870 OR2X1 $T=1014960 458320 1 0 $X=1014530 $Y=453765
X871 81 1851 1 2 1854 OR2X1 $T=1018320 568080 1 180 $X=1014530 $Y=567690
X872 81 1876 1 2 1828 OR2X1 $T=1017760 568080 1 0 $X=1017330 $Y=563525
X873 1866 289 1 2 1888 OR2X1 $T=1029520 442640 0 0 $X=1029090 $Y=442250
X874 301 1900 1 2 1891 OR2X1 $T=1064800 450480 0 180 $X=1061010 $Y=445925
X875 1906 292 1 2 305 OR2X1 $T=1066480 442640 1 0 $X=1066050 $Y=438085
X876 1906 1891 1 2 1930 OR2X1 $T=1067040 450480 1 0 $X=1066610 $Y=445925
X877 1931 1935 1 2 1937 OR2X1 $T=1071520 442640 1 0 $X=1071090 $Y=438085
X878 130 1931 1 2 1940 OR2X1 $T=1077120 442640 0 0 $X=1076690 $Y=442250
X879 81 1931 1 2 1950 OR2X1 $T=1081600 442640 1 0 $X=1081170 $Y=438085
X880 1957 1966 1 2 320 OR2X1 $T=1094480 450480 0 0 $X=1094050 $Y=450090
X881 2044 2042 1 2 1976 OR2X1 $T=1138720 458320 0 180 $X=1134930 $Y=453765
X882 2077 38 1 2 2086 OR2X1 $T=1153840 552400 1 0 $X=1153410 $Y=547845
X883 2094 421 1 2 2100 OR2X1 $T=1165600 591600 1 0 $X=1165170 $Y=587045
X884 2126 2137 1 2 2142 OR2X1 $T=1181280 560240 0 0 $X=1180850 $Y=559850
X885 2151 357 1 2 356 OR2X1 $T=1193040 615120 1 180 $X=1189250 $Y=614730
X886 390 386 387 1 2 7 NAND3X1 $T=627440 607280 1 180 $X=623090 $Y=606890
X887 19 398 16 1 2 395 NAND3X1 $T=636960 615120 1 180 $X=632610 $Y=614730
X888 407 404 406 1 2 397 NAND3X1 $T=642000 591600 0 180 $X=637650 $Y=587045
X889 21 399 24 1 2 409 NAND3X1 $T=639200 607280 0 0 $X=638770 $Y=606890
X890 26 13 23 1 2 410 NAND3X1 $T=648720 599440 1 180 $X=644370 $Y=599050
X891 413 414 23 1 2 415 NAND3X1 $T=649840 599440 0 0 $X=649410 $Y=599050
X892 417 11 6 1 2 416 NAND3X1 $T=656560 615120 1 180 $X=652210 $Y=614730
X893 32 416 419 1 2 34 NAND3X1 $T=656560 615120 0 0 $X=656130 $Y=614730
X894 417 5 26 1 2 423 NAND3X1 $T=660480 615120 0 0 $X=660050 $Y=614730
X895 423 409 418 1 2 35 NAND3X1 $T=664960 607280 0 180 $X=660610 $Y=602725
X896 632 639 643 1 2 629 NAND3X1 $T=809440 442640 0 0 $X=809010 $Y=442250
X897 637 642 649 1 2 626 NAND3X1 $T=810560 458320 0 0 $X=810130 $Y=457930
X898 660 652 644 1 2 630 NAND3X1 $T=816720 466160 1 180 $X=812370 $Y=465770
X899 676 692 701 1 2 675 NAND3X1 $T=818960 450480 1 0 $X=818530 $Y=445925
X900 679 90 703 1 2 683 NAND3X1 $T=818960 528880 1 0 $X=818530 $Y=524325
X901 92 671 677 1 2 89 NAND3X1 $T=823440 466160 1 180 $X=819090 $Y=465770
X902 94 726 736 1 2 693 NAND3X1 $T=823440 434800 0 0 $X=823010 $Y=434410
X903 713 727 737 1 2 730 NAND3X1 $T=823440 442640 0 0 $X=823010 $Y=442250
X904 722 729 740 1 2 739 NAND3X1 $T=824000 575920 0 0 $X=823570 $Y=575530
X905 710 735 744 1 2 699 NAND3X1 $T=824560 536720 0 0 $X=824130 $Y=536330
X906 706 742 721 1 2 747 NAND3X1 $T=825680 552400 0 0 $X=825250 $Y=552010
X907 763 755 743 1 2 97 NAND3X1 $T=831840 442640 1 180 $X=827490 $Y=442250
X908 796 787 768 1 2 781 NAND3X1 $T=836880 560240 0 180 $X=832530 $Y=555685
X909 778 703 808 1 2 809 NAND3X1 $T=835200 474000 1 0 $X=834770 $Y=469445
X910 780 795 816 1 2 810 NAND3X1 $T=835200 521040 0 0 $X=834770 $Y=520650
X911 767 820 829 1 2 825 NAND3X1 $T=836880 544560 0 0 $X=836450 $Y=544170
X912 819 814 803 1 2 798 NAND3X1 $T=840800 560240 0 180 $X=836450 $Y=555685
X913 807 839 122 1 2 700 NAND3X1 $T=839120 434800 1 0 $X=838690 $Y=430245
X914 823 811 831 1 2 843 NAND3X1 $T=839120 505360 0 0 $X=838690 $Y=504970
X915 121 820 848 1 2 123 NAND3X1 $T=839680 434800 0 0 $X=839250 $Y=434410
X916 815 855 869 1 2 863 NAND3X1 $T=840800 458320 0 0 $X=840370 $Y=457930
X917 867 854 840 1 2 688 NAND3X1 $T=845280 442640 0 180 $X=840930 $Y=438085
X918 868 831 821 1 2 856 NAND3X1 $T=845280 450480 1 180 $X=840930 $Y=450090
X919 124 847 876 1 2 872 NAND3X1 $T=841920 521040 1 0 $X=841490 $Y=516485
X920 790 880 889 1 2 129 NAND3X1 $T=843600 434800 0 0 $X=843170 $Y=434410
X921 885 874 864 1 2 835 NAND3X1 $T=847520 560240 1 180 $X=843170 $Y=559850
X922 909 898 862 1 2 895 NAND3X1 $T=851440 466160 0 180 $X=847090 $Y=461605
X923 824 901 898 1 2 910 NAND3X1 $T=847520 536720 1 0 $X=847090 $Y=532165
X924 881 855 923 1 2 920 NAND3X1 $T=849200 521040 0 0 $X=848770 $Y=520650
X925 916 827 933 1 2 929 NAND3X1 $T=850880 450480 1 0 $X=850450 $Y=445925
X926 800 926 941 1 2 938 NAND3X1 $T=852000 544560 0 0 $X=851570 $Y=544170
X927 924 839 942 1 2 939 NAND3X1 $T=852000 552400 0 0 $X=851570 $Y=552010
X928 946 851 925 1 2 930 NAND3X1 $T=857040 544560 0 180 $X=852690 $Y=540005
X929 759 944 912 1 2 949 NAND3X1 $T=853680 466160 1 0 $X=853250 $Y=461605
X930 943 892 959 1 2 955 NAND3X1 $T=854800 591600 1 0 $X=854370 $Y=587045
X931 794 884 969 1 2 963 NAND3X1 $T=855920 458320 1 0 $X=855490 $Y=453765
X932 904 957 971 1 2 964 NAND3X1 $T=855920 513200 1 0 $X=855490 $Y=508645
X933 884 967 979 1 2 975 NAND3X1 $T=857040 528880 1 0 $X=856610 $Y=524325
X934 974 945 996 1 2 992 NAND3X1 $T=859280 474000 1 0 $X=858850 $Y=469445
X935 151 993 948 1 2 995 NAND3X1 $T=859840 442640 0 0 $X=859410 $Y=442250
X936 998 976 954 1 2 980 NAND3X1 $T=863760 544560 1 180 $X=859410 $Y=544170
X937 999 988 813 1 2 981 NAND3X1 $T=863760 560240 0 180 $X=859410 $Y=555685
X938 1038 1028 1013 1 2 677 NAND3X1 $T=869360 466160 1 180 $X=865010 $Y=465770
X939 1017 1014 1044 1 2 1036 NAND3X1 $T=865440 560240 1 0 $X=865010 $Y=555685
X940 1040 1029 917 1 2 1034 NAND3X1 $T=869360 591600 1 180 $X=865010 $Y=591210
X941 1042 1018 1019 1 2 989 NAND3X1 $T=869920 442640 0 180 $X=865570 $Y=438085
X942 1057 1045 1020 1 2 1005 NAND3X1 $T=871600 489680 0 180 $X=867250 $Y=485125
X943 1048 1047 1035 1 2 1027 NAND3X1 $T=871600 575920 0 180 $X=867250 $Y=571365
X944 1038 968 1024 1 2 1053 NAND3X1 $T=873280 544560 1 180 $X=868930 $Y=544170
X945 1056 1065 1072 1 2 1073 NAND3X1 $T=869920 521040 0 0 $X=869490 $Y=520650
X946 1079 1067 1050 1 2 1001 NAND3X1 $T=874400 458320 0 180 $X=870050 $Y=453765
X947 1093 1071 1068 1 2 1086 NAND3X1 $T=876080 442640 0 180 $X=871730 $Y=438085
X948 1095 1083 1070 1 2 1058 NAND3X1 $T=876080 552400 0 180 $X=871730 $Y=547845
X949 1085 1097 1106 1 2 937 NAND3X1 $T=873840 528880 0 0 $X=873410 $Y=528490
X950 1022 1098 1053 1 2 1101 NAND3X1 $T=873840 575920 0 0 $X=873410 $Y=575530
X951 1049 1102 1104 1 2 1078 NAND3X1 $T=874960 450480 0 0 $X=874530 $Y=450090
X952 1103 1116 1100 1 2 1087 NAND3X1 $T=880560 434800 1 180 $X=876210 $Y=434410
X953 1105 1118 1069 1 2 1123 NAND3X1 $T=876640 505360 0 0 $X=876210 $Y=504970
X954 1126 1119 1094 1 2 1114 NAND3X1 $T=881120 544560 1 180 $X=876770 $Y=544170
X955 1134 1125 1117 1 2 624 NAND3X1 $T=882240 442640 0 180 $X=877890 $Y=438085
X956 1038 1131 1136 1 2 1093 NAND3X1 $T=878880 466160 0 0 $X=878450 $Y=465770
X957 1153 1147 1092 1 2 1138 NAND3X1 $T=885040 560240 1 180 $X=880690 $Y=559850
X958 1154 1109 1120 1 2 1139 NAND3X1 $T=885040 583760 0 180 $X=880690 $Y=579205
X959 1142 1112 1151 1 2 1157 NAND3X1 $T=881680 505360 1 0 $X=881250 $Y=500805
X960 1158 1149 1137 1 2 1062 NAND3X1 $T=885600 536720 1 180 $X=881250 $Y=536330
X961 1159 1150 1141 1 2 1079 NAND3X1 $T=886160 458320 0 180 $X=881810 $Y=453765
X962 1160 1132 1110 1 2 1148 NAND3X1 $T=886160 489680 0 180 $X=881810 $Y=485125
X963 1165 1166 1107 1 2 1170 NAND3X1 $T=888400 552400 0 180 $X=884050 $Y=547845
X964 1174 1185 1199 1 2 973 NAND3X1 $T=886720 568080 1 0 $X=886290 $Y=563525
X965 1177 1184 1201 1 2 1191 NAND3X1 $T=887280 474000 0 0 $X=886850 $Y=473610
X966 1046 1180 1202 1 2 1185 NAND3X1 $T=887280 544560 0 0 $X=886850 $Y=544170
X967 1128 1187 1188 1 2 1171 NAND3X1 $T=887280 575920 1 0 $X=886850 $Y=571365
X968 1206 1196 1176 1 2 1031 NAND3X1 $T=892320 505360 1 180 $X=887970 $Y=504970
X969 1212 1203 1192 1 2 1115 NAND3X1 $T=893440 560240 1 180 $X=889090 $Y=559850
X970 1230 1228 1225 1 2 1135 NAND3X1 $T=899600 513200 0 180 $X=895250 $Y=508645
X971 1231 1227 189 1 2 192 NAND3X1 $T=899600 615120 1 180 $X=895250 $Y=614730
X972 1237 201 1239 1 2 202 NAND3X1 $T=909120 615120 1 0 $X=908690 $Y=610565
X973 205 1244 75 1 2 203 NAND3X1 $T=919760 615120 1 180 $X=915410 $Y=614730
X974 1251 1246 635 1 2 1247 NAND3X1 $T=925920 575920 1 180 $X=921570 $Y=575530
X975 1247 1248 1256 1 2 1253 NAND3X1 $T=922560 568080 0 0 $X=922130 $Y=567690
X976 1252 1261 1255 1 2 1257 NAND3X1 $T=924800 560240 1 0 $X=924370 $Y=555685
X977 1285 1271 130 1 2 1260 NAND3X1 $T=932080 552400 0 180 $X=927730 $Y=547845
X978 1270 1284 101 1 2 1276 NAND3X1 $T=928720 489680 0 0 $X=928290 $Y=489290
X979 1276 1289 1295 1 2 1264 NAND3X1 $T=929840 497520 1 0 $X=929410 $Y=492965
X980 1258 1287 1297 1 2 1291 NAND3X1 $T=929840 583760 1 0 $X=929410 $Y=579205
X981 1272 1310 1319 1 2 1315 NAND3X1 $T=933760 521040 1 0 $X=933330 $Y=516485
X982 1325 1277 1302 1 2 1306 NAND3X1 $T=938800 505360 1 180 $X=934450 $Y=504970
X983 1326 1263 1303 1 2 214 NAND3X1 $T=938800 521040 1 180 $X=934450 $Y=520650
X984 1038 1323 1329 1 2 1332 NAND3X1 $T=936000 466160 0 0 $X=935570 $Y=465770
X985 1288 1327 1338 1 2 1282 NAND3X1 $T=936000 552400 0 0 $X=935570 $Y=552010
X986 1340 1336 81 1 2 1330 NAND3X1 $T=941600 474000 1 180 $X=937250 $Y=473610
X987 1259 1350 1343 1 2 1352 NAND3X1 $T=939920 544560 0 0 $X=939490 $Y=544170
X988 1366 1328 1345 1 2 1296 NAND3X1 $T=944400 568080 0 180 $X=940050 $Y=563525
X989 1348 1351 1374 1 2 1354 NAND3X1 $T=941040 442640 0 0 $X=940610 $Y=442250
X990 1353 1297 1322 1 2 1358 NAND3X1 $T=944960 591600 0 180 $X=940610 $Y=587045
X991 1376 1362 101 1 2 1353 NAND3X1 $T=945520 575920 1 180 $X=941170 $Y=575530
X992 1387 1373 1355 1 2 1364 NAND3X1 $T=946640 505360 0 180 $X=942290 $Y=500805
X993 1332 1383 1393 1 2 1388 NAND3X1 $T=943280 466160 0 0 $X=942850 $Y=465770
X994 1400 1391 1367 1 2 1375 NAND3X1 $T=948880 458320 1 180 $X=944530 $Y=457930
X995 1376 1398 635 1 2 1406 NAND3X1 $T=945520 575920 0 0 $X=945090 $Y=575530
X996 1392 1396 1404 1 2 1409 NAND3X1 $T=946080 434800 0 0 $X=945650 $Y=434410
X997 1417 1403 1394 1 2 1349 NAND3X1 $T=950560 489680 1 180 $X=946210 $Y=489290
X998 1402 1350 1424 1 2 1412 NAND3X1 $T=947200 544560 0 0 $X=946770 $Y=544170
X999 1407 1419 1429 1 2 1422 NAND3X1 $T=947760 599440 1 0 $X=947330 $Y=594885
X1000 1432 1420 1399 1 2 1410 NAND3X1 $T=952240 513200 1 180 $X=947890 $Y=512810
X1001 1406 1328 1444 1 2 1426 NAND3X1 $T=949440 575920 0 0 $X=949010 $Y=575530
X1002 1459 1449 1436 1 2 1385 NAND3X1 $T=955600 458320 0 180 $X=951250 $Y=453765
X1003 1480 1470 1437 1 2 1395 NAND3X1 $T=958400 474000 1 180 $X=954050 $Y=473610
X1004 1160 1456 1477 1 2 233 NAND3X1 $T=954480 481840 0 0 $X=954050 $Y=481450
X1005 1439 1473 1479 1 2 1481 NAND3X1 $T=954480 528880 0 0 $X=954050 $Y=528490
X1006 234 1476 1463 1 2 232 NAND3X1 $T=958960 434800 0 180 $X=954610 $Y=430245
X1007 1494 1298 1478 1 2 1487 NAND3X1 $T=960640 583760 1 180 $X=956290 $Y=583370
X1008 1038 1501 1504 1 2 1502 NAND3X1 $T=958960 466160 0 0 $X=958530 $Y=465770
X1009 1529 1536 1547 1 2 1513 NAND3X1 $T=965680 474000 0 0 $X=965250 $Y=473610
X1010 1537 1517 1514 1 2 1542 NAND3X1 $T=970720 575920 1 180 $X=966370 $Y=575530
X1011 1159 1553 1559 1 2 1556 NAND3X1 $T=967920 450480 0 0 $X=967490 $Y=450090
X1012 1546 1556 1557 1 2 1554 NAND3X1 $T=968480 442640 0 0 $X=968050 $Y=442250
X1013 1386 1569 1587 1 2 1519 NAND3X1 $T=971280 481840 1 0 $X=970850 $Y=477285
X1014 1160 1521 1588 1 2 1564 NAND3X1 $T=971280 489680 1 0 $X=970850 $Y=485125
X1015 1564 1572 1592 1 2 1590 NAND3X1 $T=971840 505360 0 0 $X=971410 $Y=504970
X1016 1607 1598 1573 1 2 1413 NAND3X1 $T=978560 560240 1 180 $X=974210 $Y=559850
X1017 1159 1604 1614 1 2 1577 NAND3X1 $T=975200 458320 1 0 $X=974770 $Y=453765
X1018 1159 1511 1565 1 2 1594 NAND3X1 $T=979120 474000 0 180 $X=974770 $Y=469445
X1019 1615 1620 1626 1 2 255 NAND3X1 $T=978000 458320 0 0 $X=977570 $Y=457930
X1020 1619 1622 1568 1 2 257 NAND3X1 $T=978000 591600 1 0 $X=977570 $Y=587045
X1021 1159 1635 1579 1 2 1615 NAND3X1 $T=983040 458320 0 180 $X=978690 $Y=453765
X1022 1301 1639 1638 1 2 1659 NAND3X1 $T=981360 560240 1 0 $X=980930 $Y=555685
X1023 1660 1651 1617 1 2 1654 NAND3X1 $T=985280 575920 0 180 $X=980930 $Y=571365
X1024 1649 1583 1668 1 2 1618 NAND3X1 $T=981920 583760 0 0 $X=981490 $Y=583370
X1025 1038 1665 1658 1 2 1669 NAND3X1 $T=983040 466160 0 0 $X=982610 $Y=465770
X1026 1667 1671 1678 1 2 1682 NAND3X1 $T=984720 513200 1 0 $X=984290 $Y=508645
X1027 1636 1679 1688 1 2 1674 NAND3X1 $T=985280 575920 1 0 $X=984850 $Y=571365
X1028 1673 1647 1692 1 2 1676 NAND3X1 $T=985840 434800 0 0 $X=985410 $Y=434410
X1029 1693 1684 93 1 2 1673 NAND3X1 $T=990320 442640 1 180 $X=985970 $Y=442250
X1030 1648 1691 1677 1 2 1697 NAND3X1 $T=986960 466160 0 0 $X=986530 $Y=465770
X1031 1159 1702 1680 1 2 1694 NAND3X1 $T=992560 466160 0 180 $X=988210 $Y=461605
X1032 1711 1657 1663 1 2 1707 NAND3X1 $T=992560 568080 0 180 $X=988210 $Y=563525
X1033 1714 1672 1624 1 2 1709 NAND3X1 $T=993120 568080 1 180 $X=988770 $Y=567690
X1034 1718 1725 1737 1 2 1708 NAND3X1 $T=992000 442640 1 0 $X=991570 $Y=438085
X1035 1733 1723 1712 1 2 1686 NAND3X1 $T=995920 450480 0 180 $X=991570 $Y=445925
X1036 1661 1689 1736 1 2 1735 NAND3X1 $T=992000 536720 0 0 $X=991570 $Y=536330
X1037 1738 1726 1696 1 2 1730 NAND3X1 $T=996480 560240 1 180 $X=992130 $Y=559850
X1038 1721 1743 1722 1 2 1753 NAND3X1 $T=995360 544560 1 0 $X=994930 $Y=540005
X1039 1755 1746 1731 1 2 1742 NAND3X1 $T=999840 458320 0 180 $X=995490 $Y=453765
X1040 1761 1760 1744 1 2 1771 NAND3X1 $T=998720 560240 1 0 $X=998290 $Y=555685
X1041 1777 1746 1747 1 2 1764 NAND3X1 $T=1003760 505360 1 180 $X=999410 $Y=504970
X1042 1787 1778 1745 1 2 1780 NAND3X1 $T=1005440 583760 0 180 $X=1001090 $Y=579205
X1043 1765 1772 1715 1 2 1798 NAND3X1 $T=1003200 434800 1 0 $X=1002770 $Y=430245
X1044 1782 1752 1734 1 2 1800 NAND3X1 $T=1003200 497520 1 0 $X=1002770 $Y=492965
X1045 1783 1793 1724 1 2 1802 NAND3X1 $T=1003200 528880 1 0 $X=1002770 $Y=524325
X1046 1768 1794 1774 1 2 1804 NAND3X1 $T=1003200 560240 0 0 $X=1002770 $Y=559850
X1047 1790 1766 1810 1 2 1421 NAND3X1 $T=1004320 544560 1 0 $X=1003890 $Y=540005
X1048 1813 1488 1759 1 2 1826 NAND3X1 $T=1007680 513200 1 0 $X=1007250 $Y=508645
X1049 1828 1762 1784 1 2 1819 NAND3X1 $T=1011600 568080 1 180 $X=1007250 $Y=567690
X1050 1837 1751 1488 1 2 279 NAND3X1 $T=1013280 466160 0 180 $X=1008930 $Y=461605
X1051 1835 1831 1796 1 2 1827 NAND3X1 $T=1013280 560240 0 180 $X=1008930 $Y=555685
X1052 1843 1809 1791 1 2 1833 NAND3X1 $T=1013840 442640 0 180 $X=1009490 $Y=438085
X1053 1841 1848 1807 1 2 1824 NAND3X1 $T=1015520 450480 1 180 $X=1011170 $Y=450090
X1054 1836 1815 1759 1 2 283 NAND3X1 $T=1016640 434800 0 180 $X=1012290 $Y=430245
X1055 1864 1848 1830 1 2 1856 NAND3X1 $T=1017760 505360 0 180 $X=1013410 $Y=500805
X1056 1868 1858 1821 1 2 1862 NAND3X1 $T=1018320 552400 0 180 $X=1013970 $Y=547845
X1057 1849 1850 1869 1 2 1871 NAND3X1 $T=1014960 489680 0 0 $X=1014530 $Y=489290
X1058 1855 1863 1829 1 2 1872 NAND3X1 $T=1014960 497520 1 0 $X=1014530 $Y=492965
X1059 1860 1865 1820 1 2 1845 NAND3X1 $T=1018880 521040 0 180 $X=1014530 $Y=516485
X1060 1846 1861 1852 1 2 1853 NAND3X1 $T=1019440 536720 0 180 $X=1015090 $Y=532165
X1061 1857 1840 1875 1 2 1874 NAND3X1 $T=1016080 544560 1 0 $X=1015650 $Y=540005
X1062 290 99 635 1 2 1887 NAND3X1 $T=1034000 458320 0 180 $X=1029650 $Y=453765
X1063 290 99 662 1 2 1892 NAND3X1 $T=1035120 442640 0 0 $X=1034690 $Y=442250
X1064 1888 1891 662 1 2 1890 NAND3X1 $T=1035680 450480 1 0 $X=1035250 $Y=445925
X1065 1906 300 301 1 2 1931 NAND3X1 $T=1067040 442640 0 0 $X=1066610 $Y=442250
X1066 2057 2046 2050 1 2 44 NAND3X1 $T=1148240 474000 0 180 $X=1143890 $Y=469445
X1067 37 2091 2083 1 2 2085 NAND3X1 $T=1163360 552400 0 180 $X=1159010 $Y=547845
X1068 2111 2087 421 1 2 2093 NAND3X1 $T=1172320 552400 1 180 $X=1167970 $Y=552010
X1069 37 2109 2102 1 2 2105 NAND3X1 $T=1172880 528880 1 180 $X=1168530 $Y=528490
X1070 2107 2115 344 1 2 2106 NAND3X1 $T=1175120 568080 1 180 $X=1170770 $Y=567690
X1071 2129 2127 2121 1 2 2097 NAND3X1 $T=1180160 552400 0 180 $X=1175810 $Y=547845
X1072 2130 2110 2122 1 2 2112 NAND3X1 $T=1180160 583760 0 180 $X=1175810 $Y=579205
X1073 2135 2143 349 1 2 351 NAND3X1 $T=1186320 607280 0 180 $X=1181970 $Y=602725
X1074 2135 353 284 1 2 354 NAND3X1 $T=1182960 615120 1 0 $X=1182530 $Y=610565
X1075 37 2145 2127 1 2 2144 NAND3X1 $T=1189120 544560 1 180 $X=1184770 $Y=544170
X1076 37 2138 2131 1 2 2146 NAND3X1 $T=1190240 528880 1 180 $X=1185890 $Y=528490
X1077 37 2145 2139 1 2 2150 NAND3X1 $T=1190240 552400 0 180 $X=1185890 $Y=547845
X1078 2151 359 349 1 2 360 NAND3X1 $T=1194160 615120 1 0 $X=1193730 $Y=610565
X1079 13 15 1 2 391 NOR2X1 $T=629120 599440 0 0 $X=628690 $Y=599050
X1080 15 396 1 2 394 NOR2X1 $T=631920 599440 1 0 $X=631490 $Y=594885
X1081 394 397 1 2 17 NOR2X1 $T=632480 591600 1 0 $X=632050 $Y=587045
X1082 400 402 1 2 396 NOR2X1 $T=634720 599440 1 0 $X=634290 $Y=594885
X1083 25 403 1 2 411 NOR2X1 $T=648160 607280 0 180 $X=644930 $Y=602725
X1084 23 13 1 2 8 NOR2X1 $T=651520 599440 1 0 $X=651090 $Y=594885
X1085 25 11 1 2 18 NOR2X1 $T=656000 615120 0 180 $X=652770 $Y=610565
X1086 24 13 1 2 408 NOR2X1 $T=658800 599440 0 0 $X=658370 $Y=599050
X1087 24 10 1 2 5 NOR2X1 $T=660480 615120 1 0 $X=660050 $Y=610565
X1088 624 629 1 2 625 NOR2X1 $T=806640 442640 0 0 $X=806210 $Y=442250
X1089 626 630 1 2 623 NOR2X1 $T=807200 466160 1 0 $X=806770 $Y=461605
X1090 678 655 1 2 671 NOR2X1 $T=820640 474000 0 180 $X=817410 $Y=469445
X1091 675 688 1 2 681 NOR2X1 $T=818960 442640 0 0 $X=818530 $Y=442250
X1092 693 700 1 2 651 NOR2X1 $T=820640 434800 0 0 $X=820210 $Y=434410
X1093 739 761 1 2 762 NOR2X1 $T=829600 575920 0 0 $X=829170 $Y=575530
X1094 781 798 1 2 793 NOR2X1 $T=834080 568080 0 0 $X=833650 $Y=567690
X1095 747 804 1 2 801 NOR2X1 $T=835200 583760 0 0 $X=834770 $Y=583370
X1096 835 810 1 2 791 NOR2X1 $T=841920 560240 1 180 $X=838690 $Y=559850
X1097 825 859 1 2 866 NOR2X1 $T=843600 544560 0 0 $X=843170 $Y=544170
X1098 137 138 1 2 914 NOR2X1 $T=849760 434800 1 0 $X=849330 $Y=430245
X1099 872 910 1 2 915 NOR2X1 $T=851440 536720 1 0 $X=851010 $Y=532165
X1100 929 730 1 2 928 NOR2X1 $T=855360 442640 1 180 $X=852130 $Y=442250
X1101 937 930 1 2 684 NOR2X1 $T=855920 536720 1 180 $X=852690 $Y=536330
X1102 863 963 1 2 984 NOR2X1 $T=859840 458320 1 0 $X=859410 $Y=453765
X1103 964 843 1 2 983 NOR2X1 $T=859840 513200 1 0 $X=859410 $Y=508645
X1104 980 981 1 2 987 NOR2X1 $T=862640 560240 1 180 $X=859410 $Y=559850
X1105 952 991 1 2 152 NOR2X1 $T=859840 591600 0 0 $X=859410 $Y=591210
X1106 949 157 1 2 974 NOR2X1 $T=860400 466160 1 0 $X=859970 $Y=461605
X1107 989 995 1 2 680 NOR2X1 $T=860960 442640 1 0 $X=860530 $Y=438085
X1108 1005 965 1 2 977 NOR2X1 $T=864880 575920 0 180 $X=861650 $Y=571365
X1109 1001 160 1 2 158 NOR2X1 $T=862640 458320 1 0 $X=862210 $Y=453765
X1110 130 983 1 2 1002 NOR2X1 $T=865440 513200 0 180 $X=862210 $Y=508645
X1111 130 984 1 2 1025 NOR2X1 $T=868240 458320 0 180 $X=865010 $Y=453765
X1112 1002 1031 1 2 165 NOR2X1 $T=865440 513200 1 0 $X=865010 $Y=508645
X1113 1052 975 1 2 1048 NOR2X1 $T=871040 528880 0 180 $X=867810 $Y=524325
X1114 1058 1034 1 2 166 NOR2X1 $T=871600 599440 0 180 $X=868370 $Y=594885
X1115 1023 167 1 2 1059 NOR2X1 $T=869360 458320 0 0 $X=868930 $Y=457930
X1116 1062 1073 1 2 871 NOR2X1 $T=871040 536720 1 0 $X=870610 $Y=532165
X1117 1066 1025 1 2 170 NOR2X1 $T=874400 458320 0 0 $X=873970 $Y=457930
X1118 1076 1115 1 2 1098 NOR2X1 $T=876080 560240 1 0 $X=875650 $Y=555685
X1119 1114 955 1 2 175 NOR2X1 $T=877200 591600 0 0 $X=876770 $Y=591210
X1120 1123 1135 1 2 1011 NOR2X1 $T=879440 513200 1 0 $X=879010 $Y=508645
X1121 1138 939 1 2 1144 NOR2X1 $T=881120 568080 1 0 $X=880690 $Y=563525
X1122 130 1144 1 2 1146 NOR2X1 $T=881120 575920 0 0 $X=880690 $Y=575530
X1123 1139 1146 1 2 177 NOR2X1 $T=881680 591600 1 0 $X=881250 $Y=587045
X1124 1145 1096 1 2 1156 NOR2X1 $T=882800 474000 1 0 $X=882370 $Y=469445
X1125 1181 1191 1 2 996 NOR2X1 $T=887840 474000 1 0 $X=887410 $Y=469445
X1126 196 1214 1 2 1130 NOR2X1 $T=903520 607280 1 180 $X=900290 $Y=606890
X1127 163 182 1 2 198 NOR2X1 $T=908000 615120 1 180 $X=904770 $Y=614730
X1128 130 1241 1 2 80 NOR2X1 $T=910240 442640 0 0 $X=909810 $Y=442250
X1129 101 635 1 2 1193 NOR2X1 $T=916400 575920 1 0 $X=915970 $Y=571365
X1130 81 1241 1 2 159 NOR2X1 $T=919760 450480 0 180 $X=916530 $Y=445925
X1131 206 1245 1 2 82 NOR2X1 $T=921440 434800 0 180 $X=918210 $Y=430245
X1132 207 130 1 2 1243 NOR2X1 $T=921440 434800 1 180 $X=918210 $Y=434410
X1133 98 1241 1 2 833 NOR2X1 $T=918640 458320 1 0 $X=918210 $Y=453765
X1134 101 662 1 2 1194 NOR2X1 $T=918640 575920 0 0 $X=918210 $Y=575530
X1135 81 207 1 2 1236 NOR2X1 $T=923120 442640 1 180 $X=919890 $Y=442250
X1136 206 208 1 2 1202 NOR2X1 $T=925360 434800 1 0 $X=924930 $Y=430245
X1137 130 208 1 2 1249 NOR2X1 $T=925360 442640 1 0 $X=924930 $Y=438085
X1138 101 1241 1 2 844 NOR2X1 $T=928160 458320 1 180 $X=924930 $Y=457930
X1139 81 1268 1 2 148 NOR2X1 $T=927040 583760 0 0 $X=926610 $Y=583370
X1140 98 662 1 2 1266 NOR2X1 $T=930400 568080 0 0 $X=929970 $Y=567690
X1141 101 209 1 2 99 NOR2X1 $T=934320 434800 0 180 $X=931090 $Y=430245
X1142 1304 1314 1 2 1308 NOR2X1 $T=934320 536720 0 0 $X=933890 $Y=536330
X1143 1307 1308 1 2 1303 NOR2X1 $T=934880 528880 0 0 $X=934450 $Y=528490
X1144 1186 1320 1 2 1304 NOR2X1 $T=935440 544560 1 0 $X=935010 $Y=540005
X1145 635 98 1 2 1321 NOR2X1 $T=938240 575920 1 0 $X=937810 $Y=571365
X1146 1209 1344 1 2 1314 NOR2X1 $T=938800 536720 0 0 $X=938370 $Y=536330
X1147 1349 1354 1 2 218 NOR2X1 $T=941040 489680 0 0 $X=940610 $Y=489290
X1148 1364 1306 1 2 1356 NOR2X1 $T=944400 513200 0 180 $X=941170 $Y=508645
X1149 1375 1385 1 2 1360 NOR2X1 $T=943840 450480 0 0 $X=943410 $Y=450090
X1150 1315 1388 1 2 1379 NOR2X1 $T=943840 521040 1 0 $X=943410 $Y=516485
X1151 1412 1421 1 2 1416 NOR2X1 $T=948320 552400 1 0 $X=947890 $Y=547845
X1152 1413 1422 1 2 222 NOR2X1 $T=948320 607280 1 0 $X=947890 $Y=602725
X1153 1409 1464 1 2 1450 NOR2X1 $T=955600 442640 1 0 $X=955170 $Y=438085
X1154 1513 1519 1 2 1326 NOR2X1 $T=962880 481840 0 0 $X=962450 $Y=481450
X1155 1590 1551 1 2 1586 NOR2X1 $T=975760 591600 0 180 $X=972530 $Y=587045
X1156 1580 249 1 2 247 NOR2X1 $T=973520 466160 0 0 $X=973090 $Y=465770
X1157 1610 250 1 2 253 NOR2X1 $T=979120 434800 0 180 $X=975890 $Y=430245
X1158 1558 1618 1 2 1619 NOR2X1 $T=976880 583760 0 0 $X=976450 $Y=583370
X1159 1616 1585 1 2 1622 NOR2X1 $T=980240 575920 1 180 $X=977010 $Y=575530
X1160 1676 1686 1 2 1576 NOR2X1 $T=986400 442640 1 0 $X=985970 $Y=438085
X1161 1708 265 1 2 266 NOR2X1 $T=992000 442640 0 180 $X=988770 $Y=438085
X1162 1654 1659 1 2 1706 NOR2X1 $T=989200 575920 1 0 $X=988770 $Y=571365
X1163 1697 268 1 2 267 NOR2X1 $T=994800 466160 0 0 $X=994370 $Y=465770
X1164 1596 1730 1 2 272 NOR2X1 $T=996480 560240 0 0 $X=996050 $Y=559850
X1165 1735 1780 1 2 278 NOR2X1 $T=1002080 583760 0 0 $X=1001650 $Y=583370
X1166 1709 1771 1 2 1805 NOR2X1 $T=1004880 568080 1 0 $X=1004450 $Y=563525
X1167 81 1817 1 2 1675 NOR2X1 $T=1007120 583760 0 0 $X=1006690 $Y=583370
X1168 1682 1819 1 2 1816 NOR2X1 $T=1007680 575920 1 0 $X=1007250 $Y=571365
X1169 1798 1824 1 2 1575 NOR2X1 $T=1008800 434800 0 0 $X=1008370 $Y=434410
X1170 1804 1707 1 2 1822 NOR2X1 $T=1008800 560240 0 0 $X=1008370 $Y=559850
X1171 1802 1826 1 2 1817 NOR2X1 $T=1009360 528880 0 0 $X=1008930 $Y=528490
X1172 1811 1839 1 2 1835 NOR2X1 $T=1010480 521040 0 0 $X=1010050 $Y=520650
X1173 1853 1753 1 2 1823 NOR2X1 $T=1014400 544560 1 180 $X=1011170 $Y=544170
X1174 1838 1844 1 2 1855 NOR2X1 $T=1012160 474000 0 0 $X=1011730 $Y=473610
X1175 1845 1800 1 2 1851 NOR2X1 $T=1012160 521040 1 0 $X=1011730 $Y=516485
X1176 1874 1862 1 2 1859 NOR2X1 $T=1021120 552400 0 180 $X=1017890 $Y=547845
X1177 1856 1871 1 2 1876 NOR2X1 $T=1018880 505360 0 0 $X=1018450 $Y=504970
X1178 293 292 1 2 290 NOR2X1 $T=1046880 434800 0 180 $X=1043650 $Y=430245
X1179 293 1891 1 2 1909 NOR2X1 $T=1062560 434800 0 0 $X=1062130 $Y=434410
X1180 81 1909 1 2 309 NOR2X1 $T=1079920 434800 1 0 $X=1079490 $Y=430245
X1181 1958 314 1 2 316 NOR2X1 $T=1092800 434800 0 180 $X=1089570 $Y=430245
X1182 1958 313 1 2 1935 NOR2X1 $T=1109600 434800 1 180 $X=1106370 $Y=434410
X1183 2000 1998 1 2 328 NOR2X1 $T=1117440 434800 0 180 $X=1114210 $Y=430245
X1184 313 329 1 2 1998 NOR2X1 $T=1115200 442640 1 0 $X=1114770 $Y=438085
X1185 1958 2011 1 2 2010 NOR2X1 $T=1119680 434800 0 0 $X=1119250 $Y=434410
X1186 2000 2010 1 2 2028 NOR2X1 $T=1127520 434800 1 180 $X=1124290 $Y=434410
X1187 2057 2042 1 2 2054 NOR2X1 $T=1148240 458320 0 180 $X=1145010 $Y=453765
X1188 341 2083 1 2 2077 NOR2X1 $T=1154400 552400 0 0 $X=1153970 $Y=552010
X1189 2093 2097 1 2 39 NOR2X1 $T=1163360 552400 1 0 $X=1162930 $Y=547845
X1190 2094 2098 1 2 2096 NOR2X1 $T=1163360 575920 0 0 $X=1162930 $Y=575530
X1191 2087 2091 1 2 2102 NOR2X1 $T=1170080 544560 1 180 $X=1166850 $Y=544170
X1192 341 2106 1 2 37 NOR2X1 $T=1167280 568080 1 0 $X=1166850 $Y=563525
X1193 2100 2112 1 2 342 NOR2X1 $T=1169520 599440 0 0 $X=1169090 $Y=599050
X1194 421 2112 1 2 343 NOR2X1 $T=1169520 607280 0 0 $X=1169090 $Y=606890
X1195 2092 2088 1 2 2111 NOR2X1 $T=1170080 544560 0 0 $X=1169650 $Y=544170
X1196 2104 2109 1 2 2123 NOR2X1 $T=1175680 528880 0 0 $X=1175250 $Y=528490
X1197 341 2128 1 2 2126 NOR2X1 $T=1176240 560240 1 0 $X=1175810 $Y=555685
X1198 344 2121 1 2 2130 NOR2X1 $T=1177920 568080 0 0 $X=1177490 $Y=567690
X1199 2118 2109 1 2 2131 NOR2X1 $T=1181280 528880 1 180 $X=1178050 $Y=528490
X1200 2104 2108 1 2 2129 NOR2X1 $T=1180160 536720 0 0 $X=1179730 $Y=536330
X1201 2121 2127 1 2 2139 NOR2X1 $T=1181840 552400 1 0 $X=1181410 $Y=547845
X1202 2158 2159 1 2 362 NOR2X1 $T=1199760 607280 0 0 $X=1199330 $Y=606890
X1203 357 2160 1 2 2158 NOR2X1 $T=1200880 615120 1 0 $X=1200450 $Y=610565
X1204 348 2161 1 2 2159 NOR2X1 $T=1204240 607280 0 0 $X=1203810 $Y=606890
X1205 2162 364 1 2 2161 NOR2X1 $T=1210960 607280 0 180 $X=1207730 $Y=602725
X1206 365 327 1 2 2162 NOR2X1 $T=1212080 607280 1 180 $X=1208850 $Y=606890
X1207 353 363 1 2 364 NOR2X1 $T=1213760 615120 1 0 $X=1213330 $Y=610565
X1208 401 18 1 2 398 NAND2X1 $T=636960 607280 0 180 $X=633730 $Y=602725
X1209 25 26 1 2 15 NAND2X1 $T=643120 607280 0 0 $X=642690 $Y=606890
X1210 37 440 1 2 437 NAND2X1 $T=676160 505360 1 0 $X=675730 $Y=500805
X1211 37 424 1 2 434 NAND2X1 $T=676160 528880 1 0 $X=675730 $Y=524325
X1212 42 462 1 2 45 NAND2X1 $T=690720 615120 1 0 $X=690290 $Y=610565
X1213 468 454 1 2 466 NAND2X1 $T=694080 489680 0 180 $X=690850 $Y=485125
X1214 42 452 1 2 46 NAND2X1 $T=699120 615120 1 180 $X=695890 $Y=614730
X1215 38 520 1 2 504 NAND2X1 $T=719280 474000 1 0 $X=718850 $Y=469445
X1216 37 518 1 2 497 NAND2X1 $T=722080 560240 0 180 $X=718850 $Y=555685
X1217 38 531 1 2 513 NAND2X1 $T=724320 474000 0 0 $X=723890 $Y=473610
X1218 37 533 1 2 538 NAND2X1 $T=730480 528880 0 180 $X=727250 $Y=524325
X1219 37 520 1 2 549 NAND2X1 $T=738880 536720 1 0 $X=738450 $Y=532165
X1220 38 561 1 2 553 NAND2X1 $T=745600 544560 0 0 $X=745170 $Y=544170
X1221 568 547 1 2 567 NAND2X1 $T=751200 560240 1 180 $X=747970 $Y=559850
X1222 37 570 1 2 568 NAND2X1 $T=749520 591600 1 0 $X=749090 $Y=587045
X1223 590 585 1 2 588 NAND2X1 $T=771360 583760 1 180 $X=768130 $Y=583370
X1224 38 518 1 2 585 NAND2X1 $T=774160 575920 0 180 $X=770930 $Y=571365
X1225 69 601 1 2 606 NAND2X1 $T=784800 607280 0 180 $X=781570 $Y=602725
X1226 662 603 1 2 665 NAND2X1 $T=817840 521040 1 180 $X=814610 $Y=520650
X1227 662 586 1 2 670 NAND2X1 $T=820080 497520 0 180 $X=816850 $Y=492965
X1228 635 618 1 2 687 NAND2X1 $T=818960 513200 0 0 $X=818530 $Y=512810
X1229 638 669 1 2 689 NAND2X1 $T=819520 505360 1 0 $X=819090 $Y=500805
X1230 694 695 1 2 698 NAND2X1 $T=820640 505360 0 0 $X=820210 $Y=504970
X1231 654 82 1 2 713 NAND2X1 $T=822880 442640 1 0 $X=822450 $Y=438085
X1232 719 702 1 2 672 NAND2X1 $T=825680 481840 0 180 $X=822450 $Y=477285
X1233 662 618 1 2 715 NAND2X1 $T=825680 521040 1 180 $X=822450 $Y=520650
X1234 662 641 1 2 724 NAND2X1 $T=823440 528880 0 0 $X=823010 $Y=528490
X1235 732 670 1 2 731 NAND2X1 $T=827920 489680 0 180 $X=824690 $Y=485125
X1236 667 711 1 2 729 NAND2X1 $T=829040 544560 1 180 $X=825810 $Y=544170
X1237 707 705 1 2 746 NAND2X1 $T=826800 474000 0 0 $X=826370 $Y=473610
X1238 636 756 1 2 705 NAND2X1 $T=827920 497520 0 0 $X=827490 $Y=497130
X1239 658 657 1 2 103 NAND2X1 $T=831280 528880 0 180 $X=828050 $Y=524325
X1240 774 665 1 2 110 NAND2X1 $T=834080 505360 1 180 $X=830850 $Y=504970
X1241 779 93 1 2 763 NAND2X1 $T=834640 442640 1 180 $X=831410 $Y=442250
X1242 784 658 1 2 775 NAND2X1 $T=835200 521040 1 180 $X=831970 $Y=520650
X1243 114 731 1 2 792 NAND2X1 $T=839120 481840 1 180 $X=835890 $Y=481450
X1244 817 793 1 2 118 NAND2X1 $T=839680 575920 1 180 $X=836450 $Y=575530
X1245 812 80 1 2 819 NAND2X1 $T=837440 552400 1 0 $X=837010 $Y=547845
X1246 667 770 1 2 827 NAND2X1 $T=841920 450480 0 180 $X=838690 $Y=445925
X1247 836 826 1 2 804 NAND2X1 $T=841920 583760 0 180 $X=838690 $Y=579205
X1248 707 850 1 2 803 NAND2X1 $T=840800 544560 0 0 $X=840370 $Y=544170
X1249 719 852 1 2 814 NAND2X1 $T=840800 560240 1 0 $X=840370 $Y=555685
X1250 789 80 1 2 851 NAND2X1 $T=841360 552400 0 0 $X=840930 $Y=552010
X1251 646 669 1 2 858 NAND2X1 $T=844720 497520 1 180 $X=841490 $Y=497130
X1252 875 842 1 2 685 NAND2X1 $T=846400 474000 1 180 $X=843170 $Y=473610
X1253 647 875 1 2 852 NAND2X1 $T=844720 481840 0 0 $X=844290 $Y=481450
X1254 886 82 1 2 887 NAND2X1 $T=848080 583760 1 180 $X=844850 $Y=583370
X1255 833 720 1 2 876 NAND2X1 $T=845840 521040 1 0 $X=845410 $Y=516485
X1256 648 715 1 2 878 NAND2X1 $T=846400 521040 0 0 $X=845970 $Y=520650
X1257 99 771 1 2 134 NAND2X1 $T=850320 434800 1 180 $X=847090 $Y=434410
X1258 114 905 1 2 862 NAND2X1 $T=848080 489680 1 0 $X=847650 $Y=485125
X1259 106 136 1 2 902 NAND2X1 $T=848640 450480 0 0 $X=848210 $Y=450090
X1260 846 80 1 2 913 NAND2X1 $T=852560 583760 0 180 $X=849330 $Y=579205
X1261 648 906 1 2 135 NAND2X1 $T=850320 497520 0 0 $X=849890 $Y=497130
X1262 662 140 1 2 818 NAND2X1 $T=852000 505360 1 0 $X=851570 $Y=500805
X1263 107 751 1 2 926 NAND2X1 $T=852000 552400 1 0 $X=851570 $Y=547845
X1264 107 141 1 2 921 NAND2X1 $T=853120 458320 1 0 $X=852690 $Y=453765
X1265 882 82 1 2 908 NAND2X1 $T=853120 575920 0 0 $X=852690 $Y=575530
X1266 951 928 1 2 144 NAND2X1 $T=858160 442640 0 180 $X=854930 $Y=438085
X1267 931 82 1 2 950 NAND2X1 $T=855360 568080 1 0 $X=854930 $Y=563525
X1268 667 960 1 2 944 NAND2X1 $T=860400 466160 0 180 $X=857170 $Y=461605
X1269 645 953 1 2 970 NAND2X1 $T=857600 489680 1 0 $X=857170 $Y=485125
X1270 973 130 1 2 817 NAND2X1 $T=860400 583760 0 180 $X=857170 $Y=579205
X1271 785 154 1 2 957 NAND2X1 $T=859280 505360 0 0 $X=858850 $Y=504970
X1272 106 970 1 2 988 NAND2X1 $T=861520 552400 0 0 $X=861090 $Y=552010
X1273 1011 922 1 2 162 NAND2X1 $T=866000 575920 1 180 $X=862770 $Y=575530
X1274 1027 130 1 2 1022 NAND2X1 $T=867680 575920 0 180 $X=864450 $Y=571365
X1275 662 1033 1 2 888 NAND2X1 $T=869920 521040 1 180 $X=866690 $Y=520650
X1276 667 893 1 2 1045 NAND2X1 $T=868240 481840 0 0 $X=867810 $Y=481450
X1277 1003 666 1 2 1064 NAND2X1 $T=873280 497520 1 180 $X=870050 $Y=497130
X1278 1063 159 1 2 1016 NAND2X1 $T=871040 575920 0 0 $X=870610 $Y=575530
X1279 687 1081 1 2 1051 NAND2X1 $T=871600 489680 1 0 $X=871170 $Y=485125
X1280 1003 664 1 2 1075 NAND2X1 $T=874400 489680 1 180 $X=871170 $Y=489290
X1281 844 894 1 2 1080 NAND2X1 $T=873840 521040 1 0 $X=873410 $Y=516485
X1282 172 136 1 2 1100 NAND2X1 $T=878320 434800 0 180 $X=875090 $Y=430245
X1283 1088 1064 1 2 1104 NAND2X1 $T=878880 466160 0 180 $X=875650 $Y=461605
X1284 174 894 1 2 1105 NAND2X1 $T=880000 513200 1 180 $X=876770 $Y=512810
X1285 1089 159 1 2 1120 NAND2X1 $T=877760 575920 0 0 $X=877330 $Y=575530
X1286 1127 978 1 2 1126 NAND2X1 $T=881680 536720 1 180 $X=878450 $Y=536330
X1287 707 782 1 2 1117 NAND2X1 $T=882240 450480 0 180 $X=879010 $Y=445925
X1288 707 1064 1 2 1082 NAND2X1 $T=883920 544560 1 180 $X=880690 $Y=544170
X1289 1088 919 1 2 1142 NAND2X1 $T=881680 497520 1 0 $X=881250 $Y=492965
X1290 1051 180 1 2 1155 NAND2X1 $T=883360 434800 1 0 $X=882930 $Y=430245
X1291 1162 100 1 2 1121 NAND2X1 $T=886160 481840 1 180 $X=882930 $Y=481450
X1292 107 852 1 2 1147 NAND2X1 $T=887840 560240 1 180 $X=884610 $Y=559850
X1293 172 1108 1 2 1164 NAND2X1 $T=885600 528880 1 0 $X=885170 $Y=524325
X1294 1172 1179 1 2 1057 NAND2X1 $T=886160 489680 1 0 $X=885730 $Y=485125
X1295 1186 878 1 2 1192 NAND2X1 $T=892880 552400 1 180 $X=889650 $Y=552010
X1296 1129 111 1 2 1199 NAND2X1 $T=890640 568080 1 0 $X=890210 $Y=563525
X1297 1171 80 1 2 1212 NAND2X1 $T=891200 575920 1 0 $X=890770 $Y=571365
X1298 1178 1218 1 2 1143 NAND2X1 $T=891760 513200 0 0 $X=891330 $Y=512810
X1299 1219 1215 1 2 867 NAND2X1 $T=893440 442640 1 0 $X=893010 $Y=438085
X1300 1198 1217 1 2 1220 NAND2X1 $T=896240 505360 0 180 $X=893010 $Y=500805
X1301 1211 1224 1 2 1172 NAND2X1 $T=894000 481840 0 0 $X=893570 $Y=481450
X1302 662 1226 1 2 1081 NAND2X1 $T=894000 528880 1 0 $X=893570 $Y=524325
X1303 1222 1224 1 2 1205 NAND2X1 $T=894560 466160 1 0 $X=894130 $Y=461605
X1304 1207 159 1 2 1228 NAND2X1 $T=896800 521040 1 0 $X=896370 $Y=516485
X1305 82 1012 1 2 1232 NAND2X1 $T=901280 450480 0 180 $X=898050 $Y=445925
X1306 1218 1175 1 2 1038 NAND2X1 $T=914720 489680 0 0 $X=914290 $Y=489290
X1307 1264 1236 1 2 1263 NAND2X1 $T=929280 497520 1 180 $X=926050 $Y=497130
X1308 1249 185 1 2 1267 NAND2X1 $T=927040 450480 0 0 $X=926610 $Y=450090
X1309 696 1286 1 2 1290 NAND2X1 $T=930400 528880 0 0 $X=929970 $Y=528490
X1310 1312 194 1 2 1305 NAND2X1 $T=937120 481840 1 180 $X=933890 $Y=481450
X1311 1313 1186 1 2 1310 NAND2X1 $T=937120 513200 0 180 $X=933890 $Y=508645
X1312 185 193 1 2 1382 NAND2X1 $T=943840 489680 0 0 $X=943410 $Y=489290
X1313 1389 1379 1 2 220 NAND2X1 $T=946640 560240 1 180 $X=943410 $Y=559850
X1314 1372 130 1 2 1389 NAND2X1 $T=944960 552400 0 0 $X=944530 $Y=552010
X1315 174 1312 1 2 1373 NAND2X1 $T=946640 505360 1 0 $X=946210 $Y=500805
X1316 719 1428 1 2 1383 NAND2X1 $T=948880 458320 0 0 $X=948450 $Y=457930
X1317 106 1438 1 2 1424 NAND2X1 $T=950000 560240 1 0 $X=949570 $Y=555685
X1318 662 580 1 2 1434 NAND2X1 $T=950000 568080 1 0 $X=949570 $Y=563525
X1319 172 1447 1 2 1431 NAND2X1 $T=955040 513200 1 180 $X=951810 $Y=512810
X1320 1425 1434 1 2 221 NAND2X1 $T=955040 560240 1 180 $X=951810 $Y=559850
X1321 1458 1450 1 2 230 NAND2X1 $T=955600 442640 0 180 $X=952370 $Y=438085
X1322 1061 1418 1 2 1441 NAND2X1 $T=954480 505360 1 0 $X=954050 $Y=500805
X1323 99 1448 1 2 1488 NAND2X1 $T=960080 505360 1 180 $X=956850 $Y=504970
X1324 1489 80 1 2 1495 NAND2X1 $T=958400 442640 1 0 $X=957970 $Y=438085
X1325 1483 1496 1 2 1446 NAND2X1 $T=958400 528880 1 0 $X=957970 $Y=524325
X1326 1475 1496 1 2 1442 NAND2X1 $T=958400 552400 1 0 $X=957970 $Y=547845
X1327 1493 1500 1 2 1299 NAND2X1 $T=958960 513200 0 0 $X=958530 $Y=512810
X1328 844 1446 1 2 1340 NAND2X1 $T=961760 481840 1 0 $X=961330 $Y=477285
X1329 635 1499 1 2 1497 NAND2X1 $T=964560 536720 0 180 $X=961330 $Y=532165
X1330 1321 1506 1 2 1514 NAND2X1 $T=962320 583760 1 0 $X=961890 $Y=579205
X1331 1516 1434 1 2 1525 NAND2X1 $T=966800 568080 0 180 $X=963570 $Y=563525
X1332 662 225 1 2 1531 NAND2X1 $T=967920 560240 1 180 $X=964690 $Y=559850
X1333 1525 98 1 2 1537 NAND2X1 $T=966240 575920 1 0 $X=965810 $Y=571365
X1334 1533 1544 1 2 1427 NAND2X1 $T=966800 497520 0 0 $X=966370 $Y=497130
X1335 1548 1382 1 2 1541 NAND2X1 $T=970160 497520 0 180 $X=966930 $Y=492965
X1336 635 576 1 2 1545 NAND2X1 $T=967360 521040 0 0 $X=966930 $Y=520650
X1337 662 1538 1 2 1500 NAND2X1 $T=968480 528880 0 0 $X=968050 $Y=528490
X1338 1486 1555 1 2 1550 NAND2X1 $T=968480 536720 0 0 $X=968050 $Y=536330
X1339 1545 1544 1 2 1312 NAND2X1 $T=972400 505360 0 180 $X=969170 $Y=500805
X1340 1532 1555 1 2 231 NAND2X1 $T=972400 544560 0 180 $X=969170 $Y=540005
X1341 114 1566 1 2 1570 NAND2X1 $T=975200 442640 1 180 $X=971970 $Y=442250
X1342 662 1454 1 2 1552 NAND2X1 $T=972400 552400 1 0 $X=971970 $Y=547845
X1343 1561 1591 1 2 1346 NAND2X1 $T=976880 536720 0 180 $X=973650 $Y=532165
X1344 696 1438 1 2 1574 NAND2X1 $T=977440 575920 0 180 $X=974210 $Y=571365
X1345 1533 1524 1 2 1609 NAND2X1 $T=979120 528880 0 180 $X=975890 $Y=524325
X1346 696 1320 1 2 1624 NAND2X1 $T=980800 568080 1 180 $X=977570 $Y=567690
X1347 707 1608 1 2 1628 NAND2X1 $T=981920 552400 0 180 $X=978690 $Y=547845
X1348 1038 1600 1 2 1631 NAND2X1 $T=983040 481840 0 180 $X=979810 $Y=477285
X1349 667 1467 1 2 1651 NAND2X1 $T=985280 528880 0 180 $X=982050 $Y=524325
X1350 696 1543 1 2 1663 NAND2X1 $T=986400 560240 1 180 $X=983170 $Y=559850
X1351 635 599 1 2 1670 NAND2X1 $T=987520 497520 0 180 $X=984290 $Y=492965
X1352 635 1454 1 2 1645 NAND2X1 $T=985280 544560 1 0 $X=984850 $Y=540005
X1353 106 1430 1 2 1712 NAND2X1 $T=994800 450480 1 180 $X=991570 $Y=450090
X1354 635 67 1 2 1720 NAND2X1 $T=992000 481840 0 0 $X=991570 $Y=481450
X1355 1681 1695 1 2 1683 NAND2X1 $T=994800 505360 1 180 $X=991570 $Y=504970
X1356 114 1466 1 2 1722 NAND2X1 $T=994800 544560 0 180 $X=991570 $Y=540005
X1357 662 67 1 2 1705 NAND2X1 $T=995360 481840 0 180 $X=992130 $Y=477285
X1358 707 1732 1 2 1736 NAND2X1 $T=996480 536720 0 180 $X=993250 $Y=532165
X1359 1741 111 1 2 1733 NAND2X1 $T=995920 450480 1 0 $X=995490 $Y=445925
X1360 1687 106 1 2 1743 NAND2X1 $T=995920 536720 0 0 $X=995490 $Y=536330
X1361 1748 82 1 2 1745 NAND2X1 $T=998720 583760 0 180 $X=995490 $Y=579205
X1362 106 1683 1 2 1747 NAND2X1 $T=999280 513200 0 180 $X=996050 $Y=508645
X1363 114 1518 1 2 1751 NAND2X1 $T=999840 489680 1 180 $X=996610 $Y=489290
X1364 1758 1703 1 2 1650 NAND2X1 $T=1000400 513200 1 180 $X=997170 $Y=512810
X1365 1567 82 1 2 1762 NAND2X1 $T=998160 575920 1 0 $X=997730 $Y=571365
X1366 1763 1728 1 2 1381 NAND2X1 $T=1002640 489680 0 180 $X=999410 $Y=485125
X1367 107 273 1 2 1772 NAND2X1 $T=1003200 434800 0 180 $X=999970 $Y=430245
X1368 844 1283 1 2 1785 NAND2X1 $T=1005440 481840 1 180 $X=1002210 $Y=481450
X1369 106 1442 1 2 1796 NAND2X1 $T=1007120 552400 1 180 $X=1003890 $Y=552010
X1370 114 1732 1 2 1799 NAND2X1 $T=1004880 466160 1 0 $X=1004450 $Y=461605
X1371 99 1505 1 2 1801 NAND2X1 $T=1007680 513200 0 180 $X=1004450 $Y=508645
X1372 1763 1740 1 2 1803 NAND2X1 $T=1010480 489680 1 0 $X=1010050 $Y=485125
X1373 1788 111 1 2 1841 NAND2X1 $T=1011040 458320 0 0 $X=1010610 $Y=457930
X1374 1827 130 1 2 1847 NAND2X1 $T=1011600 560240 0 0 $X=1011170 $Y=559850
X1375 1854 1805 1 2 281 NAND2X1 $T=1014400 568080 1 180 $X=1011170 $Y=567690
X1376 107 1312 1 2 1850 NAND2X1 $T=1014960 497520 0 180 $X=1011730 $Y=492965
X1377 1781 93 1 2 1843 NAND2X1 $T=1016640 442640 0 180 $X=1013410 $Y=438085
X1378 99 1727 1 2 1875 NAND2X1 $T=1020560 528880 0 180 $X=1017330 $Y=524325
X1379 1872 130 1 2 1878 NAND2X1 $T=1023360 560240 0 180 $X=1020130 $Y=555685
X1380 635 1880 1 2 1775 NAND2X1 $T=1021120 466160 0 0 $X=1020690 $Y=465770
X1381 662 1881 1 2 1690 NAND2X1 $T=1021120 481840 0 0 $X=1020690 $Y=481450
X1382 635 1883 1 2 258 NAND2X1 $T=1022800 513200 1 0 $X=1022370 $Y=508645
X1383 38 286 1 2 1894 NAND2X1 $T=1046880 615120 1 180 $X=1043650 $Y=614730
X1384 298 1905 1 2 1904 NAND2X1 $T=1058080 599440 0 0 $X=1057650 $Y=599050
X1385 1929 1909 1 2 1893 NAND2X1 $T=1070400 434800 0 180 $X=1067170 $Y=430245
X1386 1954 1950 1 2 1951 NAND2X1 $T=1086640 450480 0 180 $X=1083410 $Y=445925
X1387 1909 313 1 2 312 NAND2X1 $T=1086080 434800 0 0 $X=1085650 $Y=434410
X1388 42 1967 1 2 318 NAND2X1 $T=1092240 607280 0 0 $X=1091810 $Y=606890
X1389 37 1992 1 2 1997 NAND2X1 $T=1115760 544560 1 180 $X=1112530 $Y=544170
X1390 2007 2005 1 2 2006 NAND2X1 $T=1120240 474000 1 180 $X=1117010 $Y=473610
X1391 38 1971 1 2 2005 NAND2X1 $T=1118000 474000 1 0 $X=1117570 $Y=469445
X1392 42 2008 1 2 330 NAND2X1 $T=1118000 615120 1 0 $X=1117570 $Y=610565
X1393 37 1981 1 2 2007 NAND2X1 $T=1122480 489680 0 180 $X=1119250 $Y=485125
X1394 38 1965 1 2 2026 NAND2X1 $T=1127520 544560 0 180 $X=1124290 $Y=540005
X1395 38 2013 1 2 2031 NAND2X1 $T=1128640 474000 1 180 $X=1125410 $Y=473610
X1396 38 1987 1 2 2025 NAND2X1 $T=1128640 575920 1 0 $X=1128210 $Y=571365
X1397 37 2034 1 2 2038 NAND2X1 $T=1133120 505360 0 180 $X=1129890 $Y=500805
X1398 42 2041 1 2 337 NAND2X1 $T=1144880 615120 1 180 $X=1141650 $Y=614730
X1399 38 1955 1 2 2051 NAND2X1 $T=1146560 513200 1 180 $X=1143330 $Y=512810
X1400 2047 2050 1 2 2055 NAND2X1 $T=1144320 466160 1 0 $X=1143890 $Y=461605
X1401 2059 2048 1 2 2058 NAND2X1 $T=1149920 583760 1 180 $X=1146690 $Y=583370
X1402 42 2068 1 2 340 NAND2X1 $T=1148800 615120 0 0 $X=1148370 $Y=614730
X1403 2082 2042 1 2 2084 NAND2X1 $T=1157760 458320 1 180 $X=1154530 $Y=457930
X1404 2055 2046 1 2 2082 NAND2X1 $T=1154960 466160 1 0 $X=1154530 $Y=461605
X1405 2076 2090 1 2 2095 NAND2X1 $T=1166160 513200 0 180 $X=1162930 $Y=508645
X1406 2105 2099 1 2 2101 NAND2X1 $T=1170080 528880 0 180 $X=1166850 $Y=524325
X1407 2147 2150 1 2 2152 NAND2X1 $T=1193600 560240 1 180 $X=1190370 $Y=559850
X1408 2156 359 1 2 361 NAND2X1 $T=1200880 615120 0 180 $X=1197650 $Y=610565
X1409 25 24 413 1 2 28 MUX2X1 $T=654320 607280 1 180 $X=648290 $Y=606890
X1410 24 22 13 1 2 420 MUX2X1 $T=668320 607280 1 180 $X=662290 $Y=606890
X1411 445 39 440 1 2 435 MUX2X1 $T=681760 521040 1 180 $X=675730 $Y=520650
X1412 446 39 422 1 2 436 MUX2X1 $T=681760 583760 1 180 $X=675730 $Y=583370
X1413 446 44 41 1 2 450 MUX2X1 $T=691280 591600 1 180 $X=685250 $Y=591210
X1414 464 44 460 1 2 453 MUX2X1 $T=692960 568080 0 180 $X=686930 $Y=563525
X1415 465 44 462 1 2 455 MUX2X1 $T=693520 583760 1 180 $X=687490 $Y=583370
X1416 465 39 424 1 2 458 MUX2X1 $T=694080 536720 1 180 $X=688050 $Y=536330
X1417 464 39 447 1 2 459 MUX2X1 $T=694080 552400 0 180 $X=688050 $Y=547845
X1418 469 39 432 1 2 463 MUX2X1 $T=695200 521040 1 180 $X=689170 $Y=520650
X1419 471 44 451 1 2 467 MUX2X1 $T=698000 568080 1 180 $X=691970 $Y=567690
X1420 476 44 452 1 2 470 MUX2X1 $T=701920 521040 0 180 $X=695890 $Y=516485
X1421 478 44 475 1 2 473 MUX2X1 $T=703040 489680 0 180 $X=697010 $Y=485125
X1422 486 44 48 1 2 479 MUX2X1 $T=708640 544560 1 180 $X=702610 $Y=544170
X1423 478 39 448 1 2 480 MUX2X1 $T=709760 474000 1 180 $X=703730 $Y=473610
X1424 445 44 483 1 2 481 MUX2X1 $T=711440 560240 0 180 $X=705410 $Y=555685
X1425 469 44 487 1 2 482 MUX2X1 $T=711440 568080 1 180 $X=705410 $Y=567690
X1426 50 39 488 1 2 484 MUX2X1 $T=712000 599440 1 180 $X=705970 $Y=599050
X1427 471 39 472 1 2 496 MUX2X1 $T=706960 528880 0 0 $X=706530 $Y=528490
X1428 486 39 456 1 2 491 MUX2X1 $T=714800 489680 0 180 $X=708770 $Y=485125
X1429 530 44 525 1 2 522 MUX2X1 $T=727680 599440 0 180 $X=721650 $Y=594885
X1430 535 44 523 1 2 524 MUX2X1 $T=728800 544560 0 180 $X=722770 $Y=540005
X1431 530 39 521 1 2 539 MUX2X1 $T=736640 560240 1 180 $X=730610 $Y=559850
X1432 476 39 520 1 2 554 MUX2X1 $T=737760 466160 1 0 $X=737330 $Y=461605
X1433 535 39 531 1 2 555 MUX2X1 $T=737760 474000 0 0 $X=737330 $Y=473610
X1434 556 39 505 1 2 543 MUX2X1 $T=744480 489680 0 180 $X=738450 $Y=485125
X1435 57 39 529 1 2 544 MUX2X1 $T=744480 575920 1 180 $X=738450 $Y=575530
X1436 557 39 527 1 2 545 MUX2X1 $T=745040 505360 1 180 $X=739010 $Y=504970
X1437 556 44 55 1 2 546 MUX2X1 $T=745040 591600 0 180 $X=739010 $Y=587045
X1438 560 39 502 1 2 550 MUX2X1 $T=746720 521040 1 180 $X=740690 $Y=520650
X1439 557 44 56 1 2 551 MUX2X1 $T=746720 607280 0 180 $X=740690 $Y=602725
X1440 560 44 59 1 2 58 MUX2X1 $T=748960 615120 1 180 $X=742930 $Y=614730
X1441 61 39 514 1 2 565 MUX2X1 $T=755120 505360 0 180 $X=749090 $Y=500805
X1442 62 39 533 1 2 566 MUX2X1 $T=755120 521040 1 180 $X=749090 $Y=520650
X1443 576 63 465 1 2 572 MUX2X1 $T=765200 536720 0 180 $X=759170 $Y=532165
X1444 577 63 535 1 2 573 MUX2X1 $T=766880 466160 0 180 $X=760850 $Y=461605
X1445 578 63 556 1 2 574 MUX2X1 $T=767440 481840 0 180 $X=761410 $Y=477285
X1446 580 63 469 1 2 575 MUX2X1 $T=767440 544560 1 180 $X=761410 $Y=544170
X1447 586 63 471 1 2 579 MUX2X1 $T=771360 497520 1 180 $X=765330 $Y=497130
X1448 64 39 518 1 2 581 MUX2X1 $T=771360 568080 1 180 $X=765330 $Y=567690
X1449 587 63 530 1 2 582 MUX2X1 $T=771360 575920 0 180 $X=765330 $Y=571365
X1450 65 39 564 1 2 583 MUX2X1 $T=774720 591600 0 180 $X=768690 $Y=587045
X1451 66 39 570 1 2 584 MUX2X1 $T=774720 599440 0 180 $X=768690 $Y=594885
X1452 595 63 478 1 2 589 MUX2X1 $T=775840 466160 0 180 $X=769810 $Y=461605
X1453 598 63 557 1 2 592 MUX2X1 $T=778080 481840 0 180 $X=772050 $Y=477285
X1454 599 63 486 1 2 593 MUX2X1 $T=778080 497520 1 180 $X=772050 $Y=497130
X1455 67 63 62 1 2 594 MUX2X1 $T=779200 497520 0 180 $X=773170 $Y=492965
X1456 602 63 464 1 2 596 MUX2X1 $T=780320 521040 0 180 $X=774290 $Y=516485
X1457 68 39 526 1 2 597 MUX2X1 $T=780880 615120 0 180 $X=774850 $Y=610565
X1458 603 63 560 1 2 600 MUX2X1 $T=782000 528880 1 180 $X=775970 $Y=528490
X1459 607 63 476 1 2 604 MUX2X1 $T=786480 458320 1 180 $X=780450 $Y=457930
X1460 614 63 445 1 2 608 MUX2X1 $T=793760 528880 1 180 $X=787730 $Y=528490
X1461 615 63 61 1 2 609 MUX2X1 $T=794320 544560 0 180 $X=788290 $Y=540005
X1462 616 63 64 1 2 610 MUX2X1 $T=794880 560240 0 180 $X=788850 $Y=555685
X1463 617 63 72 1 2 611 MUX2X1 $T=796000 583760 0 180 $X=789970 $Y=579205
X1464 618 63 57 1 2 612 MUX2X1 $T=797120 568080 1 180 $X=791090 $Y=567690
X1465 72 39 561 1 2 613 MUX2X1 $T=797120 583760 1 180 $X=791090 $Y=583370
X1466 631 63 65 1 2 622 MUX2X1 $T=811120 591600 0 180 $X=805090 $Y=587045
X1467 640 63 66 1 2 627 MUX2X1 $T=813360 591600 1 180 $X=807330 $Y=591210
X1468 641 63 77 1 2 628 MUX2X1 $T=813360 607280 1 180 $X=807330 $Y=606890
X1469 77 39 70 1 2 78 MUX2X1 $T=815600 615120 1 180 $X=809570 $Y=614730
X1470 741 98 702 1 2 633 MUX2X1 $T=829600 458320 1 180 $X=823570 $Y=457930
X1471 716 98 689 1 2 634 MUX2X1 $T=831840 450480 1 180 $X=825810 $Y=450090
X1472 764 101 95 1 2 654 MUX2X1 $T=832960 434800 1 180 $X=826930 $Y=434410
X1473 754 98 720 1 2 704 MUX2X1 $T=833520 544560 0 180 $X=827490 $Y=540005
X1474 741 101 749 1 2 682 MUX2X1 $T=829040 458320 1 0 $X=828610 $Y=453765
X1475 777 63 105 1 2 753 MUX2X1 $T=834640 607280 0 180 $X=828610 $Y=602725
X1476 758 98 754 1 2 802 MUX2X1 $T=831840 536720 1 0 $X=831410 $Y=532165
X1477 799 63 112 1 2 772 MUX2X1 $T=838000 599440 1 180 $X=831970 $Y=599050
X1478 783 101 116 1 2 117 MUX2X1 $T=832960 434800 0 0 $X=832530 $Y=434410
X1479 783 98 109 1 2 779 MUX2X1 $T=833520 450480 1 0 $X=833090 $Y=445925
X1480 758 101 785 1 2 812 MUX2X1 $T=833520 536720 0 0 $X=833090 $Y=536330
X1481 128 98 845 1 2 830 MUX2X1 $T=846400 528880 1 180 $X=840370 $Y=528490
X1482 890 63 127 1 2 860 MUX2X1 $T=848640 607280 0 180 $X=842610 $Y=602725
X1483 861 98 878 1 2 789 MUX2X1 $T=849760 552400 1 180 $X=843730 $Y=552010
X1484 108 63 132 1 2 131 MUX2X1 $T=850880 615120 1 180 $X=844850 $Y=614730
X1485 712 101 728 1 2 882 MUX2X1 $T=851440 568080 1 180 $X=845410 $Y=567690
X1486 894 98 837 1 2 776 MUX2X1 $T=846400 528880 0 0 $X=845970 $Y=528490
X1487 852 101 896 1 2 846 MUX2X1 $T=852560 568080 0 180 $X=846530 $Y=563525
X1488 873 63 143 1 2 947 MUX2X1 $T=850880 615120 0 0 $X=850450 $Y=614730
X1489 936 101 907 1 2 886 MUX2X1 $T=857040 568080 1 180 $X=851010 $Y=567690
X1490 712 98 896 1 2 931 MUX2X1 $T=859280 560240 1 180 $X=853250 $Y=559850
X1491 751 101 956 1 2 1007 MUX2X1 $T=859280 568080 0 0 $X=858850 $Y=567690
X1492 115 98 775 1 2 155 MUX2X1 $T=867120 434800 0 180 $X=861090 $Y=430245
X1493 1021 63 68 1 2 994 MUX2X1 $T=867680 615120 0 180 $X=861650 $Y=610565
X1494 797 101 751 1 2 1039 MUX2X1 $T=864880 568080 0 0 $X=864450 $Y=567690
X1495 733 101 858 1 2 997 MUX2X1 $T=872160 544560 0 180 $X=866130 $Y=540005
X1496 956 101 1026 1 2 1037 MUX2X1 $T=866560 560240 0 0 $X=866130 $Y=559850
X1497 1051 98 1041 1 2 149 MUX2X1 $T=873280 434800 1 180 $X=867250 $Y=434410
X1498 1041 98 147 1 2 168 MUX2X1 $T=868240 434800 1 0 $X=867810 $Y=430245
X1499 1108 101 1015 1 2 1063 MUX2X1 $T=878880 560240 1 180 $X=872850 $Y=559850
X1500 797 98 1015 1 2 1089 MUX2X1 $T=880000 568080 0 180 $X=873970 $Y=563525
X1501 1030 101 970 1 2 1129 MUX2X1 $T=877760 552400 0 0 $X=877330 $Y=552010
X1502 184 182 1208 1 2 1200 MUX2X1 $T=887280 615120 0 0 $X=886850 $Y=614730
X1503 899 101 725 1 2 1161 MUX2X1 $T=893440 536720 1 180 $X=887410 $Y=536330
X1504 725 101 733 1 2 1207 MUX2X1 $T=888400 521040 0 0 $X=887970 $Y=520650
X1505 1238 63 195 1 2 1233 MUX2X1 $T=904640 607280 0 180 $X=898610 $Y=602725
X1506 1242 63 199 1 2 1240 MUX2X1 $T=913600 607280 0 180 $X=907570 $Y=602725
X1507 1293 63 210 1 2 1269 MUX2X1 $T=934320 607280 1 180 $X=928290 $Y=606890
X1508 1359 63 217 1 2 1334 MUX2X1 $T=944400 615120 1 180 $X=938370 $Y=614730
X1509 1390 98 1365 1 2 1265 MUX2X1 $T=947760 528880 1 180 $X=941730 $Y=528490
X1510 1430 98 1370 1 2 1278 MUX2X1 $T=952800 489680 0 180 $X=946770 $Y=485125
X1511 1347 98 1430 1 2 1471 MUX2X1 $T=961760 481840 0 180 $X=955730 $Y=477285
X1512 1414 98 1346 1 2 1363 MUX2X1 $T=962880 450480 1 180 $X=956850 $Y=450090
X1513 1313 101 1428 1 2 235 MUX2X1 $T=964560 458320 0 180 $X=958530 $Y=453765
X1514 241 101 223 1 2 1280 MUX2X1 $T=966800 497520 1 180 $X=960770 $Y=497130
X1515 1440 63 244 1 2 1534 MUX2X1 $T=962320 607280 1 0 $X=961890 $Y=602725
X1516 1527 98 1530 1 2 1333 MUX2X1 $T=970720 552400 1 180 $X=964690 $Y=552010
X1517 1550 101 1320 1 2 1567 MUX2X1 $T=967920 560240 0 0 $X=967490 $Y=559850
X1518 1438 101 1525 1 2 1582 MUX2X1 $T=969040 575920 1 0 $X=968610 $Y=571365
X1519 1499 63 248 1 2 1597 MUX2X1 $T=970720 615120 0 0 $X=970290 $Y=614730
X1520 1498 63 251 1 2 1612 MUX2X1 $T=972960 607280 1 0 $X=972530 $Y=602725
X1521 1543 98 1286 1 2 1634 MUX2X1 $T=985840 568080 0 180 $X=979810 $Y=563525
X1522 241 98 1641 1 2 1384 MUX2X1 $T=986400 450480 0 180 $X=980370 $Y=445925
X1523 1584 98 1687 1 2 1342 MUX2X1 $T=984160 513200 0 0 $X=983730 $Y=512810
X1524 1447 98 1442 1 2 1699 MUX2X1 $T=985840 552400 0 0 $X=985410 $Y=552010
X1525 1316 98 1683 1 2 1656 MUX2X1 $T=992000 544560 1 180 $X=985970 $Y=544170
X1526 1318 98 1584 1 2 1713 MUX2X1 $T=997600 513200 1 180 $X=991570 $Y=512810
X1527 248 39 269 1 2 1754 MUX2X1 $T=993120 615120 0 0 $X=992690 $Y=614730
X1528 1683 98 1609 1 2 1748 MUX2X1 $T=993680 544560 0 0 $X=993250 $Y=544170
X1529 1640 63 271 1 2 1756 MUX2X1 $T=993680 599440 1 0 $X=993250 $Y=594885
X1530 1378 101 1652 1 2 1767 MUX2X1 $T=996480 521040 0 0 $X=996050 $Y=520650
X1531 1606 98 1621 1 2 1773 MUX2X1 $T=996480 528880 0 0 $X=996050 $Y=528490
X1532 1337 101 1299 1 2 1776 MUX2X1 $T=997600 497520 0 0 $X=997170 $Y=497130
X1533 236 101 1446 1 2 1741 MUX2X1 $T=1003760 450480 1 180 $X=997730 $Y=450090
X1534 1371 98 1317 1 2 1786 MUX2X1 $T=999280 513200 1 0 $X=998850 $Y=508645
X1535 261 101 1685 1 2 1788 MUX2X1 $T=999840 458320 1 0 $X=999410 $Y=453765
X1536 264 98 1685 1 2 1781 MUX2X1 $T=1000400 450480 1 0 $X=999970 $Y=445925
X1537 1770 101 1549 1 2 1795 MUX2X1 $T=1000400 544560 0 0 $X=999970 $Y=544170
X1538 1757 101 1621 1 2 1704 MUX2X1 $T=1007680 528880 1 180 $X=1001650 $Y=528490
X1539 1803 101 1770 1 2 1719 MUX2X1 $T=1007680 552400 0 180 $X=1001650 $Y=547845
X1540 961 63 280 1 2 1834 MUX2X1 $T=1006560 599440 0 0 $X=1006130 $Y=599050
X1541 1357 63 288 1 2 1886 MUX2X1 $T=1023920 591600 0 0 $X=1023490 $Y=591210
X1542 1210 63 294 1 2 1897 MUX2X1 $T=1044640 599440 0 0 $X=1044210 $Y=599050
X1543 1454 63 295 1 2 1898 MUX2X1 $T=1045200 575920 1 0 $X=1044770 $Y=571365
X1544 757 63 296 1 2 1899 MUX2X1 $T=1045200 591600 1 0 $X=1044770 $Y=587045
X1545 1506 63 1901 1 2 1902 MUX2X1 $T=1053040 583760 1 0 $X=1052610 $Y=579205
X1546 1881 63 297 1 2 1903 MUX2X1 $T=1054160 568080 1 0 $X=1053730 $Y=563525
X1547 91 63 1907 1 2 1911 MUX2X1 $T=1059200 481840 0 0 $X=1058770 $Y=481450
X1548 1491 63 1910 1 2 1914 MUX2X1 $T=1059760 568080 1 0 $X=1059330 $Y=563525
X1549 1226 63 1912 1 2 1916 MUX2X1 $T=1060320 560240 1 0 $X=1059890 $Y=555685
X1550 1883 63 302 1 2 1918 MUX2X1 $T=1060880 544560 0 0 $X=1060450 $Y=544170
X1551 1538 63 1915 1 2 1921 MUX2X1 $T=1061440 528880 0 0 $X=1061010 $Y=528490
X1552 1033 63 1917 1 2 1923 MUX2X1 $T=1062000 521040 0 0 $X=1061570 $Y=520650
X1553 1882 63 1919 1 2 1924 MUX2X1 $T=1062560 505360 0 0 $X=1062130 $Y=504970
X1554 962 63 1920 1 2 1925 MUX2X1 $T=1062560 521040 1 0 $X=1062130 $Y=516485
X1555 140 63 1922 1 2 1926 MUX2X1 $T=1063120 497520 1 0 $X=1062690 $Y=492965
X1556 1880 63 1927 1 2 1932 MUX2X1 $T=1064800 474000 1 0 $X=1064370 $Y=469445
X1557 146 63 1928 1 2 1933 MUX2X1 $T=1064800 481840 0 0 $X=1064370 $Y=481450
X1558 296 39 306 1 2 1934 MUX2X1 $T=1067600 599440 0 0 $X=1067170 $Y=599050
X1559 1885 63 1941 1 2 1943 MUX2X1 $T=1075440 474000 1 0 $X=1075010 $Y=469445
X1560 153 63 1948 1 2 1952 MUX2X1 $T=1079920 489680 0 0 $X=1079490 $Y=489290
X1561 1912 44 1945 1 2 1944 MUX2X1 $T=1086640 560240 0 180 $X=1080610 $Y=555685
X1562 1917 44 310 1 2 1949 MUX2X1 $T=1089440 552400 1 180 $X=1083410 $Y=552010
X1563 1917 39 1955 1 2 1959 MUX2X1 $T=1086640 528880 0 0 $X=1086210 $Y=528490
X1564 1901 39 1908 1 2 1963 MUX2X1 $T=1087760 599440 0 0 $X=1087330 $Y=599050
X1565 1912 39 1965 1 2 1968 MUX2X1 $T=1090000 552400 0 0 $X=1089570 $Y=552010
X1566 1920 44 308 1 2 1969 MUX2X1 $T=1091120 536720 1 0 $X=1090690 $Y=532165
X1567 1915 44 317 1 2 1960 MUX2X1 $T=1097280 560240 0 180 $X=1091250 $Y=555685
X1568 1907 44 1967 1 2 1964 MUX2X1 $T=1099520 497520 0 180 $X=1093490 $Y=492965
X1569 1907 39 1971 1 2 1974 MUX2X1 $T=1095600 474000 1 0 $X=1095170 $Y=469445
X1570 1948 44 1972 1 2 1975 MUX2X1 $T=1095600 489680 0 0 $X=1095170 $Y=489290
X1571 1948 39 1973 1 2 1977 MUX2X1 $T=1096160 474000 0 0 $X=1095730 $Y=473610
X1572 1901 44 321 1 2 319 MUX2X1 $T=1102320 615120 0 180 $X=1096290 $Y=610565
X1573 1941 44 1978 1 2 1982 MUX2X1 $T=1097840 513200 1 0 $X=1097410 $Y=508645
X1574 1920 39 1961 1 2 1983 MUX2X1 $T=1097840 536720 1 0 $X=1097410 $Y=532165
X1575 1941 39 1981 1 2 1984 MUX2X1 $T=1098400 481840 0 0 $X=1097970 $Y=481450
X1576 302 39 1990 1 2 1994 MUX2X1 $T=1107360 591600 0 0 $X=1106930 $Y=591210
X1577 1915 39 1992 1 2 1995 MUX2X1 $T=1108480 560240 1 0 $X=1108050 $Y=555685
X1578 295 39 1987 1 2 2004 MUX2X1 $T=1112960 575920 0 0 $X=1112530 $Y=575530
X1579 1928 39 2013 1 2 2019 MUX2X1 $T=1119680 489680 0 0 $X=1119250 $Y=489290
X1580 1919 44 2008 1 2 2027 MUX2X1 $T=1120800 615120 1 0 $X=1120370 $Y=610565
X1581 1928 44 2020 1 2 2015 MUX2X1 $T=1129200 528880 0 180 $X=1123170 $Y=524325
X1582 1922 44 2021 1 2 2016 MUX2X1 $T=1129200 552400 1 180 $X=1123170 $Y=552010
X1583 1919 39 2034 1 2 2035 MUX2X1 $T=1124720 505360 1 0 $X=1124290 $Y=500805
X1584 1910 39 1953 1 2 2045 MUX2X1 $T=1133680 583760 0 0 $X=1133250 $Y=583370
X1585 1910 44 2041 1 2 2053 MUX2X1 $T=1139840 591600 0 0 $X=1139410 $Y=591210
X1586 1927 44 2052 1 2 2049 MUX2X1 $T=1149360 521040 1 180 $X=1143330 $Y=520650
X1587 329 2054 2043 1 2 339 MUX2X1 $T=1144320 434800 0 0 $X=1143890 $Y=434410
X1588 1922 39 2061 1 2 2069 MUX2X1 $T=1146000 505360 1 0 $X=1145570 $Y=500805
X1589 2043 44 2068 1 2 2073 MUX2X1 $T=1147120 591600 0 0 $X=1146690 $Y=591210
X1590 1927 39 2072 1 2 2074 MUX2X1 $T=1148240 489680 0 0 $X=1147810 $Y=489290
X1591 2043 39 2075 1 2 2080 MUX2X1 $T=1149920 583760 1 0 $X=1149490 $Y=579205
X1592 37 2083 38 1 2 2089 MUX2X1 $T=1164480 552400 1 180 $X=1158450 $Y=552010
X1593 363 365 327 1 2 2160 MUX2X1 $T=1212640 615120 1 180 $X=1206610 $Y=614730
X1684 8 399 1 2 400 AND2X1 $T=633040 599440 0 0 $X=632610 $Y=599050
X1685 408 22 1 2 402 AND2X1 $T=642560 599440 1 180 $X=638770 $Y=599050
X1686 27 6 1 2 389 AND2X1 $T=646480 615120 1 180 $X=642690 $Y=614730
X1687 415 412 1 2 33 AND2X1 $T=655440 599440 0 0 $X=655010 $Y=599050
X1688 691 697 1 2 706 AND2X1 $T=820080 552400 0 0 $X=819650 $Y=552010
X1689 738 746 1 2 759 AND2X1 $T=827360 474000 1 0 $X=826930 $Y=469445
X1690 765 769 1 2 778 AND2X1 $T=830720 474000 1 0 $X=830290 $Y=469445
X1691 786 792 1 2 800 AND2X1 $T=833520 489680 0 0 $X=833090 $Y=489290
X1692 788 805 1 2 815 AND2X1 $T=835760 458320 0 0 $X=835330 $Y=457930
X1693 848 841 1 2 823 AND2X1 $T=843600 474000 1 180 $X=839810 $Y=473610
X1694 865 849 1 2 881 AND2X1 $T=843040 521040 0 0 $X=842610 $Y=520650
X1695 879 887 1 2 892 AND2X1 $T=844720 591600 1 0 $X=844290 $Y=587045
X1696 883 857 1 2 868 AND2X1 $T=845280 450480 0 0 $X=844850 $Y=450090
X1697 897 877 1 2 901 AND2X1 $T=848080 536720 0 0 $X=847650 $Y=536330
X1698 908 913 1 2 917 AND2X1 $T=849200 591600 1 0 $X=848770 $Y=587045
X1699 921 902 1 2 909 AND2X1 $T=853120 458320 0 180 $X=849330 $Y=453765
X1700 938 130 1 2 952 AND2X1 $T=854240 583760 1 0 $X=853810 $Y=579205
X1701 1016 1008 1 2 959 AND2X1 $T=866560 583760 0 180 $X=862770 $Y=579205
X1702 895 130 1 2 1023 AND2X1 $T=863760 466160 1 0 $X=863330 $Y=461605
X1703 1010 1004 1 2 1017 AND2X1 $T=868800 536720 0 180 $X=865010 $Y=532165
X1704 1055 1043 1 2 998 AND2X1 $T=871040 505360 1 180 $X=867250 $Y=504970
X1705 1077 1074 1 2 1040 AND2X1 $T=874960 591600 1 180 $X=871170 $Y=591210
X1706 1084 1060 1 2 1085 AND2X1 $T=877200 513200 1 180 $X=873410 $Y=512810
X1707 1121 1111 1 2 1103 AND2X1 $T=880000 481840 0 180 $X=876210 $Y=477285
X1708 1183 1155 1 2 187 AND2X1 $T=887840 434800 1 0 $X=887410 $Y=430245
X1709 1173 1186 1 2 1181 AND2X1 $T=892320 466160 1 180 $X=888530 $Y=465770
X1710 970 194 1 2 1235 AND2X1 $T=897360 481840 0 0 $X=896930 $Y=481450
X1711 1202 98 1 2 106 AND2X1 $T=910240 450480 0 0 $X=909810 $Y=450090
X1712 190 1236 1 2 172 AND2X1 $T=917520 442640 0 180 $X=913730 $Y=438085
X1713 194 1236 1 2 1061 AND2X1 $T=914160 481840 1 0 $X=913730 $Y=477285
X1714 1243 190 1 2 696 AND2X1 $T=919760 458320 1 180 $X=915970 $Y=457930
X1715 185 1243 1 2 1186 AND2X1 $T=919760 466160 1 180 $X=915970 $Y=465770
X1716 185 1236 1 2 1162 AND2X1 $T=918640 481840 0 0 $X=918210 $Y=481450
X1717 180 1236 1 2 1124 AND2X1 $T=918640 497520 0 0 $X=918210 $Y=497130
X1718 1202 101 1 2 114 AND2X1 $T=922560 434800 0 0 $X=922130 $Y=434410
X1719 1249 194 1 2 1167 AND2X1 $T=928160 458320 0 180 $X=924370 $Y=453765
X1720 1298 1268 1 2 1287 AND2X1 $T=934320 583760 1 180 $X=930530 $Y=583370
X1721 1378 82 1 2 1344 AND2X1 $T=946640 536720 0 180 $X=942850 $Y=532165
X1722 1397 1401 1 2 1400 AND2X1 $T=946080 474000 1 0 $X=945650 $Y=469445
X1723 1368 1405 1 2 1402 AND2X1 $T=946640 544560 1 0 $X=946210 $Y=540005
X1724 1415 1380 1 2 1429 AND2X1 $T=948320 591600 0 0 $X=947890 $Y=591210
X1725 1411 1433 1 2 1439 AND2X1 $T=949440 528880 1 0 $X=949010 $Y=524325
X1726 1441 1431 1 2 1387 AND2X1 $T=953360 505360 1 180 $X=949570 $Y=504970
X1727 1443 1408 1 2 1455 AND2X1 $T=951680 591600 1 0 $X=951250 $Y=587045
X1728 1468 1472 1 2 1432 AND2X1 $T=958400 513200 0 180 $X=954610 $Y=508645
X1729 1485 1490 1 2 1494 AND2X1 $T=957280 591600 0 0 $X=956850 $Y=591210
X1730 1509 1515 1 2 1527 AND2X1 $T=962880 552400 1 0 $X=962450 $Y=547845
X1731 1481 130 1 2 1558 AND2X1 $T=968480 568080 1 0 $X=968050 $Y=563525
X1732 1532 1531 1 2 1365 AND2X1 $T=976320 536720 1 180 $X=972530 $Y=536330
X1733 1570 1599 1 2 1480 AND2X1 $T=978560 442640 1 180 $X=974770 $Y=442250
X1734 1594 1632 1 2 1636 AND2X1 $T=978000 536720 0 0 $X=977570 $Y=536330
X1735 1630 1646 1 2 260 AND2X1 $T=984720 434800 0 180 $X=980930 $Y=430245
X1736 1694 1669 1 2 1718 AND2X1 $T=989760 458320 0 0 $X=989330 $Y=457930
X1737 1716 1717 1 2 1419 AND2X1 $T=997040 583760 1 180 $X=993250 $Y=583370
X1738 1739 274 1 2 1765 AND2X1 $T=998160 434800 0 0 $X=997730 $Y=434410
X1739 1797 1449 1 2 1782 AND2X1 $T=1007120 489680 1 180 $X=1003330 $Y=489290
X1740 1806 1789 1 2 1777 AND2X1 $T=1007120 505360 1 180 $X=1003330 $Y=504970
X1741 1792 1799 1 2 1755 AND2X1 $T=1007680 458320 1 0 $X=1007250 $Y=453765
X1742 1878 1822 1 2 287 AND2X1 $T=1023360 568080 1 0 $X=1022930 $Y=563525
X1743 299 1891 1 2 289 AND2X1 $T=1059760 434800 0 180 $X=1055970 $Y=430245
X1744 2098 2094 1 2 341 AND2X1 $T=1164480 583760 0 0 $X=1164050 $Y=583370
X1745 2106 2117 1 2 38 AND2X1 $T=1172320 568080 1 0 $X=1171890 $Y=563525
X1767 403 1 2 399 INVX2 $T=637520 599440 0 0 $X=637090 $Y=599050
X1768 405 1 2 401 INVX2 $T=639200 607280 1 180 $X=637090 $Y=606890
X1769 20 1 2 413 INVX2 $T=647600 599440 1 0 $X=647170 $Y=594885
X1770 14 1 2 414 INVX2 $T=648720 591600 0 0 $X=648290 $Y=591210
X1771 26 1 2 11 INVX2 $T=649280 615120 1 0 $X=648850 $Y=610565
X1772 25 1 2 6 INVX2 $T=650960 615120 0 0 $X=650530 $Y=614730
X1773 24 1 2 23 INVX2 $T=653200 607280 0 180 $X=651090 $Y=602725
X1774 417 1 2 36 INVX2 $T=666640 615120 1 0 $X=666210 $Y=610565
X1775 699 1 2 679 INVX2 $T=822880 536720 0 180 $X=820770 $Y=532165
X1776 1086 1 2 169 INVX2 $T=873840 434800 1 0 $X=873410 $Y=430245
X1777 1152 1 2 1154 INVX2 $T=885040 583760 1 0 $X=884610 $Y=579205
X1778 1157 1 2 1176 INVX2 $T=886720 505360 1 0 $X=886290 $Y=500805
X1779 1170 1 2 1174 INVX2 $T=887840 560240 0 0 $X=887410 $Y=559850
X1780 1012 1 2 1213 INVX2 $T=894000 474000 1 180 $X=891890 $Y=473610
X1781 186 1 2 1214 INVX2 $T=894000 607280 1 180 $X=891890 $Y=606890
X1782 98 1 2 101 INVX2 $T=894560 434800 0 180 $X=892450 $Y=430245
X1783 1075 1 2 1216 INVX2 $T=894560 466160 1 180 $X=892450 $Y=465770
X1784 163 1 2 189 INVX2 $T=894560 615120 1 180 $X=892450 $Y=614730
X1785 1234 1 2 1209 INVX2 $T=911920 505360 1 0 $X=911490 $Y=500805
X1786 1218 1 2 667 INVX2 $T=915840 474000 0 180 $X=913730 $Y=469445
X1787 696 1 2 1175 INVX2 $T=916400 497520 1 180 $X=914290 $Y=497130
X1788 1243 1 2 1245 INVX2 $T=918640 434800 1 180 $X=916530 $Y=434410
X1789 111 1 2 1241 INVX2 $T=924800 450480 0 180 $X=922690 $Y=445925
X1790 1260 1 2 1252 INVX2 $T=927600 552400 1 180 $X=925490 $Y=552010
X1791 1224 1 2 1262 INVX2 $T=926480 474000 1 0 $X=926050 $Y=469445
X1792 93 1 2 1268 INVX2 $T=928720 575920 0 0 $X=928290 $Y=575530
X1793 1267 1 2 707 INVX2 $T=933200 458320 1 0 $X=932770 $Y=453765
X1794 1275 1 2 719 INVX2 $T=934880 458320 1 180 $X=932770 $Y=457930
X1795 1330 1 2 1338 INVX2 $T=938800 552400 1 0 $X=938370 $Y=547845
X1796 1361 1 2 1335 INVX2 $T=943840 474000 0 180 $X=941730 $Y=469445
X1797 1346 1 2 1390 INVX2 $T=949440 528880 1 180 $X=947330 $Y=528490
X1798 1382 1 2 1088 INVX2 $T=952240 489680 1 180 $X=950130 $Y=489290
X1799 114 1 2 1453 INVX2 $T=952800 528880 0 0 $X=952370 $Y=528490
X1800 1507 1 2 1503 INVX2 $T=963440 489680 0 180 $X=961330 $Y=485125
X1801 1427 1 2 1526 INVX2 $T=964560 458320 1 0 $X=964130 $Y=453765
X1802 1466 1 2 1625 INVX2 $T=983600 450480 1 180 $X=981490 $Y=450090
X1803 1833 1 2 1836 INVX2 $T=1011040 434800 1 0 $X=1010610 $Y=430245
X1804 130 1 2 81 INVX2 $T=1020560 434800 0 0 $X=1020130 $Y=434410
X1805 99 1 2 1866 INVX2 $T=1030080 450480 0 180 $X=1027970 $Y=445925
X1806 293 1 2 1906 INVX2 $T=1060320 442640 1 0 $X=1059890 $Y=438085
X1807 1900 1 2 300 INVX2 $T=1062000 442640 1 0 $X=1061570 $Y=438085
X1808 1935 1 2 1929 INVX2 $T=1074880 434800 0 180 $X=1072770 $Y=430245
X1809 1909 1 2 1956 INVX2 $T=1087200 442640 1 0 $X=1086770 $Y=438085
X1810 1976 1 2 63 INVX2 $T=1101760 458320 1 180 $X=1099650 $Y=457930
X1811 329 1 2 2011 INVX2 $T=1120800 442640 1 0 $X=1120370 $Y=438085
X1812 320 1 2 2012 INVX2 $T=1121360 450480 0 0 $X=1120930 $Y=450090
X1813 2033 1 2 2037 INVX2 $T=1130880 442640 1 0 $X=1130450 $Y=438085
X1814 2044 1 2 2057 INVX2 $T=1147120 466160 1 0 $X=1146690 $Y=461605
X1815 2046 1 2 2070 INVX2 $T=1150480 466160 1 0 $X=1150050 $Y=461605
X1816 2055 1 2 2078 INVX2 $T=1153280 466160 1 0 $X=1152850 $Y=461605
X1817 2083 1 2 2087 INVX2 $T=1157760 552400 1 0 $X=1157330 $Y=547845
X1818 2092 1 2 2091 INVX2 $T=1165040 544560 0 0 $X=1164610 $Y=544170
X1819 421 1 2 2098 INVX2 $T=1168960 575920 1 180 $X=1166850 $Y=575530
X1820 2103 1 2 2107 INVX2 $T=1168400 575920 1 0 $X=1167970 $Y=571365
X1821 341 1 2 2117 INVX2 $T=1173440 560240 1 0 $X=1173010 $Y=555685
X1822 346 1 2 2116 INVX2 $T=1175120 615120 0 180 $X=1173010 $Y=610565
X1823 2104 1 2 2118 INVX2 $T=1174000 528880 0 0 $X=1173570 $Y=528490
X1824 38 1 2 2120 INVX2 $T=1175120 544560 0 0 $X=1174690 $Y=544170
X1825 2122 1 2 2115 INVX2 $T=1177920 568080 1 180 $X=1175810 $Y=567690
X1826 327 1 2 349 INVX2 $T=1178480 607280 0 0 $X=1178050 $Y=606890
X1827 2128 1 2 2127 INVX2 $T=1180160 552400 1 0 $X=1179730 $Y=547845
X1828 348 1 2 2135 INVX2 $T=1181280 615120 1 0 $X=1180850 $Y=610565
X1829 284 1 2 352 INVX2 $T=1183520 615120 0 0 $X=1183090 $Y=614730
X1830 2138 1 2 2145 INVX2 $T=1187440 544560 1 0 $X=1187010 $Y=540005
X1831 2151 1 2 2143 INVX2 $T=1190240 607280 0 180 $X=1188130 $Y=602725
X1832 364 1 2 2157 INVX2 $T=1205360 607280 0 180 $X=1203250 $Y=602725
X1895 427 474 2 368 1 2 424 DFFQSRX1 $T=648160 536720 1 0 $X=647730 $Y=532165
X1896 367 474 368 2 1 2 426 DFFQSRX1 $T=648160 544560 0 0 $X=647730 $Y=544170
X1897 426 474 368 2 1 2 421 DFFQSRX1 $T=685680 560240 1 180 $X=660050 $Y=559850
X1898 431 474 2 368 1 2 422 DFFQSRX1 $T=687360 568080 0 180 $X=661730 $Y=563525
X1899 458 474 2 368 1 2 465 DFFQSRX1 $T=678960 544560 1 0 $X=678530 $Y=540005
X1900 459 474 2 368 1 2 464 DFFQSRX1 $T=678960 560240 1 0 $X=678530 $Y=555685
X1901 455 474 2 368 1 2 462 DFFQSRX1 $T=678960 591600 1 0 $X=678530 $Y=587045
X1902 450 474 2 368 1 2 41 DFFQSRX1 $T=678960 599440 0 0 $X=678530 $Y=599050
X1903 463 485 2 368 1 2 469 DFFQSRX1 $T=681200 513200 1 0 $X=680770 $Y=508645
X1904 470 485 2 368 1 2 452 DFFQSRX1 $T=711440 505360 0 180 $X=685810 $Y=500805
X1905 473 485 2 368 1 2 475 DFFQSRX1 $T=687360 497520 0 0 $X=686930 $Y=497130
X1906 480 485 2 368 1 2 478 DFFQSRX1 $T=688480 474000 1 0 $X=688050 $Y=469445
X1907 479 474 2 368 1 2 48 DFFQSRX1 $T=692400 552400 0 0 $X=691970 $Y=552010
X1908 481 474 2 368 1 2 483 DFFQSRX1 $T=695760 568080 1 0 $X=695330 $Y=563525
X1909 482 562 2 368 1 2 487 DFFQSRX1 $T=696320 583760 0 0 $X=695890 $Y=583370
X1910 490 562 2 368 1 2 488 DFFQSRX1 $T=696880 591600 0 0 $X=696450 $Y=591210
X1911 496 563 2 368 1 2 471 DFFQSRX1 $T=724880 521040 1 180 $X=699250 $Y=520650
X1912 495 563 2 368 1 2 472 DFFQSRX1 $T=726000 536720 1 180 $X=700370 $Y=536330
X1913 491 485 2 368 1 2 486 DFFQSRX1 $T=704160 481840 1 0 $X=703730 $Y=477285
X1914 517 485 2 368 1 2 505 DFFQSRX1 $T=704160 489680 0 0 $X=703730 $Y=489290
X1915 499 485 2 368 1 2 502 DFFQSRX1 $T=704160 505360 0 0 $X=703730 $Y=504970
X1916 507 562 2 368 1 2 529 DFFQSRX1 $T=709760 575920 1 0 $X=709330 $Y=571365
X1917 511 562 2 368 1 2 526 DFFQSRX1 $T=709760 591600 1 0 $X=709330 $Y=587045
X1918 522 562 2 368 1 2 525 DFFQSRX1 $T=712000 599440 0 0 $X=711570 $Y=599050
X1919 534 563 2 368 1 2 533 DFFQSRX1 $T=712560 528880 0 0 $X=712130 $Y=528490
X1920 524 563 2 368 1 2 523 DFFQSRX1 $T=713120 544560 0 0 $X=712690 $Y=544170
X1921 542 563 2 368 1 2 527 DFFQSRX1 $T=719840 505360 1 0 $X=719410 $Y=500805
X1922 539 562 2 368 1 2 530 DFFQSRX1 $T=721520 568080 0 0 $X=721090 $Y=567690
X1923 567 562 2 368 1 2 521 DFFQSRX1 $T=747280 560240 0 180 $X=721650 $Y=555685
X1924 554 571 2 368 1 2 476 DFFQSRX1 $T=753440 458320 0 180 $X=727810 $Y=453765
X1925 555 571 2 368 1 2 535 DFFQSRX1 $T=754000 474000 0 180 $X=728370 $Y=469445
X1926 546 562 2 368 1 2 55 DFFQSRX1 $T=729360 599440 1 0 $X=728930 $Y=594885
X1927 544 562 2 368 1 2 57 DFFQSRX1 $T=729920 583760 0 0 $X=729490 $Y=583370
X1928 543 571 2 368 1 2 556 DFFQSRX1 $T=730480 481840 1 0 $X=730050 $Y=477285
X1929 545 563 2 368 1 2 557 DFFQSRX1 $T=730480 497520 0 0 $X=730050 $Y=497130
X1930 551 369 2 368 1 2 56 DFFQSRX1 $T=731600 615120 1 0 $X=731170 $Y=610565
X1931 558 562 2 368 1 2 564 DFFQSRX1 $T=738320 575920 1 0 $X=737890 $Y=571365
X1932 565 563 2 368 1 2 61 DFFQSRX1 $T=740560 513200 1 0 $X=740130 $Y=508645
X1933 566 563 2 368 1 2 62 DFFQSRX1 $T=740560 521040 1 0 $X=740130 $Y=516485
X1934 550 563 2 368 1 2 560 DFFQSRX1 $T=740560 528880 1 0 $X=740130 $Y=524325
X1935 572 563 2 368 1 2 576 DFFQSRX1 $T=749520 536720 0 0 $X=749090 $Y=536330
X1936 575 563 2 368 1 2 580 DFFQSRX1 $T=751200 552400 1 0 $X=750770 $Y=547845
X1937 552 563 2 368 1 2 561 DFFQSRX1 $T=752320 544560 1 0 $X=751890 $Y=540005
X1938 574 571 2 368 1 2 578 DFFQSRX1 $T=754000 474000 1 0 $X=753570 $Y=469445
X1939 581 562 2 368 1 2 64 DFFQSRX1 $T=755680 560240 0 0 $X=755250 $Y=559850
X1940 582 562 2 368 1 2 587 DFFQSRX1 $T=756240 560240 1 0 $X=755810 $Y=555685
X1941 588 71 2 368 1 2 518 DFFQSRX1 $T=782000 583760 0 180 $X=756370 $Y=579205
X1942 604 571 2 368 1 2 607 DFFQSRX1 $T=759040 450480 1 0 $X=758610 $Y=445925
X1943 589 571 2 368 1 2 595 DFFQSRX1 $T=759040 450480 0 0 $X=758610 $Y=450090
X1944 592 571 2 368 1 2 598 DFFQSRX1 $T=759040 466160 0 0 $X=758610 $Y=465770
X1945 594 571 2 368 1 2 67 DFFQSRX1 $T=759040 489680 1 0 $X=758610 $Y=485125
X1946 579 571 2 368 1 2 586 DFFQSRX1 $T=759040 489680 0 0 $X=758610 $Y=489290
X1947 596 571 2 368 1 2 602 DFFQSRX1 $T=759040 505360 1 0 $X=758610 $Y=500805
X1948 600 571 2 368 1 2 603 DFFQSRX1 $T=759040 521040 0 0 $X=758610 $Y=520650
X1949 583 370 2 368 1 2 65 DFFQSRX1 $T=759040 591600 0 0 $X=758610 $Y=591210
X1950 584 370 2 368 1 2 66 DFFQSRX1 $T=759040 599440 0 0 $X=758610 $Y=599050
X1951 606 370 2 368 1 2 570 DFFQSRX1 $T=784240 607280 1 180 $X=758610 $Y=606890
X1952 597 370 2 368 1 2 68 DFFQSRX1 $T=759040 615120 0 0 $X=758610 $Y=614730
X1953 609 71 2 368 1 2 615 DFFQSRX1 $T=786480 552400 1 0 $X=786050 $Y=547845
X1954 608 71 2 368 1 2 614 DFFQSRX1 $T=789840 536720 0 0 $X=789410 $Y=536330
X1955 612 71 2 368 1 2 618 DFFQSRX1 $T=789840 560240 0 0 $X=789410 $Y=559850
X1956 611 71 2 368 1 2 617 DFFQSRX1 $T=789840 575920 1 0 $X=789410 $Y=571365
X1957 622 71 2 368 1 2 631 DFFQSRX1 $T=796000 583760 1 0 $X=795570 $Y=579205
X1958 613 71 2 368 1 2 72 DFFQSRX1 $T=797120 583760 0 0 $X=796690 $Y=583370
X1959 628 71 2 368 1 2 641 DFFQSRX1 $T=797120 607280 1 0 $X=796690 $Y=602725
X1960 627 71 2 368 1 2 640 DFFQSRX1 $T=798240 599440 1 0 $X=797810 $Y=594885
X1961 372 373 2 368 1 2 70 DFFQSRX1 $T=844160 615120 0 180 $X=818530 $Y=610565
X1962 753 71 2 368 1 2 777 DFFQSRX1 $T=819520 607280 0 0 $X=819090 $Y=606890
X1963 772 71 2 368 1 2 799 DFFQSRX1 $T=822320 591600 0 0 $X=821890 $Y=591210
X1964 860 373 2 368 1 2 890 DFFQSRX1 $T=840800 599440 1 0 $X=840370 $Y=594885
X1965 947 373 2 368 1 2 873 DFFQSRX1 $T=869920 607280 1 180 $X=844290 $Y=606890
X1966 994 373 2 368 1 2 1021 DFFQSRX1 $T=852560 607280 1 0 $X=852130 $Y=602725
X1967 1233 1623 2 368 1 2 1238 DFFQSRX1 $T=901280 591600 0 0 $X=900850 $Y=591210
X1968 1269 1623 2 368 1 2 1293 DFFQSRX1 $T=919760 607280 1 0 $X=919330 $Y=602725
X1969 1334 1623 2 368 1 2 1359 DFFQSRX1 $T=926480 615120 1 0 $X=926050 $Y=610565
X1970 376 1623 2 368 1 2 225 DFFQSRX1 $T=976880 615120 0 180 $X=951250 $Y=610565
X1971 1534 1623 2 368 1 2 1440 DFFQSRX1 $T=977440 599440 1 180 $X=951810 $Y=599050
X1972 1612 1623 2 368 1 2 1498 DFFQSRX1 $T=985840 599440 0 180 $X=960210 $Y=594885
X1973 1597 1623 2 368 1 2 1499 DFFQSRX1 $T=985840 607280 1 180 $X=960210 $Y=606890
X1974 1756 1623 2 368 1 2 1640 DFFQSRX1 $T=1006560 591600 1 180 $X=980930 $Y=591210
X1975 1754 303 2 368 1 2 248 DFFQSRX1 $T=1006560 599440 1 180 $X=980930 $Y=599050
X1976 1834 303 2 368 1 2 961 DFFQSRX1 $T=1006560 607280 0 180 $X=980930 $Y=602725
X1977 1884 303 2 368 1 2 269 DFFQSRX1 $T=1012160 615120 0 0 $X=1011730 $Y=614730
X1978 1886 303 2 368 1 2 1357 DFFQSRX1 $T=1013840 599440 0 0 $X=1013410 $Y=599050
X1979 1889 377 2 368 1 2 662 DFFQSRX1 $T=1050800 442640 0 180 $X=1025170 $Y=438085
X1980 1895 303 2 368 1 2 286 DFFQSRX1 $T=1058080 607280 1 180 $X=1032450 $Y=606890
X1981 1897 315 2 368 1 2 1210 DFFQSRX1 $T=1059200 591600 1 180 $X=1033570 $Y=591210
X1982 1899 315 2 368 1 2 757 DFFQSRX1 $T=1060320 583760 1 180 $X=1034690 $Y=583370
X1983 1898 315 2 368 1 2 1454 DFFQSRX1 $T=1060880 568080 1 180 $X=1035250 $Y=567690
X1984 1902 315 2 368 1 2 1506 DFFQSRX1 $T=1066480 575920 1 180 $X=1040850 $Y=575530
X1985 1903 1936 2 368 1 2 1881 DFFQSRX1 $T=1068720 560240 1 180 $X=1043090 $Y=559850
X1986 1914 1936 2 368 1 2 1491 DFFQSRX1 $T=1073760 552400 1 180 $X=1048130 $Y=552010
X1987 1916 1936 2 368 1 2 1226 DFFQSRX1 $T=1074880 552400 0 180 $X=1049250 $Y=547845
X1988 1918 1936 2 368 1 2 1883 DFFQSRX1 $T=1075440 544560 0 180 $X=1049810 $Y=540005
X1989 1921 1936 2 368 1 2 1538 DFFQSRX1 $T=1076000 536720 0 180 $X=1050370 $Y=532165
X1990 378 325 2 368 1 2 1900 DFFQSRX1 $T=1076560 458320 1 180 $X=1050930 $Y=457930
X1991 1923 1936 2 368 1 2 1033 DFFQSRX1 $T=1076560 528880 0 180 $X=1050930 $Y=524325
X1992 1924 1936 2 368 1 2 1882 DFFQSRX1 $T=1077120 513200 0 180 $X=1051490 $Y=508645
X1993 1925 1936 2 368 1 2 962 DFFQSRX1 $T=1077120 513200 1 180 $X=1051490 $Y=512810
X1994 1934 315 2 368 1 2 296 DFFQSRX1 $T=1077120 591600 0 180 $X=1051490 $Y=587045
X1995 1952 1936 2 368 1 2 153 DFFQSRX1 $T=1077680 489680 1 180 $X=1052050 $Y=489290
X1996 1926 1936 2 368 1 2 140 DFFQSRX1 $T=1077680 497520 1 180 $X=1052050 $Y=497130
X1997 1932 325 2 368 1 2 1880 DFFQSRX1 $T=1078800 466160 1 180 $X=1053170 $Y=465770
X1998 1933 1936 2 368 1 2 146 DFFQSRX1 $T=1078800 481840 0 180 $X=1053170 $Y=477285
X1999 1911 1936 2 368 1 2 91 DFFQSRX1 $T=1078800 489680 0 180 $X=1053170 $Y=485125
X2000 379 315 2 368 1 2 297 DFFQSRX1 $T=1082720 615120 1 180 $X=1057090 $Y=614730
X2001 1904 303 2 368 1 2 1908 DFFQSRX1 $T=1058080 607280 0 0 $X=1057650 $Y=606890
X2002 1943 325 2 368 1 2 1885 DFFQSRX1 $T=1090000 458320 0 180 $X=1064370 $Y=453765
X2003 1939 325 2 368 1 2 1957 DFFQSRX1 $T=1065360 450480 0 0 $X=1064930 $Y=450090
X2004 1944 315 2 368 1 2 1945 DFFQSRX1 $T=1067040 575920 1 0 $X=1066610 $Y=571365
X2005 1946 315 2 368 1 2 304 DFFQSRX1 $T=1092240 583760 1 180 $X=1066610 $Y=583370
X2006 1949 1936 2 368 1 2 310 DFFQSRX1 $T=1074880 568080 0 0 $X=1074450 $Y=567690
X2007 1963 315 2 368 1 2 1901 DFFQSRX1 $T=1100080 591600 1 180 $X=1074450 $Y=591210
X2008 1959 1986 2 368 1 2 1917 DFFQSRX1 $T=1106240 528880 0 180 $X=1080610 $Y=524325
X2009 1969 1986 2 368 1 2 308 DFFQSRX1 $T=1106240 536720 1 180 $X=1080610 $Y=536330
X2010 1968 1986 2 368 1 2 1912 DFFQSRX1 $T=1106240 544560 1 180 $X=1080610 $Y=544170
X2011 1960 1936 2 368 1 2 317 DFFQSRX1 $T=1081040 560240 0 0 $X=1080610 $Y=559850
X2012 1951 325 2 368 1 2 1966 DFFQSRX1 $T=1082720 442640 0 0 $X=1082290 $Y=442250
X2013 1974 325 2 368 1 2 1907 DFFQSRX1 $T=1110160 466160 1 180 $X=1084530 $Y=465770
X2014 1977 325 2 368 1 2 1948 DFFQSRX1 $T=1110160 481840 0 180 $X=1084530 $Y=477285
X2015 1964 1986 2 368 1 2 1967 DFFQSRX1 $T=1084960 505360 1 0 $X=1084530 $Y=500805
X2016 1982 1986 2 368 1 2 1978 DFFQSRX1 $T=1084960 513200 0 0 $X=1084530 $Y=512810
X2017 1975 1986 2 368 1 2 1972 DFFQSRX1 $T=1085520 505360 0 0 $X=1085090 $Y=504970
X2018 1984 325 2 368 1 2 1941 DFFQSRX1 $T=1111280 489680 0 180 $X=1085650 $Y=485125
X2019 1983 1986 2 368 1 2 1920 DFFQSRX1 $T=1112960 521040 1 180 $X=1087330 $Y=520650
X2020 1980 331 2 368 1 2 306 DFFQSRX1 $T=1112960 607280 0 180 $X=1087330 $Y=602725
X2021 1999 1986 2 368 1 2 1961 DFFQSRX1 $T=1117440 528880 1 180 $X=1091810 $Y=528490
X2022 1995 1986 2 368 1 2 1915 DFFQSRX1 $T=1117440 552400 0 180 $X=1091810 $Y=547845
X2023 1988 315 2 368 1 2 1992 DFFQSRX1 $T=1092240 575920 1 0 $X=1091810 $Y=571365
X2024 2004 331 2 368 1 2 295 DFFQSRX1 $T=1117440 583760 1 180 $X=1091810 $Y=583370
X2025 1994 331 2 368 1 2 302 DFFQSRX1 $T=1117440 591600 0 180 $X=1091810 $Y=587045
X2026 2001 332 2 368 1 2 1973 DFFQSRX1 $T=1128640 458320 1 180 $X=1103010 $Y=457930
X2027 2006 332 2 368 1 2 1971 DFFQSRX1 $T=1130880 466160 0 180 $X=1105250 $Y=461605
X2028 2022 331 2 368 1 2 1987 DFFQSRX1 $T=1133680 560240 1 180 $X=1108050 $Y=559850
X2029 2029 332 2 368 1 2 2033 DFFQSRX1 $T=1119680 450480 1 0 $X=1119250 $Y=445925
X2030 2039 336 2 368 1 2 1965 DFFQSRX1 $T=1144880 552400 0 180 $X=1119250 $Y=547845
X2031 2028 332 2 368 1 2 1958 DFFQSRX1 $T=1123600 434800 1 0 $X=1123170 $Y=430245
X2032 2032 332 2 368 1 2 2013 DFFQSRX1 $T=1123600 466160 0 0 $X=1123170 $Y=465770
X2033 2036 332 2 368 1 2 1981 DFFQSRX1 $T=1123600 481840 0 0 $X=1123170 $Y=481450
X2034 2019 332 2 368 1 2 1928 DFFQSRX1 $T=1123600 497520 0 0 $X=1123170 $Y=497130
X2035 2035 332 2 368 1 2 1919 DFFQSRX1 $T=1123600 513200 1 0 $X=1123170 $Y=508645
X2036 2018 332 2 368 1 2 2034 DFFQSRX1 $T=1123600 521040 1 0 $X=1123170 $Y=516485
X2037 2015 1986 2 368 1 2 2020 DFFQSRX1 $T=1123600 536720 0 0 $X=1123170 $Y=536330
X2038 1991 331 2 368 1 2 1990 DFFQSRX1 $T=1123600 599440 1 0 $X=1123170 $Y=594885
X2039 2027 331 2 368 1 2 2008 DFFQSRX1 $T=1123600 607280 1 0 $X=1123170 $Y=602725
X2040 2053 334 2 368 1 2 2041 DFFQSRX1 $T=1157200 607280 1 180 $X=1131570 $Y=606890
X2041 2058 2056 2 368 1 2 1953 DFFQSRX1 $T=1157760 591600 0 180 $X=1132130 $Y=587045
X2042 2054 336 2 368 1 2 2040 DFFQSRX1 $T=1159440 442640 1 180 $X=1133810 $Y=442250
X2043 2049 1986 2 368 1 2 2052 DFFQSRX1 $T=1134240 528880 0 0 $X=1133810 $Y=528490
X2044 2064 336 2 368 1 2 1955 DFFQSRX1 $T=1160560 528880 0 180 $X=1134930 $Y=524325
X2045 2080 2056 2 368 1 2 2043 DFFQSRX1 $T=1162240 575920 0 180 $X=1136610 $Y=571365
X2046 2063 336 2 368 1 2 2044 DFFQSRX1 $T=1162800 481840 0 180 $X=1137170 $Y=477285
X2047 2069 336 2 368 1 2 1922 DFFQSRX1 $T=1162800 497520 0 180 $X=1137170 $Y=492965
X2048 2073 331 2 368 1 2 2068 DFFQSRX1 $T=1137600 599440 0 0 $X=1137170 $Y=599050
X2049 2074 336 2 368 1 2 1927 DFFQSRX1 $T=1163360 489680 0 180 $X=1137730 $Y=485125
X2050 2062 332 2 368 1 2 2072 DFFQSRX1 $T=1139280 505360 0 0 $X=1138850 $Y=504970
X2051 2084 336 2 368 1 2 2046 DFFQSRX1 $T=1165040 450480 1 180 $X=1139410 $Y=450090
X2052 2096 2056 2 368 1 2 2050 DFFQSRX1 $T=1169520 568080 1 180 $X=1143890 $Y=567690
X2053 2089 331 2 368 1 2 2083 DFFQSRX1 $T=1145440 560240 0 0 $X=1145010 $Y=559850
X2054 2081 336 2 368 1 2 2092 DFFQSRX1 $T=1148800 536720 0 0 $X=1148370 $Y=536330
X2055 2095 336 2 368 1 2 2061 DFFQSRX1 $T=1177920 505360 0 180 $X=1152290 $Y=500805
X2056 421 2056 368 2 1 2 2094 DFFQSRX1 $T=1153840 599440 1 0 $X=1153410 $Y=594885
X2057 2101 2056 2 368 1 2 2088 DFFQSRX1 $T=1184080 513200 1 180 $X=1158450 $Y=512810
X2058 2133 2056 2 368 1 2 2104 DFFQSRX1 $T=1194160 513200 0 180 $X=1168530 $Y=508645
X2059 2132 2056 2 368 1 2 2075 DFFQSRX1 $T=1168960 591600 1 0 $X=1168530 $Y=587045
X2060 2149 2056 2 368 1 2 2108 DFFQSRX1 $T=1194720 521040 1 180 $X=1169090 $Y=520650
X2061 344 2056 2 368 1 2 2122 DFFQSRX1 $T=1170080 575920 1 0 $X=1169650 $Y=571365
X2062 2141 2056 2 368 1 2 2110 DFFQSRX1 $T=1195840 575920 1 180 $X=1170210 $Y=575530
X2063 2152 2056 2 368 1 2 2121 DFFQSRX1 $T=1203120 568080 0 180 $X=1177490 $Y=563525
X2064 2154 2056 2 368 1 2 2128 DFFQSRX1 $T=1203680 552400 1 180 $X=1178050 $Y=552010
X2101 477 1 2 474 BUFX1 $T=700800 568080 1 180 $X=697570 $Y=567690
X2102 477 1 2 485 BUFX1 $T=709200 521040 0 180 $X=705970 $Y=516485
X2103 477 1 2 562 BUFX1 $T=745600 560240 0 0 $X=745170 $Y=559850
X2104 477 1 2 563 BUFX1 $T=746720 536720 0 0 $X=746290 $Y=536330
X2105 477 1 2 571 BUFX1 $T=756240 521040 0 0 $X=755810 $Y=520650
X2106 605 1 2 477 BUFX1 $T=783680 568080 0 180 $X=780450 $Y=563525
X2107 477 1 2 71 BUFX1 $T=788720 568080 0 0 $X=788290 $Y=567690
X2108 142 1 2 605 BUFX1 $T=855360 568080 0 180 $X=852130 $Y=563525
X2109 605 1 2 212 BUFX1 $T=931520 568080 1 0 $X=931090 $Y=563525
X2110 212 1 2 1623 BUFX1 $T=981360 607280 0 180 $X=978130 $Y=602725
X2111 605 1 2 1913 BUFX1 $T=1067040 575920 0 180 $X=1063810 $Y=571365
X2112 1913 1 2 303 BUFX1 $T=1064240 599440 0 0 $X=1063810 $Y=599050
X2113 1913 1 2 1936 BUFX1 $T=1072080 568080 0 0 $X=1071650 $Y=567690
X2114 605 1 2 1962 BUFX1 $T=1090560 568080 1 0 $X=1090130 $Y=563525
X2115 1962 1 2 315 BUFX1 $T=1093360 575920 1 180 $X=1090130 $Y=575530
X2116 1962 1 2 1986 BUFX1 $T=1104560 552400 0 0 $X=1104130 $Y=552010
X2117 1962 1 2 325 BUFX1 $T=1114080 489680 0 180 $X=1110850 $Y=485125
X2118 1962 1 2 332 BUFX1 $T=1124160 505360 0 0 $X=1123730 $Y=504970
X2119 1962 1 2 331 BUFX1 $T=1128640 568080 0 180 $X=1125410 $Y=563525
X2120 1913 1 2 334 BUFX1 $T=1129200 591600 0 0 $X=1128770 $Y=591210
X2121 1962 1 2 336 BUFX1 $T=1137600 536720 1 0 $X=1137170 $Y=532165
X2122 1913 1 2 2056 BUFX1 $T=1144880 575920 0 0 $X=1144450 $Y=575530
X2223 1 2 385 5 386 ICV_61 $T=620160 607280 0 0 $X=619730 $Y=606890
X2224 1 2 3 6 4 ICV_61 $T=620160 615120 0 0 $X=619730 $Y=614730
X2225 1 2 11 13 12 ICV_61 $T=627440 615120 0 0 $X=627010 $Y=614730
X2226 1 2 13 6 20 ICV_61 $T=638080 615120 1 0 $X=637650 $Y=610565
X2227 1 2 425 429 427 ICV_61 $T=671680 544560 1 0 $X=671250 $Y=540005
X2228 1 2 38 447 449 ICV_61 $T=682880 536720 0 0 $X=682450 $Y=536330
X2229 1 2 42 483 49 ICV_61 $T=703600 615120 0 0 $X=703170 $Y=614730
X2230 1 2 37 502 506 ICV_61 $T=719280 528880 1 0 $X=718850 $Y=524325
X2231 1 2 37 527 516 ICV_61 $T=721520 497520 0 0 $X=721090 $Y=497130
X2232 1 2 38 505 519 ICV_61 $T=723760 489680 1 0 $X=723330 $Y=485125
X2233 1 2 38 564 559 ICV_61 $T=746720 568080 0 0 $X=746290 $Y=567690
X2234 1 2 633 80 632 ICV_61 $T=808880 450480 1 0 $X=808450 $Y=445925
X2235 1 2 84 680 86 ICV_61 $T=817280 434800 0 0 $X=816850 $Y=434410
X2236 1 2 704 93 710 ICV_61 $T=821200 536720 0 0 $X=820770 $Y=536330
X2237 1 2 707 723 686 ICV_61 $T=822320 481840 0 0 $X=821890 $Y=481450
X2238 1 2 696 95 649 ICV_61 $T=823440 466160 1 0 $X=823010 $Y=461605
X2239 1 2 752 762 104 ICV_61 $T=827920 583760 1 0 $X=827490 $Y=579205
X2240 1 2 646 773 95 ICV_61 $T=830160 489680 0 0 $X=829730 $Y=489290
X2241 1 2 789 82 745 ICV_61 $T=833520 560240 0 0 $X=833090 $Y=559850
X2242 1 2 853 871 126 ICV_61 $T=841920 568080 1 0 $X=841490 $Y=563525
X2243 1 2 842 674 764 ICV_61 $T=844720 474000 1 0 $X=844290 $Y=469445
X2244 1 2 635 873 806 ICV_61 $T=844720 505360 1 0 $X=844290 $Y=500805
X2245 1 2 806 690 893 ICV_61 $T=845840 481840 1 0 $X=845410 $Y=477285
X2246 1 2 719 115 912 ICV_61 $T=849200 442640 0 0 $X=848770 $Y=442250
X2247 1 2 662 890 953 ICV_61 $T=855360 513200 0 0 $X=854930 $Y=512810
X2248 1 2 953 986 932 ICV_61 $T=858720 521040 0 0 $X=858290 $Y=520650
X2249 1 2 856 130 156 ICV_61 $T=859840 450480 0 0 $X=859410 $Y=450090
X2250 1 2 1039 148 1008 ICV_61 $T=867120 583760 0 0 $X=866690 $Y=583370
X2251 1 2 696 775 1050 ICV_61 $T=868240 450480 0 0 $X=867810 $Y=450090
X2252 1 2 1061 1032 1072 ICV_61 $T=870480 521040 1 0 $X=870050 $Y=516485
X2253 1 2 1061 919 1102 ICV_61 $T=876640 458320 1 0 $X=876210 $Y=453765
X2254 1 2 719 878 1119 ICV_61 $T=878320 552400 1 0 $X=877890 $Y=547845
X2255 1 2 172 970 1137 ICV_61 $T=883360 528880 0 0 $X=882930 $Y=528490
X2256 1 2 1169 1175 1127 ICV_61 $T=885040 497520 0 0 $X=884610 $Y=497130
X2257 1 2 1167 749 1184 ICV_61 $T=886720 466160 1 0 $X=886290 $Y=461605
X2258 1 2 1075 1209 1177 ICV_61 $T=888960 489680 0 0 $X=888530 $Y=489290
X2259 1 2 635 1210 1006 ICV_61 $T=888960 521040 1 0 $X=888530 $Y=516485
X2260 1 2 899 190 1217 ICV_61 $T=891200 497520 1 0 $X=890770 $Y=492965
X2261 1 2 1218 1216 1131 ICV_61 $T=892880 474000 1 0 $X=892450 $Y=469445
X2262 1 2 163 191 1208 ICV_61 $T=893440 615120 1 0 $X=893010 $Y=610565
X2263 1 2 180 1243 1234 ICV_61 $T=910240 458320 0 0 $X=909810 $Y=457930
X2264 1 2 1253 93 1259 ICV_61 $T=924800 544560 0 0 $X=924370 $Y=544170
X2265 1 2 1279 1291 1288 ICV_61 $T=929840 552400 0 0 $X=929410 $Y=552010
X2266 1 2 1266 1357 1345 ICV_61 $T=941040 575920 1 0 $X=940610 $Y=571365
X2267 1 2 1339 193 1386 ICV_61 $T=943280 481840 0 0 $X=942850 $Y=481450
X2268 1 2 1384 148 1374 ICV_61 $T=944400 442640 1 0 $X=943970 $Y=438085
X2269 1 2 99 1418 1397 ICV_61 $T=947200 474000 0 0 $X=946770 $Y=473610
X2270 1 2 174 223 1403 ICV_61 $T=947200 497520 0 0 $X=946770 $Y=497130
X2271 1 2 107 1371 1411 ICV_61 $T=947200 521040 0 0 $X=946770 $Y=520650
X2272 1 2 635 1021 1425 ICV_61 $T=948880 575920 1 0 $X=948450 $Y=571365
X2273 1 2 114 1448 1405 ICV_61 $T=950560 536720 0 0 $X=950130 $Y=536330
X2274 1 2 1452 1500 1428 ICV_61 $T=958400 513200 1 0 $X=957970 $Y=508645
X2275 1 2 696 1370 1522 ICV_61 $T=962880 442640 0 0 $X=962450 $Y=442250
X2276 1 2 114 1507 240 ICV_61 $T=963440 434800 1 0 $X=963010 $Y=430245
X2277 1 2 1510 1545 245 ICV_61 $T=966240 505360 1 0 $X=965810 $Y=500805
X2278 1 2 1262 1550 1547 ICV_61 $T=968480 474000 1 0 $X=968050 $Y=469445
X2279 1 2 174 1318 1560 ICV_61 $T=969600 497520 0 0 $X=969170 $Y=497130
X2280 1 2 174 1584 1572 ICV_61 $T=971840 513200 1 0 $X=971410 $Y=508645
X2281 1 2 1532 1591 1543 ICV_61 $T=972960 544560 0 0 $X=972530 $Y=544170
X2282 1 2 1483 1603 1606 ICV_61 $T=975200 513200 0 0 $X=974770 $Y=512810
X2283 1 2 99 1589 1630 ICV_61 $T=978000 442640 1 0 $X=977570 $Y=438085
X2284 1 2 1595 1218 1637 ICV_61 $T=979120 505360 1 0 $X=978690 $Y=500805
X2285 1 2 662 1491 1603 ICV_61 $T=979120 528880 1 0 $X=978690 $Y=524325
X2286 1 2 1038 1650 1643 ICV_61 $T=980240 513200 1 0 $X=979810 $Y=508645
X2287 1 2 1670 1700 1316 ICV_61 $T=987520 497520 1 0 $X=987090 $Y=492965
X2288 1 2 662 614 1664 ICV_61 $T=988080 521040 0 0 $X=987650 $Y=520650
X2289 1 2 1567 80 1711 ICV_61 $T=994800 568080 1 0 $X=994370 $Y=563525
X2290 1 2 1586 1749 270 ICV_61 $T=995360 591600 1 0 $X=994930 $Y=587045
X2291 1 2 719 273 1691 ICV_61 $T=995920 474000 1 0 $X=995490 $Y=469445
X2292 1 2 719 1549 1760 ICV_61 $T=997040 552400 1 0 $X=996610 $Y=547845
X2293 1 2 1582 80 1778 ICV_61 $T=1001520 575920 0 0 $X=1001090 $Y=575530
X2294 1 2 1634 80 1784 ICV_61 $T=1002080 568080 0 0 $X=1001650 $Y=567690
X2295 1 2 106 1757 1830 ICV_61 $T=1008800 505360 1 0 $X=1008370 $Y=500805
X2296 1 2 1786 93 1864 ICV_61 $T=1014400 505360 0 0 $X=1013970 $Y=504970
X2297 1 2 1769 1681 1867 ICV_61 $T=1014960 474000 1 0 $X=1014530 $Y=469445
X2298 1 2 662 1885 1627 ICV_61 $T=1024480 466160 1 0 $X=1024050 $Y=461605
X2299 1 2 38 1908 1905 ICV_61 $T=1060880 599440 0 0 $X=1060450 $Y=599050
X2300 1 2 42 1972 322 ICV_61 $T=1104000 607280 0 0 $X=1103570 $Y=606890
X2301 1 2 38 1990 1993 ICV_61 $T=1115200 591600 0 0 $X=1114770 $Y=591210
X2302 1 2 37 2013 2003 ICV_61 $T=1120800 474000 1 0 $X=1120370 $Y=469445
X2303 1 2 2012 2033 2030 ICV_61 $T=1125280 450480 0 0 $X=1124850 $Y=450090
X2304 1 2 38 2034 2023 ICV_61 $T=1128080 521040 0 0 $X=1127650 $Y=520650
X2305 1 2 42 2021 335 ICV_61 $T=1133120 615120 0 0 $X=1132690 $Y=614730
X2306 1 2 2033 2044 2047 ICV_61 $T=1139840 458320 0 0 $X=1139410 $Y=457930
X2307 1 2 2079 2085 2081 ICV_61 $T=1153840 544560 0 0 $X=1153410 $Y=544170
X2308 1 2 2120 2125 2113 ICV_61 $T=1174560 536720 1 0 $X=1174130 $Y=532165
X2309 1 2 37 2123 2124 ICV_61 $T=1175120 528880 1 0 $X=1174690 $Y=524325
X2310 1 2 359 358 366 ICV_61 $T=1212640 615120 0 0 $X=1212210 $Y=614730
X2311 1 2 388 8 387 ICV_62 $T=622400 607280 1 0 $X=621970 $Y=602725
X2312 1 2 37 432 430 ICV_62 $T=671680 489680 1 0 $X=671250 $Y=485125
X2313 1 2 508 515 511 ICV_62 $T=714800 583760 1 0 $X=714370 $Y=579205
X2314 1 2 38 514 536 ICV_62 $T=724320 513200 1 0 $X=723890 $Y=508645
X2315 1 2 549 559 558 ICV_62 $T=741120 560240 0 0 $X=740690 $Y=559850
X2316 1 2 76 625 619 ICV_62 $T=806080 434800 0 0 $X=805650 $Y=434410
X2317 1 2 634 82 656 ICV_62 $T=812240 458320 1 0 $X=811810 $Y=453765
X2318 1 2 635 757 750 ICV_62 $T=826240 513200 0 0 $X=825810 $Y=512810
X2319 1 2 724 658 751 ICV_62 $T=826240 528880 0 0 $X=825810 $Y=528490
X2320 1 2 650 766 723 ICV_62 $T=827920 489680 1 0 $X=827490 $Y=485125
X2321 1 2 99 731 769 ICV_62 $T=829600 474000 0 0 $X=829170 $Y=473610
X2322 1 2 659 784 782 ICV_62 $T=830720 521040 1 0 $X=830290 $Y=516485
X2323 1 2 734 756 797 ICV_62 $T=832960 568080 1 0 $X=832530 $Y=563525
X2324 1 2 663 687 905 ICV_62 $T=849200 481840 1 0 $X=848770 $Y=477285
X2325 1 2 934 668 845 ICV_62 $T=852000 474000 0 0 $X=851570 $Y=473610
X2326 1 2 106 956 923 ICV_62 $T=854240 528880 0 0 $X=853810 $Y=528490
X2327 1 2 107 797 954 ICV_62 $T=854800 552400 1 0 $X=854370 $Y=547845
X2328 1 2 635 146 985 ICV_62 $T=858160 481840 0 0 $X=857730 $Y=481450
X2329 1 2 662 962 784 ICV_62 $T=858720 513200 0 0 $X=858290 $Y=512810
X2330 1 2 667 982 993 ICV_62 $T=859840 450480 1 0 $X=859410 $Y=445925
X2331 1 2 106 751 1035 ICV_62 $T=864880 568080 1 0 $X=864450 $Y=563525
X2332 1 2 1037 159 1000 ICV_62 $T=865440 591600 1 0 $X=865010 $Y=587045
X2333 1 2 1063 93 885 ICV_62 $T=869360 568080 1 0 $X=868930 $Y=563525
X2334 1 2 1037 148 1077 ICV_62 $T=869920 591600 1 0 $X=869490 $Y=587045
X2335 1 2 1089 93 1047 ICV_62 $T=872720 568080 0 0 $X=872290 $Y=567690
X2336 1 2 934 1081 1099 ICV_62 $T=873280 497520 1 0 $X=872850 $Y=492965
X2337 1 2 719 1075 1125 ICV_62 $T=882240 442640 1 0 $X=881810 $Y=438085
X2338 1 2 80 1075 1222 ICV_62 $T=892320 458320 0 0 $X=891890 $Y=457930
X2339 1 2 1221 1224 1190 ICV_62 $T=892880 458320 1 0 $X=892450 $Y=453765
X2340 1 2 1229 1234 1219 ICV_62 $T=896240 442640 1 0 $X=895810 $Y=438085
X2341 1 2 1249 180 1275 ICV_62 $T=927600 442640 0 0 $X=927170 $Y=442250
X2342 1 2 1290 1311 1307 ICV_62 $T=932080 528880 1 0 $X=931650 $Y=524325
X2343 1 2 1209 1347 1319 ICV_62 $T=937680 521040 1 0 $X=937250 $Y=516485
X2344 1 2 833 1370 1367 ICV_62 $T=940480 458320 0 0 $X=940050 $Y=457930
X2345 1 2 1088 1377 1355 ICV_62 $T=941040 497520 1 0 $X=940610 $Y=492965
X2346 1 2 107 1446 1401 ICV_62 $T=949440 474000 1 0 $X=949010 $Y=469445
X2347 1 2 662 587 1469 ICV_62 $T=952800 568080 1 0 $X=952370 $Y=563525
X2348 1 2 1088 1482 1463 ICV_62 $T=954480 466160 1 0 $X=954050 $Y=461605
X2349 1 2 1475 1474 236 ICV_62 $T=956160 544560 0 0 $X=955730 $Y=544170
X2350 1 2 114 1467 1449 ICV_62 $T=957280 489680 1 0 $X=956850 $Y=485125
X2351 1 2 662 1440 1496 ICV_62 $T=957840 575920 1 0 $X=957410 $Y=571365
X2352 1 2 174 239 1476 ICV_62 $T=958960 434800 1 0 $X=958530 $Y=430245
X2353 1 2 1461 1523 1378 ICV_62 $T=961760 513200 0 0 $X=961330 $Y=512810
X2354 1 2 1542 80 1568 ICV_62 $T=969600 583760 1 0 $X=969170 $Y=579205
X2355 1 2 1038 1316 1595 ICV_62 $T=972960 497520 0 0 $X=972530 $Y=497130
X2356 1 2 1523 1603 1600 ICV_62 $T=973520 474000 0 0 $X=973090 $Y=473610
X2357 1 2 1555 1484 1611 ICV_62 $T=975200 560240 1 0 $X=974770 $Y=555685
X2358 1 2 1275 1625 1614 ICV_62 $T=975760 450480 0 0 $X=975330 $Y=450090
X2359 1 2 667 1578 1587 ICV_62 $T=975760 481840 0 0 $X=975330 $Y=481450
X2360 1 2 1644 1562 263 ICV_62 $T=983600 521040 0 0 $X=983170 $Y=520650
X2361 1 2 1656 80 1688 ICV_62 $T=984720 575920 0 0 $X=984290 $Y=575530
X2362 1 2 707 1505 1744 ICV_62 $T=994240 560240 1 0 $X=993810 $Y=555685
X2363 1 2 1710 1720 1727 ICV_62 $T=994800 481840 0 0 $X=994370 $Y=481450
X2364 1 2 1818 1858 1610 ICV_62 $T=1011600 442640 0 0 $X=1011170 $Y=442250
X2365 1 2 1786 111 1813 ICV_62 $T=1011600 513200 0 0 $X=1011170 $Y=512810
X2366 1 2 114 1867 1858 ICV_62 $T=1013280 466160 1 0 $X=1012850 $Y=461605
X2367 1 2 662 1880 1740 ICV_62 $T=1019440 474000 0 0 $X=1019010 $Y=473610
X2368 1 2 635 1881 1763 ICV_62 $T=1020000 489680 1 0 $X=1019570 $Y=485125
X2369 1 2 635 1882 1729 ICV_62 $T=1020000 497520 0 0 $X=1019570 $Y=497130
X2370 1 2 662 1883 1681 ICV_62 $T=1022240 505360 1 0 $X=1021810 $Y=500805
X2371 1 2 635 1885 1769 ICV_62 $T=1025040 474000 1 0 $X=1024610 $Y=469445
X2372 1 2 37 1955 1947 ICV_62 $T=1084400 583760 1 0 $X=1083970 $Y=579205
X2373 1 2 323 1989 1988 ICV_62 $T=1106800 575920 0 0 $X=1106370 $Y=575530
X2374 1 2 2114 2116 345 ICV_62 $T=1169520 615120 0 0 $X=1169090 $Y=614730
X2375 1 2 2109 2117 2125 ICV_62 $T=1174560 544560 1 0 $X=1174130 $Y=540005
X2376 1 2 8 10 9 ICV_87 $T=623520 615120 0 0 $X=623090 $Y=614730
X2377 1 2 38 424 429 ICV_87 $T=675040 544560 1 0 $X=674610 $Y=540005
X2378 1 2 37 472 461 ICV_87 $T=694080 536720 0 0 $X=693650 $Y=536330
X2379 1 2 42 487 51 ICV_87 $T=708640 615120 1 0 $X=708210 $Y=610565
X2380 1 2 42 523 53 ICV_87 $T=719280 607280 0 0 $X=718850 $Y=606890
X2381 1 2 37 70 590 ICV_87 $T=784240 607280 0 0 $X=783810 $Y=606890
X2382 1 2 620 623 569 ICV_87 $T=802720 466160 1 0 $X=802290 $Y=461605
X2383 1 2 719 720 748 ICV_87 $T=825680 560240 1 0 $X=825250 $Y=555685
X2384 1 2 635 108 732 ICV_87 $T=828480 575920 1 0 $X=828050 $Y=571365
X2385 1 2 107 109 726 ICV_87 $T=829600 434800 1 0 $X=829170 $Y=430245
X2386 1 2 776 111 780 ICV_87 $T=831280 528880 1 0 $X=830850 $Y=524325
X2387 1 2 662 108 756 ICV_87 $T=836880 568080 0 0 $X=836450 $Y=567690
X2388 1 2 802 93 824 ICV_87 $T=837440 536720 1 0 $X=837010 $Y=532165
X2389 1 2 809 130 945 ICV_87 $T=853680 474000 1 0 $X=853250 $Y=469445
X2390 1 2 966 977 150 ICV_87 $T=857040 583760 0 0 $X=856610 $Y=583370
X2391 1 2 997 159 946 ICV_87 $T=860960 544560 1 0 $X=860530 $Y=540005
X2392 1 2 986 715 161 ICV_87 $T=862080 521040 1 0 $X=861650 $Y=516485
X2393 1 2 1039 159 1074 ICV_87 $T=870480 583760 0 0 $X=870050 $Y=583370
X2394 1 2 1190 1204 1042 ICV_87 $T=887840 450480 0 0 $X=887410 $Y=450090
X2395 1 2 1220 1236 1230 ICV_87 $T=897360 497520 0 0 $X=896930 $Y=497130
X2396 1 2 1257 1282 211 ICV_87 $T=927600 568080 1 0 $X=927170 $Y=563525
X2397 1 2 1273 209 1279 ICV_87 $T=928160 528880 1 0 $X=927730 $Y=524325
X2398 1 2 1274 1300 1301 ICV_87 $T=932080 552400 1 0 $X=931650 $Y=547845
X2399 1 2 1194 587 1297 ICV_87 $T=934320 583760 0 0 $X=933890 $Y=583370
X2400 1 2 1462 1475 1418 ICV_87 $T=953920 536720 0 0 $X=953490 $Y=536330
X2401 1 2 114 1427 1472 ICV_87 $T=955600 497520 0 0 $X=955170 $Y=497130
X2402 1 2 1452 1510 1337 ICV_87 $T=960080 505360 0 0 $X=959650 $Y=504970
X2403 1 2 1167 1543 1536 ICV_87 $T=965680 481840 0 0 $X=965250 $Y=481450
X2404 1 2 1365 1275 1579 ICV_87 $T=971840 450480 0 0 $X=971410 $Y=450090
X2405 1 2 172 1621 1592 ICV_87 $T=975760 505360 0 0 $X=975330 $Y=504970
X2406 1 2 667 1466 1657 ICV_87 $T=981360 544560 1 0 $X=980930 $Y=540005
X2407 1 2 1637 1666 1667 ICV_87 $T=982480 505360 1 0 $X=982050 $Y=500805
X2408 1 2 258 1627 1482 ICV_87 $T=983040 481840 1 0 $X=982610 $Y=477285
X2409 1 2 1764 81 1749 ICV_87 $T=998720 591600 1 0 $X=998290 $Y=587045
X2410 1 2 1750 107 1797 ICV_87 $T=1003200 497520 0 0 $X=1002770 $Y=497130
X2411 1 2 833 1312 1812 ICV_87 $T=1005440 481840 0 0 $X=1005010 $Y=481450
X2412 1 2 107 1770 1806 ICV_87 $T=1007680 521040 1 0 $X=1007250 $Y=516485
X2413 1 392 393 388 2 395 14 390 ICV_111 $T=628560 607280 1 0 $X=628130 $Y=602725
X2414 1 428 433 431 2 38 422 433 ICV_111 $T=673360 560240 1 0 $X=672930 $Y=555685
X2415 1 434 442 438 2 38 440 442 ICV_111 $T=675600 513200 1 0 $X=675170 $Y=508645
X2416 1 38 526 515 2 37 488 508 ICV_111 $T=721520 583760 0 0 $X=721090 $Y=583370
X2417 1 38 527 540 2 541 540 542 ICV_111 $T=730480 513200 1 0 $X=730050 $Y=508645
X2418 1 667 705 697 2 707 698 721 ICV_111 $T=820640 544560 0 0 $X=820210 $Y=544170
X2419 1 645 766 741 2 99 770 786 ICV_111 $T=830720 481840 0 0 $X=830290 $Y=481450
X2420 1 113 111 790 2 117 111 807 ICV_111 $T=833520 434800 1 0 $X=833090 $Y=430245
X2421 1 114 770 743 2 114 698 119 ICV_111 $T=834640 442640 0 0 $X=834210 $Y=442250
X2422 1 99 822 831 2 114 822 855 ICV_111 $T=839120 481840 0 0 $X=838690 $Y=481450
X2423 1 114 850 857 2 99 850 884 ICV_111 $T=841920 466160 1 0 $X=841490 $Y=461605
X2424 1 708 766 899 2 773 647 919 ICV_111 $T=848080 489680 0 0 $X=847650 $Y=489290
X2425 1 99 918 839 2 934 663 109 ICV_111 $T=850880 466160 0 0 $X=850450 $Y=465770
X2426 1 931 111 924 2 106 907 942 ICV_111 $T=854240 560240 1 0 $X=853810 $Y=555685
X2427 1 662 961 990 2 164 845 971 ICV_111 $T=860400 505360 1 0 $X=859970 $Y=500805
X2428 1 645 935 982 2 696 845 1020 ICV_111 $T=862080 489680 1 0 $X=861650 $Y=485125
X2429 1 1007 148 1109 2 1129 148 1009 ICV_111 $T=876080 583760 0 0 $X=875650 $Y=583370
X2430 1 696 1012 1122 2 1140 1122 1145 ICV_111 $T=878320 474000 0 0 $X=877890 $Y=473610
X2431 1 764 185 1183 2 83 185 188 ICV_111 $T=887280 434800 0 0 $X=886850 $Y=434410
X2432 1 1193 614 1248 2 1253 111 1255 ICV_111 $T=922000 568080 1 0 $X=921570 $Y=563525
X2433 1 1193 1293 1309 2 1333 1309 1331 ICV_111 $T=934320 568080 1 0 $X=933890 $Y=563525
X2434 1 221 98 1366 2 1410 130 1407 ICV_111 $T=944400 568080 1 0 $X=943970 $Y=563525
X2435 1 1193 1454 1444 2 662 1021 1474 ICV_111 $T=952240 575920 1 0 $X=951810 $Y=571365
X2436 1 1461 1483 1292 2 1497 1461 238 ICV_111 $T=956160 521040 0 0 $X=955730 $Y=520650
X2437 1 1425 1500 1467 2 662 1499 1510 ICV_111 $T=962880 528880 0 0 $X=962450 $Y=528490
X2438 1 662 1357 1555 2 707 1566 1573 ICV_111 $T=969600 560240 1 0 $X=969170 $Y=555685
X2439 1 1605 1628 1616 2 707 1611 1638 ICV_111 $T=977440 552400 0 0 $X=977010 $Y=552010
X2440 1 1710 258 1621 2 106 1337 1752 ICV_111 $T=994240 505360 1 0 $X=993810 $Y=500805
X2441 1 1773 111 1846 2 1795 111 1857 ICV_111 $T=1011040 536720 0 0 $X=1010610 $Y=536330
X2623 1 2 399 23 405 ICV_69 $T=640320 607280 1 0 $X=639890 $Y=602725
X2624 1 2 411 408 418 ICV_69 $T=656000 607280 0 0 $X=655570 $Y=606890
X2625 1 2 430 443 439 ICV_69 $T=676160 489680 1 0 $X=675730 $Y=485125
X2626 1 2 38 448 443 ICV_69 $T=681200 489680 1 0 $X=680770 $Y=485125
X2627 1 2 38 456 454 ICV_69 $T=686240 489680 1 0 $X=685810 $Y=485125
X2628 1 2 516 519 517 ICV_69 $T=718720 489680 1 0 $X=718290 $Y=485125
X2629 1 2 528 532 534 ICV_69 $T=726000 536720 0 0 $X=725570 $Y=536330
X2630 1 2 548 553 552 ICV_69 $T=740560 544560 0 0 $X=740130 $Y=544170
X2631 1 2 591 621 74 ICV_69 $T=803280 615120 1 0 $X=802850 $Y=610565
X2632 1 2 635 602 647 ICV_69 $T=812240 497520 1 0 $X=811810 $Y=492965
X2633 1 2 635 617 659 ICV_69 $T=813920 513200 0 0 $X=813490 $Y=512810
X2634 1 2 85 681 87 ICV_69 $T=817840 442640 1 0 $X=817410 $Y=438085
X2635 1 2 707 717 644 ICV_69 $T=822320 474000 1 0 $X=821890 $Y=469445
X2636 1 2 719 689 727 ICV_69 $T=828480 450480 1 0 $X=828050 $Y=445925
X2637 1 2 636 818 116 ICV_69 $T=836880 497520 0 0 $X=836450 $Y=497130
X2638 1 2 114 723 813 ICV_69 $T=836880 521040 1 0 $X=836450 $Y=516485
X2639 1 2 830 80 826 ICV_69 $T=839680 575920 0 0 $X=839250 $Y=575530
X2640 1 2 99 893 880 ICV_69 $T=845840 450480 1 0 $X=845410 $Y=445925
X2641 1 2 114 900 124 ICV_69 $T=847520 481840 0 0 $X=847090 $Y=481450
X2642 1 2 107 907 735 ICV_69 $T=848080 544560 1 0 $X=847650 $Y=540005
X2643 1 2 99 932 898 ICV_69 $T=852000 528880 1 0 $X=851570 $Y=524325
X2644 1 2 696 749 948 ICV_69 $T=854800 450480 0 0 $X=854370 $Y=450090
X2645 1 2 106 1012 969 ICV_69 $T=863200 450480 0 0 $X=862770 $Y=450090
X2646 1 2 985 664 1026 ICV_69 $T=865440 497520 0 0 $X=865010 $Y=497130
X2647 1 2 661 990 1030 ICV_69 $T=866000 505360 1 0 $X=865570 $Y=500805
X2648 1 2 958 690 1015 ICV_69 $T=866560 489680 0 0 $X=866130 $Y=489290
X2649 1 2 997 148 1056 ICV_69 $T=868800 528880 0 0 $X=868370 $Y=528490
X2650 1 2 667 1032 1090 ICV_69 $T=873280 474000 0 0 $X=872850 $Y=473610
X2651 1 2 1143 1133 1095 ICV_69 $T=881680 513200 0 0 $X=881250 $Y=512810
X2652 1 2 1038 128 1178 ICV_69 $T=886720 513200 0 0 $X=886290 $Y=512810
X2653 1 2 181 186 1182 ICV_69 $T=887280 607280 0 0 $X=886850 $Y=606890
X2654 1 2 858 180 1198 ICV_69 $T=888400 505360 1 0 $X=887970 $Y=500805
X2655 1 2 1195 196 1237 ICV_69 $T=899040 615120 1 0 $X=898610 $Y=610565
X2656 1 2 1130 198 1239 ICV_69 $T=904080 615120 1 0 $X=903650 $Y=610565
X2657 1 2 82 1286 1281 ICV_69 $T=929280 536720 0 0 $X=928850 $Y=536330
X2658 1 2 1193 1021 1322 ICV_69 $T=936000 591600 1 0 $X=935570 $Y=587045
X2659 1 2 1218 1335 1329 ICV_69 $T=937120 474000 1 0 $X=936690 $Y=469445
X2660 1 2 174 1371 1311 ICV_69 $T=942160 521040 0 0 $X=941730 $Y=520650
X2661 1 2 1358 159 1380 ICV_69 $T=943280 591600 0 0 $X=942850 $Y=591210
X2662 1 2 172 1414 1404 ICV_69 $T=947200 450480 1 0 $X=946770 $Y=445925
X2663 1 2 844 1361 1436 ICV_69 $T=955040 458320 0 0 $X=954610 $Y=457930
X2664 1 2 1193 1491 1478 ICV_69 $T=957280 583760 1 0 $X=956850 $Y=579205
X2665 1 2 1425 1469 1438 ICV_69 $T=958960 568080 1 0 $X=958530 $Y=563525
X2666 1 2 1160 1518 1492 ICV_69 $T=962320 497520 1 0 $X=961890 $Y=492965
X2667 1 2 635 1498 1530 ICV_69 $T=967360 552400 1 0 $X=966930 $Y=547845
X2668 1 2 1509 1552 1549 ICV_69 $T=967920 544560 0 0 $X=967490 $Y=544170
X2669 1 2 719 1286 1581 ICV_69 $T=972960 568080 0 0 $X=972530 $Y=567690
X2670 1 2 719 1525 1598 ICV_69 $T=975200 568080 1 0 $X=974770 $Y=563525
X2671 1 2 667 1505 1620 ICV_69 $T=977440 497520 0 0 $X=977010 $Y=497130
X2672 1 2 719 1652 1569 ICV_69 $T=981920 481840 0 0 $X=981490 $Y=481450
X2673 1 2 1038 1549 1653 ICV_69 $T=981920 552400 1 0 $X=981490 $Y=547845
X2674 1 2 707 1578 1677 ICV_69 $T=985840 474000 1 0 $X=985410 $Y=469445
X2675 1 2 1670 1690 1578 ICV_69 $T=986960 481840 0 0 $X=986530 $Y=481450
X2676 1 2 1698 1710 1370 ICV_69 $T=989200 489680 1 0 $X=988770 $Y=485125
X2677 1 2 1695 1700 1641 ICV_69 $T=990880 474000 1 0 $X=990450 $Y=469445
X2678 1 2 1699 93 1721 ICV_69 $T=992000 552400 1 0 $X=991570 $Y=547845
X2679 1 2 1719 82 1714 ICV_69 $T=993120 575920 1 0 $X=992690 $Y=571365
X2680 1 2 107 1317 1825 ICV_69 $T=1009360 505360 0 0 $X=1008930 $Y=504970
X2681 1 2 107 1318 1832 ICV_69 $T=1009920 474000 1 0 $X=1009490 $Y=469445
X2682 1 2 1776 93 1863 ICV_69 $T=1014960 497520 0 0 $X=1014530 $Y=497130
X2683 1 2 99 1611 1865 ICV_69 $T=1017760 513200 1 0 $X=1017330 $Y=508645
X2684 1 2 1985 2023 2018 ICV_69 $T=1123040 521040 0 0 $X=1122610 $Y=520650
X2685 1 2 2017 2025 2022 ICV_69 $T=1123600 575920 1 0 $X=1123170 $Y=571365
X2686 1 2 389 408 407 ICV_110 $T=640880 591600 0 0 $X=640450 $Y=591210
X2687 1 2 437 444 441 ICV_110 $T=676160 497520 0 0 $X=675730 $Y=497130
X2688 1 2 506 509 507 ICV_110 $T=715360 560240 1 0 $X=714930 $Y=555685
X2689 1 2 635 577 650 ICV_110 $T=812800 481840 0 0 $X=812370 $Y=481450
X2690 1 2 633 82 660 ICV_110 $T=814480 458320 0 0 $X=814050 $Y=457930
X2691 1 2 696 716 643 ICV_110 $T=822320 450480 0 0 $X=821890 $Y=450090
X2692 1 2 694 670 725 ICV_110 $T=824000 497520 0 0 $X=823570 $Y=497130
X2693 1 2 719 749 652 ICV_110 $T=826800 466160 1 0 $X=826370 $Y=461605
X2694 1 2 707 103 760 ICV_110 $T=828480 552400 1 0 $X=828050 $Y=547845
X2695 1 2 732 832 120 ICV_110 $T=838560 489680 0 0 $X=838130 $Y=489290
X2696 1 2 114 838 703 ICV_110 $T=839120 521040 0 0 $X=838690 $Y=520650
X2697 1 2 707 771 840 ICV_110 $T=841920 450480 1 0 $X=841490 $Y=445925
X2698 1 2 920 130 943 ICV_110 $T=855920 575920 0 0 $X=855490 $Y=575530
X2699 1 2 106 1030 1044 ICV_110 $T=869920 552400 0 0 $X=869490 $Y=552010
X2700 1 2 707 918 1068 ICV_110 $T=871600 450480 1 0 $X=871170 $Y=445925
X2701 1 2 719 936 1083 ICV_110 $T=873840 552400 0 0 $X=873410 $Y=552010
X2702 1 2 782 1061 171 ICV_110 $T=875520 450480 1 0 $X=875090 $Y=445925
X2703 1 2 116 1124 1111 ICV_110 $T=877760 497520 1 0 $X=877330 $Y=492965
X2704 1 2 1130 181 179 ICV_110 $T=883360 615120 0 0 $X=882930 $Y=614730
X2705 1 2 80 1012 1221 ICV_110 $T=894560 450480 1 0 $X=894130 $Y=445925
X2706 1 2 1223 193 1206 ICV_110 $T=894560 489680 0 0 $X=894130 $Y=489290
X2707 1 2 1266 580 1298 ICV_110 $T=932640 575920 0 0 $X=932210 $Y=575530
X2708 1 2 107 1378 1368 ICV_110 $T=942720 544560 1 0 $X=942290 $Y=540005
X2709 1 2 107 226 1437 ICV_110 $T=950560 474000 0 0 $X=950130 $Y=473610
X2710 1 2 1061 1466 1465 ICV_110 $T=953360 450480 0 0 $X=952930 $Y=450090
X2711 1 2 1426 80 1443 ICV_110 $T=953360 583760 1 0 $X=952930 $Y=579205
X2712 1 2 99 1445 1473 ICV_110 $T=955040 513200 0 0 $X=954610 $Y=512810
X2713 1 2 1486 1462 226 ICV_110 $T=957840 536720 1 0 $X=957410 $Y=532165
X2714 1 2 1266 1491 1517 ICV_110 $T=962320 575920 1 0 $X=961890 $Y=571365
X2715 1 2 1510 1516 1377 ICV_110 $T=962880 528880 1 0 $X=962450 $Y=524325
X2716 1 2 1503 1382 1521 ICV_110 $T=963440 489680 1 0 $X=963010 $Y=485125
X2717 1 2 1516 1524 223 ICV_110 $T=963440 521040 0 0 $X=963010 $Y=520650
X2718 1 2 635 1538 1486 ICV_110 $T=966240 536720 1 0 $X=965810 $Y=532165
X2719 1 2 635 1506 1483 ICV_110 $T=966800 528880 1 0 $X=966370 $Y=524325
X2720 1 2 1160 1482 1548 ICV_110 $T=967360 489680 1 0 $X=966930 $Y=485125
X2721 1 2 1487 148 1583 ICV_110 $T=972960 583760 0 0 $X=972530 $Y=583370
X2722 1 2 662 1498 1591 ICV_110 $T=975200 552400 1 0 $X=974770 $Y=547845
X2723 1 2 1602 1613 1607 ICV_110 $T=976320 521040 0 0 $X=975890 $Y=520650
X2724 1 2 719 1543 1639 ICV_110 $T=979680 560240 0 0 $X=979250 $Y=559850
X2725 1 2 1645 1531 1687 ICV_110 $T=988080 544560 1 0 $X=987650 $Y=540005
X2726 1 2 1763 1758 277 ICV_110 $T=999840 489680 0 0 $X=999410 $Y=489290
X2727 1 2 707 1650 1774 ICV_110 $T=1000400 544560 1 0 $X=999970 $Y=540005
X2728 1 2 1704 93 1783 ICV_110 $T=1002640 536720 1 0 $X=1002210 $Y=532165
X2729 1 2 1779 1814 1811 ICV_110 $T=1006560 521040 0 0 $X=1006130 $Y=520650
X2730 1 2 1788 93 1837 ICV_110 $T=1011040 458320 1 0 $X=1010610 $Y=453765
X2731 1 2 1892 1893 291 ICV_110 $T=1040160 434800 1 0 $X=1039730 $Y=430245
X2732 1 2 42 2052 338 ICV_110 $T=1144880 615120 0 0 $X=1144450 $Y=614730
X2733 1 2 2060 2067 2062 ICV_110 $T=1148800 513200 1 0 $X=1148370 $Y=508645
X2734 1 10 22 403 2 ICV_93 $T=641440 615120 1 0 $X=641010 $Y=610565
X2735 1 42 451 40 2 ICV_93 $T=681760 607280 0 0 $X=681330 $Y=606890
X2736 1 38 472 494 2 ICV_93 $T=708080 536720 1 0 $X=707650 $Y=532165
X2737 1 38 529 509 2 ICV_93 $T=721520 560240 0 0 $X=721090 $Y=559850
X2738 1 635 595 638 2 ICV_93 $T=806640 505360 1 0 $X=806210 $Y=500805
X2739 1 662 595 657 2 ICV_93 $T=810560 513200 1 0 $X=810130 $Y=508645
X2740 1 684 673 512 2 ICV_93 $T=815040 536720 0 0 $X=814610 $Y=536330
X2741 1 882 80 879 2 ICV_93 $T=841360 575920 1 0 $X=840930 $Y=571365
X2742 1 635 140 708 2 ICV_93 $T=848640 497520 1 0 $X=848210 $Y=492965
X2743 1 82 1075 1229 2 ICV_93 $T=894560 434800 1 0 $X=894130 $Y=430245
X2744 1 216 190 215 2 ICV_93 $T=934320 434800 1 0 $X=933890 $Y=430245
X2745 1 1492 1382 1460 2 ICV_93 $T=954480 497520 1 0 $X=954050 $Y=492965
X2746 1 662 1359 1544 2 ICV_93 $T=964000 505360 0 0 $X=963570 $Y=504970
X2747 1 707 1482 1678 2 ICV_93 $T=982480 489680 0 0 $X=982050 $Y=489290
X2748 1 662 1238 1710 2 ICV_93 $T=986400 505360 1 0 $X=985970 $Y=500805
X2749 1 106 1346 1731 2 ICV_93 $T=989760 458320 1 0 $X=989330 $Y=453765
X2750 1 42 1978 326 2 ICV_93 $T=1109600 615120 0 0 $X=1109170 $Y=614730
X2751 1 2038 2024 2036 2 ICV_93 $T=1125280 489680 0 0 $X=1124850 $Y=489290
X2752 1 38 2075 2119 2 ICV_93 $T=1170640 591600 0 0 $X=1170210 $Y=591210
X2753 1 2134 2119 2132 2 ICV_93 $T=1176800 591600 0 0 $X=1176370 $Y=591210
X2754 1 2 408 414 31 ICV_104 $T=650400 591600 0 0 $X=649970 $Y=591210
X2755 1 2 635 603 658 ICV_104 $T=811680 528880 0 0 $X=811250 $Y=528490
X2756 1 2 635 631 734 ICV_104 $T=822880 568080 0 0 $X=822450 $Y=567690
X2757 1 2 99 723 90 ICV_104 $T=825680 481840 0 0 $X=825250 $Y=481450
X2758 1 2 99 1064 1107 ICV_104 $T=873840 536720 0 0 $X=873410 $Y=536330
X2759 1 2 204 196 1244 ICV_104 $T=913040 615120 1 0 $X=912610 $Y=610565
X2760 1 2 1321 640 1256 ICV_104 $T=933200 568080 0 0 $X=932770 $Y=567690
X2761 1 2 1369 1356 219 ICV_104 $T=939920 552400 0 0 $X=939490 $Y=552010
X2762 1 2 1460 1435 1417 ICV_104 $T=950560 497520 0 0 $X=950130 $Y=497130
X2763 1 2 662 1242 1462 ICV_104 $T=951120 544560 0 0 $X=950690 $Y=544170
X2764 1 2 1275 1526 1553 ICV_104 $T=970720 450480 1 0 $X=970290 $Y=445925
X2765 1 2 1581 1574 1585 ICV_104 $T=970720 575920 0 0 $X=970290 $Y=575530
X2766 1 2 635 1640 1644 ICV_104 $T=991440 521040 0 0 $X=991010 $Y=520650
X2767 1 2 106 1446 1807 ICV_104 $T=1003760 450480 0 0 $X=1003330 $Y=450090
X2768 1 2 106 1641 1818 ICV_104 $T=1006000 450480 1 0 $X=1005570 $Y=445925
X2769 1 2 1879 1877 1884 ICV_104 $T=1021120 607280 0 0 $X=1020690 $Y=606890
X2770 1 2 38 1992 1989 ICV_104 $T=1109040 568080 0 0 $X=1108610 $Y=567690
X2771 1 2 2014 2031 2032 ICV_104 $T=1124160 474000 1 0 $X=1123730 $Y=469445
X2772 1 2 2103 2117 2141 ICV_104 $T=1180160 583760 1 0 $X=1179730 $Y=579205
X2773 1 2 2137 2128 2153 ICV_104 $T=1189120 544560 0 0 $X=1188690 $Y=544170
X2774 1 2 2153 2144 2154 ICV_104 $T=1190240 552400 1 0 $X=1189810 $Y=547845
X2842 1 2 420 18 419 ICV_91 $T=656000 615120 1 0 $X=655570 $Y=610565
X2843 1 2 497 494 495 ICV_91 $T=708640 544560 0 0 $X=708210 $Y=544170
X2844 1 2 38 488 492 ICV_91 $T=710320 583760 1 0 $X=709890 $Y=579205
X2845 1 2 538 536 537 ICV_91 $T=724880 521040 1 0 $X=724450 $Y=516485
X2846 1 2 37 521 541 ICV_91 $T=731040 536720 0 0 $X=730610 $Y=536330
X2847 1 2 38 521 547 ICV_91 $T=736640 560240 0 0 $X=736210 $Y=559850
X2848 1 2 662 607 663 ICV_91 $T=812800 474000 1 0 $X=812370 $Y=469445
X2849 1 2 683 81 673 ICV_91 $T=816720 536720 1 0 $X=816290 $Y=532165
X2850 1 2 659 666 720 ICV_91 $T=821760 513200 0 0 $X=821330 $Y=512810
X2851 1 2 718 695 96 ICV_91 $T=823440 505360 0 0 $X=823010 $Y=504970
X2852 1 2 106 758 744 ICV_91 $T=827360 536720 1 0 $X=826930 $Y=532165
X2853 1 2 636 714 758 ICV_91 $T=830720 497520 0 0 $X=830290 $Y=497130
X2854 1 2 806 668 783 ICV_91 $T=834080 474000 0 0 $X=833650 $Y=473610
X2855 1 2 802 111 811 ICV_91 $T=835200 528880 1 0 $X=834770 $Y=524325
X2856 1 2 828 664 822 ICV_91 $T=836880 497520 1 0 $X=836450 $Y=492965
X2857 1 2 830 82 796 ICV_91 $T=837440 568080 1 0 $X=837010 $Y=563525
X2858 1 2 812 93 834 ICV_91 $T=838000 544560 1 0 $X=837570 $Y=540005
X2859 1 2 719 775 854 ICV_91 $T=845280 442640 1 0 $X=844850 $Y=438085
X2860 1 2 958 756 147 ICV_91 $T=854800 497520 1 0 $X=854370 $Y=492965
X2861 1 2 661 953 749 ICV_91 $T=856480 474000 0 0 $X=856050 $Y=473610
X2862 1 2 1006 668 900 ICV_91 $T=860960 474000 0 0 $X=860530 $Y=473610
X2863 1 2 985 990 1012 ICV_91 $T=862640 481840 1 0 $X=862210 $Y=477285
X2864 1 2 1061 960 1060 ICV_91 $T=868240 513200 1 0 $X=867810 $Y=508645
X2865 1 2 667 1064 1067 ICV_91 $T=869360 466160 0 0 $X=868930 $Y=465770
X2866 1 2 1088 893 1084 ICV_91 $T=871040 481840 0 0 $X=870610 $Y=481450
X2867 1 2 107 1026 1166 ICV_91 $T=883360 560240 1 0 $X=882930 $Y=555685
X2868 1 2 1194 108 1188 ICV_91 $T=886160 583760 0 0 $X=885730 $Y=583370
X2869 1 2 1205 1173 1168 ICV_91 $T=887840 458320 0 0 $X=887410 $Y=457930
X2870 1 2 1207 148 1196 ICV_91 $T=887840 513200 1 0 $X=887410 $Y=508645
X2871 1 2 1209 907 1203 ICV_91 $T=888400 552400 1 0 $X=887970 $Y=547845
X2872 1 2 1278 93 1273 ICV_91 $T=927600 521040 0 0 $X=927170 $Y=520650
X2873 1 2 1275 1267 1159 ICV_91 $T=931520 450480 1 0 $X=931090 $Y=445925
X2874 1 2 1342 159 1325 ICV_91 $T=937120 513200 1 0 $X=936690 $Y=508645
X2875 1 2 1346 833 1343 ICV_91 $T=937680 528880 0 0 $X=937250 $Y=528490
X2876 1 2 1313 106 1391 ICV_91 $T=943840 458320 1 0 $X=943410 $Y=453765
X2877 1 2 106 1283 1399 ICV_91 $T=944400 513200 1 0 $X=943970 $Y=508645
X2878 1 2 635 587 1484 ICV_91 $T=955040 560240 0 0 $X=954610 $Y=559850
X2879 1 2 1497 1496 1423 ICV_91 $T=958400 528880 0 0 $X=957970 $Y=528490
X2880 1 2 1493 1469 1505 ICV_91 $T=959520 560240 1 0 $X=959090 $Y=555685
X2881 1 2 635 1440 1516 ICV_91 $T=962880 568080 0 0 $X=962450 $Y=567690
X2882 1 2 1542 82 1539 ICV_91 $T=965120 583760 1 0 $X=964690 $Y=579205
X2883 1 2 235 82 1546 ICV_91 $T=966800 434800 0 0 $X=966370 $Y=434410
X2884 1 2 1545 1524 1566 ICV_91 $T=970160 521040 0 0 $X=969730 $Y=520650
X2885 1 2 258 1603 1361 ICV_91 $T=978000 474000 0 0 $X=977570 $Y=473610
X2886 1 2 1656 82 1649 ICV_91 $T=980240 575920 0 0 $X=979810 $Y=575530
X2887 1 2 1662 1655 1661 ICV_91 $T=981360 536720 1 0 $X=980930 $Y=532165
X2888 1 2 1699 159 1696 ICV_91 $T=986400 560240 0 0 $X=985970 $Y=559850
X2889 1 2 1729 1664 1732 ICV_91 $T=991440 497520 0 0 $X=991010 $Y=497130
X2890 1 2 114 1423 1759 ICV_91 $T=996480 536720 1 0 $X=996050 $Y=532165
X2891 1 2 844 1371 1779 ICV_91 $T=1000400 513200 0 0 $X=999970 $Y=512810
X2892 1 2 107 239 1792 ICV_91 $T=1002080 458320 0 0 $X=1001650 $Y=457930
X2893 1 2 107 1299 1793 ICV_91 $T=1003200 521040 1 0 $X=1002770 $Y=516485
X2894 1 2 164 1312 1820 ICV_91 $T=1007120 489680 0 0 $X=1006690 $Y=489290
X2895 1 2 1785 1812 1838 ICV_91 $T=1009360 481840 1 0 $X=1008930 $Y=477285
X2896 1 2 37 286 1879 ICV_91 $T=1019440 615120 1 0 $X=1019010 $Y=610565
X2897 1 2 1896 1894 1895 ICV_91 $T=1042400 607280 1 0 $X=1041970 $Y=602725
X2898 1 2 1979 1970 1980 ICV_91 $T=1098960 599440 1 0 $X=1098530 $Y=594885
X2899 1 2 38 1981 2024 ICV_91 $T=1122480 489680 1 0 $X=1122050 $Y=485125
X2900 1 2 2009 2026 2039 ICV_91 $T=1127520 544560 1 0 $X=1127090 $Y=540005
X2901 1 2 2071 2044 2065 ICV_91 $T=1148800 466160 0 0 $X=1148370 $Y=465770
X2902 1 2 2131 2108 2138 ICV_91 $T=1180160 536720 1 0 $X=1179730 $Y=532165
X2903 13 22 2 1 417 XOR2X1 $T=671680 615120 1 180 $X=665090 $Y=614730
X2904 512 52 2 1 13 XOR2X1 $T=718720 615120 0 180 $X=712130 $Y=610565
X2905 569 60 2 1 24 XOR2X1 $T=751200 599440 1 180 $X=744610 $Y=599050
X2906 619 73 2 1 75 XOR2X1 $T=802160 615120 0 0 $X=801730 $Y=614730
X2907 992 52 2 1 163 XOR2X1 $T=858720 615120 0 0 $X=858290 $Y=614730
X2908 1101 173 2 1 25 XOR2X1 $T=878880 607280 1 180 $X=872290 $Y=606890
X2909 178 60 2 1 183 XOR2X1 $T=882800 607280 1 0 $X=882370 $Y=602725
X2910 1163 200 2 1 191 XOR2X1 $T=911920 607280 1 180 $X=905330 $Y=606890
X2911 1842 282 2 1 284 XOR2X1 $T=1011600 607280 0 0 $X=1011170 $Y=606890
X2912 1816 173 2 1 327 XOR2X1 $T=1110160 607280 0 0 $X=1109730 $Y=606890
X2913 284 353 2 1 2151 XOR2X1 $T=1186880 615120 1 0 $X=1186450 $Y=610565
X2930 1 2 37 422 425 ICV_59 $T=673360 544560 0 0 $X=672930 $Y=544170
X2931 1 2 461 449 457 ICV_59 $T=686800 536720 1 0 $X=686370 $Y=532165
X2932 1 2 500 498 499 ICV_59 $T=711440 505360 1 0 $X=711010 $Y=500805
X2933 1 2 37 526 528 ICV_59 $T=722080 552400 0 0 $X=721650 $Y=552010
X2934 1 2 635 598 646 ICV_59 $T=811120 489680 1 0 $X=810690 $Y=485125
X2935 1 2 654 80 653 ICV_59 $T=812800 442640 1 0 $X=812370 $Y=438085
X2936 1 2 662 598 666 ICV_59 $T=815600 489680 0 0 $X=815170 $Y=489290
X2937 1 2 662 617 669 ICV_59 $T=816720 513200 1 0 $X=816290 $Y=508645
X2938 1 2 662 631 695 ICV_59 $T=819520 568080 0 0 $X=819090 $Y=567690
X2939 1 2 732 695 728 ICV_59 $T=824000 568080 1 0 $X=823570 $Y=563525
X2940 1 2 659 657 102 ICV_59 $T=827920 505360 0 0 $X=827490 $Y=504970
X2941 1 2 724 750 771 ICV_59 $T=830720 513200 1 0 $X=830290 $Y=508645
X2942 1 2 99 83 795 ICV_59 $T=834080 505360 0 0 $X=833650 $Y=504970
X2943 1 2 106 110 821 ICV_59 $T=837440 450480 0 0 $X=837010 $Y=450090
X2944 1 2 106 797 864 ICV_59 $T=843600 560240 1 0 $X=843170 $Y=555685
X2945 1 2 1007 111 999 ICV_59 $T=862640 560240 0 0 $X=862210 $Y=559850
X2946 1 2 719 1051 1071 ICV_59 $T=870480 442640 0 0 $X=870050 $Y=442250
X2947 1 2 174 1026 1113 ICV_59 $T=876640 521040 1 0 $X=876210 $Y=516485
X2948 1 2 1130 163 176 ICV_59 $T=878320 615120 0 0 $X=877890 $Y=614730
X2949 1 2 1088 1099 1118 ICV_59 $T=879440 497520 0 0 $X=879010 $Y=497130
X2950 1 2 707 1099 1140 ICV_59 $T=880000 481840 0 0 $X=879570 $Y=481450
X2951 1 2 172 1030 1151 ICV_59 $T=882240 513200 1 0 $X=881810 $Y=508645
X2952 1 2 1161 159 1158 ICV_59 $T=882800 544560 1 0 $X=882370 $Y=540005
X2953 1 2 1161 93 1165 ICV_59 $T=883920 544560 0 0 $X=883490 $Y=544170
X2954 1 2 1171 93 1153 ICV_59 $T=883920 568080 0 0 $X=883490 $Y=567690
X2955 1 2 80 128 1211 ICV_59 $T=890640 481840 0 0 $X=890210 $Y=481450
X2956 1 2 1249 190 1224 ICV_59 $T=922000 466160 1 0 $X=921570 $Y=461605
X2957 1 2 1278 80 1272 ICV_59 $T=928160 513200 0 0 $X=927730 $Y=512810
X2958 1 2 1281 1234 1274 ICV_59 $T=928160 544560 0 0 $X=927730 $Y=544170
X2959 1 2 1294 194 1289 ICV_59 $T=930960 481840 0 0 $X=930530 $Y=481450
X2960 1 2 1299 180 1295 ICV_59 $T=931520 505360 1 0 $X=931090 $Y=500805
X2961 1 2 1318 1124 1302 ICV_59 $T=934880 505360 1 0 $X=934450 $Y=500805
X2962 1 2 1331 1202 1327 ICV_59 $T=936000 560240 0 0 $X=935570 $Y=559850
X2963 1 2 1337 190 1324 ICV_59 $T=937120 489680 1 0 $X=936690 $Y=485125
X2964 1 2 1363 159 1351 ICV_59 $T=941040 442640 1 0 $X=940610 $Y=438085
X2965 1 2 174 216 1396 ICV_59 $T=944960 434800 1 0 $X=944530 $Y=430245
X2966 1 2 1088 1445 1451 ICV_59 $T=951680 458320 0 0 $X=951250 $Y=457930
X2967 1 2 231 172 1394 ICV_59 $T=952240 489680 0 0 $X=951810 $Y=489290
X2968 1 2 1471 93 1459 ICV_59 $T=955600 458320 1 0 $X=955170 $Y=453765
X2969 1 2 1509 1469 216 ICV_59 $T=960640 544560 0 0 $X=960210 $Y=544170
X2970 1 2 635 1359 1523 ICV_59 $T=966240 513200 0 0 $X=965810 $Y=512810
X2971 1 2 635 640 1698 ICV_59 $T=988640 489680 0 0 $X=988210 $Y=489290
X2972 1 2 114 1600 1715 ICV_59 $T=990320 434800 1 0 $X=989890 $Y=430245
X2973 1 2 106 1606 1724 ICV_59 $T=992000 528880 0 0 $X=991570 $Y=528490
X2974 1 2 264 154 1739 ICV_59 $T=994240 434800 0 0 $X=993810 $Y=434410
X2975 1 2 99 1381 1746 ICV_59 $T=999280 481840 0 0 $X=998850 $Y=481450
X2976 1 2 1758 1644 1770 ICV_59 $T=999840 521040 1 0 $X=999410 $Y=516485
X2977 1 2 844 1652 1766 ICV_59 $T=999840 528880 1 0 $X=999410 $Y=524325
X2978 1 2 106 236 1815 ICV_59 $T=1007120 434800 1 0 $X=1006690 $Y=430245
X2979 1 2 1776 111 1849 ICV_59 $T=1011600 489680 0 0 $X=1011170 $Y=489290
X2980 1 2 1713 111 1860 ICV_59 $T=1014400 528880 1 0 $X=1013970 $Y=524325
X2981 1 2 38 269 1877 ICV_59 $T=1017760 607280 0 0 $X=1017330 $Y=606890
X2982 1 2 38 304 1942 ICV_59 $T=1077680 599440 0 0 $X=1077250 $Y=599050
X2983 1 2 1947 1942 1946 ICV_59 $T=1081040 583760 1 0 $X=1080610 $Y=579205
X2984 1 2 42 1945 311 ICV_59 $T=1083280 607280 0 0 $X=1082850 $Y=606890
X2985 1 2 38 306 1970 ICV_59 $T=1095600 599440 1 0 $X=1095170 $Y=594885
X2986 1 2 2003 1996 2001 ICV_59 $T=1114640 474000 1 0 $X=1114210 $Y=469445
X2987 1 2 2065 44 2063 ICV_59 $T=1148240 474000 1 0 $X=1147810 $Y=469445
X2988 1 2 2140 2120 2137 ICV_59 $T=1181280 544560 0 0 $X=1180850 $Y=544170
X2989 1 2 37 447 428 ICV_68 $T=676720 544560 0 0 $X=676290 $Y=544170
X2990 1 2 38 533 532 ICV_68 $T=722640 528880 1 0 $X=722210 $Y=524325
X2991 1 2 634 80 637 ICV_68 $T=807200 458320 1 0 $X=806770 $Y=453765
X2992 1 2 709 718 711 ICV_68 $T=820080 513200 1 0 $X=819650 $Y=508645
X2993 1 2 696 741 738 ICV_68 $T=823440 466160 0 0 $X=823010 $Y=465770
X2994 1 2 696 147 933 ICV_68 $T=854800 450480 1 0 $X=854370 $Y=445925
X2995 1 2 911 1082 1076 ICV_68 $T=869360 560240 1 0 $X=868930 $Y=555685
X2996 1 2 986 935 907 ICV_68 $T=886720 528880 0 0 $X=886290 $Y=528490
X2997 1 2 1214 183 1227 ICV_68 $T=894000 607280 0 0 $X=893570 $Y=606890
X2998 1 2 1232 1234 1197 ICV_68 $T=896240 442640 0 0 $X=895810 $Y=442250
X2999 1 2 1358 148 1408 ICV_68 $T=944960 591600 1 0 $X=944530 $Y=587045
X3000 1 2 1061 1427 224 ICV_68 $T=946640 450480 0 0 $X=946210 $Y=450090
X3001 1 2 1321 1440 1490 ICV_68 $T=960640 591600 0 0 $X=960210 $Y=591210
X3002 1 2 1523 1627 254 ICV_68 $T=975200 481840 1 0 $X=974770 $Y=477285
X3003 1 2 172 1606 1601 ICV_68 $T=975200 513200 1 0 $X=974770 $Y=508645
X3004 1 2 719 1378 1671 ICV_68 $T=982480 521040 1 0 $X=982050 $Y=516485
X3005 1 2 1342 148 1726 ICV_68 $T=991440 552400 0 0 $X=991010 $Y=552010
X3006 1 2 719 1803 1794 ICV_68 $T=1002640 560240 1 0 $X=1002210 $Y=555685
X3007 1 2 106 1317 1829 ICV_68 $T=1007120 497520 1 0 $X=1006690 $Y=492965
X3008 1 2 662 1882 1758 ICV_68 $T=1018880 497520 1 0 $X=1018450 $Y=492965
X3009 1 2 1887 1890 1889 ICV_68 $T=1033440 450480 0 0 $X=1033010 $Y=450090
X3010 1 2 1937 305 307 ICV_68 $T=1074320 434800 0 0 $X=1073890 $Y=434410
X3011 1 2 37 1953 1896 ICV_68 $T=1081040 599440 0 0 $X=1080610 $Y=599050
X3012 1 2 1935 2030 2029 ICV_68 $T=1122480 442640 1 0 $X=1122050 $Y=438085
X3013 1 2 2037 2040 2000 ICV_68 $T=1127520 434800 0 0 $X=1127090 $Y=434410
X3014 1 2 2086 2092 2079 ICV_68 $T=1157200 544560 0 0 $X=1156770 $Y=544170
X3015 1 2 2124 2136 2133 ICV_68 $T=1178480 528880 1 0 $X=1178050 $Y=524325
X3016 1 2 448 439 368 485 ICV_60 $T=678400 474000 0 0 $X=677970 $Y=473610
X3017 1 2 456 466 368 485 ICV_60 $T=678400 481840 1 0 $X=677970 $Y=477285
X3018 1 2 432 441 368 485 ICV_60 $T=678400 489680 0 0 $X=677970 $Y=489290
X3019 1 2 440 438 368 485 ICV_60 $T=678400 505360 0 0 $X=677970 $Y=504970
X3020 1 2 445 435 368 485 ICV_60 $T=678400 513200 0 0 $X=677970 $Y=512810
X3021 1 2 447 457 368 474 ICV_60 $T=678400 528880 0 0 $X=677970 $Y=528490
X3022 1 2 460 453 368 474 ICV_60 $T=678400 575920 1 0 $X=677970 $Y=571365
X3023 1 2 451 467 368 474 ICV_60 $T=678400 575920 0 0 $X=677970 $Y=575530
X3024 1 2 446 436 368 474 ICV_60 $T=678400 583760 1 0 $X=677970 $Y=579205
X3025 1 2 50 484 368 562 ICV_60 $T=696320 607280 1 0 $X=695890 $Y=602725
X3026 1 2 531 510 368 485 ICV_60 $T=703040 458320 0 0 $X=702610 $Y=457930
X3027 1 2 520 503 368 485 ICV_60 $T=703040 466160 1 0 $X=702610 $Y=461605
X3028 1 2 514 537 368 563 ICV_60 $T=719280 513200 0 0 $X=718850 $Y=512810
X3029 1 2 577 573 368 571 ICV_60 $T=751200 458320 0 0 $X=750770 $Y=457930
X3030 1 2 599 593 368 571 ICV_60 $T=758480 505360 0 0 $X=758050 $Y=504970
X3031 1 2 616 610 368 71 ICV_60 $T=785920 552400 0 0 $X=785490 $Y=552010
X3032 1 2 1242 1240 368 1623 ICV_60 $T=900720 599440 0 0 $X=900290 $Y=599050
X3033 1 2 2021 2016 368 331 ICV_60 $T=1123040 560240 1 0 $X=1122610 $Y=555685
X3034 1 2 1910 2045 368 331 ICV_60 $T=1124160 583760 1 0 $X=1123730 $Y=579205
X3054 1 2 38 432 444 ICV_92 $T=680080 497520 0 0 $X=679650 $Y=497130
X3055 1 2 42 460 43 ICV_92 $T=689040 615120 0 0 $X=688610 $Y=614730
X3056 1 2 38 502 498 ICV_92 $T=712000 513200 0 0 $X=711570 $Y=512810
X3057 1 2 42 525 54 ICV_92 $T=722640 615120 1 0 $X=722210 $Y=610565
X3058 1 2 37 531 548 ICV_92 $T=738880 536720 0 0 $X=738450 $Y=536330
X3059 1 2 38 79 621 ICV_92 $T=808320 615120 1 0 $X=807890 $Y=610565
X3060 1 2 99 685 849 ICV_92 $T=841360 497520 1 0 $X=840930 $Y=492965
X3061 1 2 844 861 847 ICV_92 $T=841360 513200 0 0 $X=840930 $Y=512810
X3062 1 2 1054 1090 1096 ICV_92 $T=873840 474000 1 0 $X=873410 $Y=469445
X3063 1 2 936 101 1128 ICV_92 $T=879440 575920 1 0 $X=879010 $Y=571365
X3064 1 2 1243 194 1218 ICV_92 $T=919200 474000 1 0 $X=918770 $Y=469445
X3065 1 2 241 106 1599 ICV_92 $T=978560 442640 0 0 $X=978130 $Y=442250
X3066 1 2 1695 1705 1589 ICV_92 $T=988640 474000 0 0 $X=988210 $Y=473610
X3067 1 2 662 1640 1701 ICV_92 $T=992560 528880 1 0 $X=992130 $Y=524325
X3068 1 2 1729 1690 261 ICV_92 $T=1002080 481840 1 0 $X=1001650 $Y=477285
X3069 1 2 833 1803 1810 ICV_92 $T=1006560 536720 1 0 $X=1006130 $Y=532165
X3070 1 2 833 1757 1814 ICV_92 $T=1007120 528880 1 0 $X=1006690 $Y=524325
X3071 1 2 1997 2002 1999 ICV_92 $T=1114640 536720 0 0 $X=1114210 $Y=536330
X3072 1 2 37 1990 2017 ICV_92 $T=1123600 591600 1 0 $X=1123170 $Y=587045
X3115 1 42 475 47 2 ICV_90 $T=693520 615120 1 0 $X=693090 $Y=610565
X3116 1 489 492 490 2 ICV_90 $T=704160 583760 1 0 $X=703730 $Y=579205
X3117 1 37 529 489 2 ICV_90 $T=719280 583760 1 0 $X=718850 $Y=579205
X3118 1 635 586 636 2 ICV_90 $T=806080 497520 1 0 $X=805650 $Y=492965
X3119 1 672 686 678 2 ICV_90 $T=815040 474000 0 0 $X=814610 $Y=473610
X3120 1 719 147 1018 2 ICV_90 $T=861520 434800 0 0 $X=861090 $Y=434410
X3121 1 1061 940 1112 2 ICV_90 $T=873280 497520 0 0 $X=872850 $Y=497130
X3122 1 837 1162 1225 2 ICV_90 $T=892320 505360 0 0 $X=891890 $Y=504970
X3123 1 707 1377 1393 2 ICV_90 $T=947200 466160 0 0 $X=946770 $Y=465770
X3124 1 114 1611 1873 2 ICV_90 $T=1013840 481840 1 0 $X=1013410 $Y=477285
X3125 1 1938 1940 1939 2 ICV_90 $T=1070960 442640 0 0 $X=1070530 $Y=442250
X3126 1 1956 1957 1938 2 ICV_90 $T=1088880 434800 0 0 $X=1088450 $Y=434410
X3127 1 1956 1966 1954 2 ICV_90 $T=1088880 442640 1 0 $X=1088450 $Y=438085
X3128 1 324 1993 1991 2 ICV_90 $T=1106800 599440 0 0 $X=1106370 $Y=599050
X3129 1 2078 2046 2071 2 ICV_90 $T=1151600 474000 1 0 $X=1151170 $Y=469445
X3130 1 37 355 2134 2 ICV_90 $T=1182960 591600 0 0 $X=1182530 $Y=591210
X3178 1 37 456 501 2 37 448 493 ICV_105 $T=712560 474000 1 180 $X=709330 $Y=473610
X3179 1 750 714 100 2 709 694 716 ICV_105 $T=828480 497520 0 180 $X=825250 $Y=492965
X3180 1 107 689 788 2 107 96 765 ICV_105 $T=833520 466160 0 180 $X=830290 $Y=461605
X3181 1 682 93 794 2 99 711 755 ICV_105 $T=834640 450480 1 180 $X=831410 $Y=450090
X3182 1 833 702 805 2 106 783 808 ICV_105 $T=839120 466160 0 180 $X=835890 $Y=461605
X3183 1 888 647 133 2 666 828 125 ICV_105 $T=845280 489680 1 180 $X=842050 $Y=489290
X3184 1 107 135 883 2 844 716 869 ICV_105 $T=847520 458320 1 180 $X=844290 $Y=457930
X3185 1 903 674 918 2 903 875 136 ICV_105 $T=850880 474000 0 180 $X=847650 $Y=469445
X3186 1 114 932 1004 2 114 782 967 ICV_105 $T=862640 536720 0 180 $X=859410 $Y=532165
X3187 1 707 940 1094 2 1061 982 1069 ICV_105 $T=873840 505360 1 180 $X=870610 $Y=504970
X3188 1 1484 1474 1447 2 635 580 1475 ICV_105 $T=957840 552400 1 180 $X=954610 $Y=552010
X3189 1 662 1506 1524 2 662 1293 1562 ICV_105 $T=973520 528880 0 180 $X=970290 $Y=524325
X3190 1 1631 1175 1602 2 1541 1563 1571 ICV_105 $T=978000 497520 0 180 $X=974770 $Y=492965
X3191 1 1653 1218 1662 2 1645 1591 1608 ICV_105 $T=983040 544560 1 180 $X=979810 $Y=544170
X3192 1 662 640 1700 2 1681 1533 241 ICV_105 $T=988640 497520 1 180 $X=985410 $Y=497130
X3193 1 99 1566 1809 2 107 276 1791 ICV_105 $T=1006560 442640 0 180 $X=1003330 $Y=438085
X3194 1 99 1650 1861 2 107 1757 1852 ICV_105 $T=1014960 528880 1 180 $X=1011730 $Y=528490
X3195 1 37 1908 1985 2 37 1965 1979 ICV_105 $T=1103440 583760 0 180 $X=1100210 $Y=579205
X3196 1 38 1961 2002 2 37 1961 2009 ICV_105 $T=1121920 544560 0 180 $X=1118690 $Y=540005
X3197 1 2137 2108 2148 2 2138 2117 2140 ICV_105 $T=1185760 536720 1 180 $X=1182530 $Y=536330
X3198 1 2148 2146 2149 2 2113 2104 2136 ICV_105 $T=1186320 528880 0 180 $X=1183090 $Y=524325
X3220 1 493 504 503 2 501 513 510 ICV_108 $T=713680 474000 1 0 $X=713250 $Y=469445
X3221 1 37 505 500 2 37 514 468 ICV_108 $T=713680 497520 1 0 $X=713250 $Y=492965
X3222 1 667 685 642 2 696 702 701 ICV_108 $T=818400 458320 0 0 $X=817970 $Y=457930
X3223 1 635 91 694 2 662 91 714 ICV_108 $T=820080 497520 1 0 $X=819650 $Y=492965
X3224 1 667 698 692 2 707 711 737 ICV_108 $T=822880 450480 1 0 $X=822450 $Y=445925
X3225 1 665 718 712 2 635 641 718 ICV_108 $T=822880 528880 1 0 $X=822450 $Y=524325
X3226 1 638 709 733 2 662 757 709 ICV_108 $T=825120 513200 1 0 $X=824690 $Y=508645
X3227 1 704 111 767 2 667 782 787 ICV_108 $T=830720 544560 0 0 $X=830290 $Y=544170
X3228 1 662 799 773 2 114 771 816 ICV_108 $T=834080 513200 1 0 $X=833650 $Y=508645
X3229 1 773 842 837 2 635 799 828 ICV_108 $T=839680 513200 1 0 $X=839250 $Y=508645
X3230 1 646 888 850 2 806 818 785 ICV_108 $T=844720 497520 0 0 $X=844290 $Y=497130
X3231 1 635 777 842 2 828 906 861 ICV_108 $T=845280 513200 1 0 $X=844850 $Y=508645
X3232 1 106 128 841 2 903 663 128 ICV_108 $T=846400 474000 0 0 $X=845970 $Y=473610
X3233 1 99 891 139 2 114 940 736 ICV_108 $T=850320 434800 0 0 $X=849890 $Y=434410
X3234 1 650 935 141 2 662 146 875 ICV_108 $T=852560 481840 0 0 $X=852130 $Y=481450
X3235 1 650 832 936 2 635 961 903 ICV_108 $T=853680 489680 0 0 $X=853250 $Y=489290
X3236 1 635 890 934 2 635 962 774 ICV_108 $T=853680 505360 0 0 $X=853250 $Y=504970
X3237 1 106 899 941 2 776 148 925 ICV_108 $T=854240 536720 1 0 $X=853810 $Y=532165
X3238 1 818 958 838 2 662 153 832 ICV_108 $T=856480 497520 0 0 $X=856050 $Y=497130
X3239 1 708 832 960 2 635 153 958 ICV_108 $T=859280 489680 0 0 $X=858850 $Y=489290
X3240 1 707 960 972 2 107 1015 1014 ICV_108 $T=860960 552400 1 0 $X=860530 $Y=547845
X3241 1 107 837 979 2 635 1033 1003 ICV_108 $T=862640 528880 1 0 $X=862210 $Y=524325
X3242 1 164 1030 1043 2 154 1026 1055 ICV_108 $T=871040 505360 1 0 $X=870610 $Y=500805
X3243 1 1080 1091 1052 2 833 1108 1091 ICV_108 $T=872720 528880 1 0 $X=872290 $Y=524325
X3244 1 1006 1081 1108 2 174 837 1149 ICV_108 $T=880000 528880 1 0 $X=879570 $Y=524325
X3245 1 662 1210 935 2 635 1226 986 ICV_108 $T=891760 528880 0 0 $X=891330 $Y=528490
X3246 1 99 1423 1350 2 106 1447 1433 ICV_108 $T=948320 536720 1 0 $X=947890 $Y=532165
X3247 1 107 1442 1420 2 662 576 1461 ICV_108 $T=950560 521040 0 0 $X=950130 $Y=520650
X3248 1 635 1357 1493 2 635 225 1509 ICV_108 $T=959520 560240 0 0 $X=959090 $Y=559850
X3249 1 1194 1506 1485 2 1487 159 1520 ICV_108 $T=960640 583760 0 0 $X=960210 $Y=583370
X3250 1 1493 1515 1313 2 1515 1530 1317 ICV_108 $T=961760 513200 1 0 $X=961330 $Y=508645
X3251 1 114 1608 252 2 99 1600 256 ICV_108 $T=975760 434800 0 0 $X=975330 $Y=434410
X3252 1 635 1491 1533 2 1645 1701 1685 ICV_108 $T=985280 528880 1 0 $X=984850 $Y=524325
X3253 1 1561 1664 1286 2 1561 1701 1466 ICV_108 $T=986400 528880 0 0 $X=985970 $Y=528490
X3254 1 1698 1740 1507 2 1703 1728 1430 ICV_108 $T=994240 489680 1 0 $X=993810 $Y=485125
X3255 1 37 2072 2076 2 38 2072 2067 ICV_108 $T=1152720 513200 1 0 $X=1152290 $Y=508645
X3256 1 2 37 564 591 ICV_70 $T=773040 615120 0 180 $X=769810 $Y=610565
X3257 1 2 38 570 601 ICV_70 $T=779760 607280 0 180 $X=776530 $Y=602725
X3258 1 2 638 665 83 ICV_70 $T=818400 505360 1 180 $X=815170 $Y=504970
X3259 1 2 662 616 674 ICV_70 $T=820640 521040 1 180 $X=817410 $Y=520650
X3260 1 2 785 696 742 ICV_70 $T=835200 552400 0 180 $X=831970 $Y=547845
X3261 1 2 846 82 836 ICV_70 $T=843040 583760 1 180 $X=839810 $Y=583370
X3262 1 2 106 845 870 ICV_70 $T=845840 536720 1 180 $X=842610 $Y=536330
X3263 1 2 886 80 722 ICV_70 $T=847520 575920 1 180 $X=844290 $Y=575530
X3264 1 2 107 858 874 ICV_70 $T=849760 552400 0 180 $X=846530 $Y=547845
X3265 1 2 107 720 904 ICV_70 $T=851440 505360 1 180 $X=848210 $Y=504970
X3266 1 2 719 861 911 ICV_70 $T=852000 560240 0 180 $X=848770 $Y=555685
X3267 1 2 687 674 894 ICV_70 $T=853120 513200 1 180 $X=849890 $Y=512810
X3268 1 2 662 777 906 ICV_70 $T=853680 513200 0 180 $X=850450 $Y=508645
X3269 1 2 99 838 976 ICV_70 $T=861520 528880 1 180 $X=858290 $Y=528490
X3270 1 2 1003 784 956 ICV_70 $T=864880 521040 1 180 $X=861650 $Y=520650
X3271 1 2 99 900 1010 ICV_70 $T=866560 528880 1 180 $X=863330 $Y=528490
X3272 1 2 1036 130 1029 ICV_70 $T=868800 575920 1 180 $X=865570 $Y=575530
X3273 1 2 1006 690 1041 ICV_70 $T=871040 474000 1 180 $X=867810 $Y=473610
X3274 1 2 719 1041 1054 ICV_70 $T=871600 474000 0 180 $X=868370 $Y=469445
X3275 1 2 1088 918 1065 ICV_70 $T=876640 466160 1 180 $X=873410 $Y=465770
X3276 1 2 174 102 1116 ICV_70 $T=881120 434800 0 180 $X=877890 $Y=430245
X3277 1 2 1200 1182 1195 ICV_70 $T=891200 615120 0 180 $X=887970 $Y=610565
X3278 1 2 1283 1162 1277 ICV_70 $T=932080 513200 0 180 $X=928850 $Y=508645
X3279 1 2 1321 587 1328 ICV_70 $T=939360 575920 1 180 $X=936130 $Y=575530
X3280 1 2 1384 159 1392 ICV_70 $T=950560 442640 0 180 $X=947330 $Y=438085
X3281 1 2 1452 1434 1448 ICV_70 $T=956160 552400 0 180 $X=952930 $Y=547845
X3282 1 2 1486 1474 1518 ICV_70 $T=966240 536720 1 180 $X=963010 $Y=536330
X3283 1 2 696 1428 1626 ICV_70 $T=980800 466160 1 180 $X=977570 $Y=465770
X3284 1 2 99 1608 1647 ICV_70 $T=984160 442640 0 180 $X=980930 $Y=438085
X3285 1 2 1670 1664 1414 ICV_70 $T=986960 489680 0 180 $X=983730 $Y=485125
X3286 1 2 1531 1484 264 ICV_70 $T=989760 552400 0 180 $X=986530 $Y=547845
X3287 1 2 1704 159 1668 ICV_70 $T=991440 583760 1 180 $X=988210 $Y=583370
X3288 1 2 1713 148 1717 ICV_70 $T=993680 583760 0 180 $X=990450 $Y=579205
X3289 1 2 114 263 1723 ICV_70 $T=997600 466160 0 180 $X=994370 $Y=461605
X3290 1 2 1748 80 1660 ICV_70 $T=999280 575920 1 180 $X=996050 $Y=575530
X3291 1 2 1698 1728 1757 ICV_70 $T=1000960 497520 0 180 $X=997730 $Y=492965
X3292 1 2 1769 1544 276 ICV_70 $T=1002640 466160 0 180 $X=999410 $Y=461605
X3293 1 2 1767 82 1768 ICV_70 $T=1002640 568080 0 180 $X=999410 $Y=563525
X3294 1 2 1775 1705 273 ICV_70 $T=1003760 466160 1 180 $X=1000530 $Y=465770
X3295 1 2 114 1294 1789 ICV_70 $T=1008240 489680 0 180 $X=1005010 $Y=485125
X3296 1 2 107 1803 1840 ICV_70 $T=1013840 544560 0 180 $X=1010610 $Y=540005
X3297 1 2 1582 93 1868 ICV_70 $T=1018320 560240 0 180 $X=1015090 $Y=555685
X3298 1 2 99 1867 1848 ICV_70 $T=1018880 466160 1 180 $X=1015650 $Y=465770
X3299 1 2 114 1727 1869 ICV_70 $T=1018880 481840 1 180 $X=1015650 $Y=481450
X3300 1 2 38 1973 1996 ICV_70 $T=1115200 474000 1 180 $X=1111970 $Y=473610
X3301 1 2 42 2020 333 ICV_70 $T=1130880 615120 1 180 $X=1127650 $Y=614730
X3302 1 2 38 1953 2048 ICV_70 $T=1144880 583760 1 180 $X=1141650 $Y=583370
X3303 1 2 37 1987 2060 ICV_70 $T=1151600 544560 1 180 $X=1148370 $Y=544170
X3304 1 2 2070 2050 2042 ICV_70 $T=1152720 458320 1 180 $X=1149490 $Y=457930
X3305 1 2 38 2061 2090 ICV_70 $T=1161120 513200 0 180 $X=1157890 $Y=508645
X3306 1 2 2102 2088 2109 ICV_70 $T=1172320 536720 0 180 $X=1169090 $Y=532165
X3307 1 2 2113 2088 2099 ICV_70 $T=1172880 528880 0 180 $X=1169650 $Y=524325
X3308 1 2 2110 2098 2103 ICV_70 $T=1174000 583760 0 180 $X=1170770 $Y=579205
X3309 1 2 2142 2121 2147 ICV_70 $T=1188560 560240 1 180 $X=1185330 $Y=559850
X3310 1 2 2157 2155 2156 ICV_70 $T=1201440 607280 0 180 $X=1198210 $Y=602725
X3311 1 656 653 655 2 ICV_106 $T=811120 450480 0 0 $X=810690 $Y=450090
X3312 1 667 83 639 2 ICV_106 $T=813360 442640 0 0 $X=812930 $Y=442250
X3313 1 37 561 88 2 ICV_106 $T=815600 615120 0 0 $X=815170 $Y=614730
X3314 1 750 657 754 2 ICV_106 $T=825120 521040 1 0 $X=824690 $Y=516485
X3315 1 696 728 740 2 ICV_106 $T=827360 568080 1 0 $X=826930 $Y=563525
X3316 1 774 669 891 2 ICV_106 $T=843040 505360 0 0 $X=842610 $Y=504970
X3317 1 661 715 1032 2 ICV_106 $T=863200 513200 0 0 $X=862770 $Y=512810
X3318 1 1038 919 1169 2 ICV_106 $T=883360 489680 0 0 $X=882930 $Y=489290
X3319 1 1296 1202 1285 2 ICV_106 $T=928720 560240 1 0 $X=928290 $Y=555685
X3320 1 833 1361 1336 2 ICV_106 $T=941600 474000 0 0 $X=941170 $Y=473610
X3321 1 1457 228 229 2 ICV_106 $T=950000 434800 0 0 $X=949570 $Y=434410
X3322 1 231 844 1470 2 ICV_106 $T=953360 466160 0 0 $X=952930 $Y=465770
X3323 1 1363 93 237 2 ICV_106 $T=955600 434800 0 0 $X=955170 $Y=434410
X3324 1 243 130 1512 2 ICV_106 $T=961200 434800 0 0 $X=960770 $Y=434410
X3325 1 707 1507 1529 2 ICV_106 $T=962880 474000 1 0 $X=962450 $Y=469445
X3326 1 635 614 1703 2 ICV_106 $T=987520 521040 1 0 $X=987090 $Y=516485
X3327 1 1283 154 1734 2 ICV_106 $T=990880 497520 1 0 $X=990450 $Y=492965
X3328 1 1781 80 1725 2 ICV_106 $T=999280 442640 0 0 $X=998850 $Y=442250
X3329 1 1847 1706 1842 2 ICV_106 $T=1010480 575920 1 0 $X=1010050 $Y=571365
X3330 1 37 2075 2059 2 ICV_106 $T=1149920 583760 0 0 $X=1149490 $Y=583370
X3331 1 349 284 346 2 ICV_106 $T=1175120 615120 1 0 $X=1174690 $Y=610565
X3332 1 2 635 616 648 ICV_89 $T=811120 521040 0 0 $X=810690 $Y=520650
X3333 1 2 662 602 664 ICV_89 $T=813920 497520 0 0 $X=813490 $Y=497130
X3334 1 2 719 712 691 ICV_89 $T=821760 560240 1 0 $X=821330 $Y=555685
X3335 1 2 696 754 768 ICV_89 $T=829600 552400 0 0 $X=829170 $Y=552010
X3336 1 2 662 873 766 ICV_89 $T=848080 505360 1 0 $X=847650 $Y=500805
X3337 1 2 114 1032 1092 ICV_89 $T=872160 544560 1 0 $X=871730 $Y=540005
X3338 1 2 1193 631 1187 ICV_89 $T=886720 583760 1 0 $X=886290 $Y=579205
X3339 1 2 1197 1189 1134 ICV_89 $T=887280 442640 0 0 $X=886850 $Y=442250
X3340 1 2 1280 93 1271 ICV_89 $T=927600 536720 1 0 $X=927170 $Y=532165
X3341 1 2 1426 82 1415 ICV_89 $T=947760 583760 0 0 $X=947330 $Y=583370
X3342 1 2 635 1242 1452 ICV_89 $T=951120 552400 0 0 $X=950690 $Y=552010
X3343 1 2 99 1292 1468 ICV_89 $T=953360 505360 0 0 $X=952930 $Y=504970
X3344 1 2 1642 1629 1648 ICV_89 $T=980240 489680 1 0 $X=979810 $Y=485125
X3345 1 2 1741 82 1737 ICV_89 $T=995920 442640 1 0 $X=995490 $Y=438085
X3346 1 2 1769 1705 1283 ICV_89 $T=999280 474000 1 0 $X=998850 $Y=469445
X3347 1 2 1873 1870 285 ICV_89 $T=1018320 458320 1 0 $X=1017890 $Y=453765
X3348 1 635 607 661 2 635 578 645 ICV_109 $T=814480 481840 0 180 $X=811250 $Y=477285
X3349 1 662 577 690 2 662 578 668 ICV_109 $T=819520 481840 1 180 $X=816290 $Y=481450
X3350 1 724 734 115 2 734 714 770 ICV_109 $T=834080 497520 0 180 $X=830850 $Y=492965
X3351 1 114 685 848 2 99 717 820 ICV_109 $T=841920 474000 0 180 $X=838690 $Y=469445
X3352 1 107 878 897 2 107 861 829 ICV_109 $T=849200 544560 1 180 $X=845970 $Y=544170
X3353 1 774 888 896 2 107 894 865 ICV_109 $T=855920 521040 1 180 $X=852690 $Y=520650
X3354 1 114 982 889 2 114 891 145 ICV_109 $T=858720 434800 1 180 $X=855490 $Y=434410
X3355 1 648 990 717 2 985 906 940 ICV_109 $T=863760 497520 0 180 $X=860530 $Y=492965
X3356 1 779 159 1049 2 707 893 1019 ICV_109 $T=868800 450480 0 180 $X=865570 $Y=445925
X3357 1 172 725 1106 2 174 1108 1097 ICV_109 $T=880560 528880 1 180 $X=877330 $Y=528490
X3358 1 1530 1562 1347 2 1552 1530 1445 ICV_109 $T=972400 513200 1 180 $X=969170 $Y=512810
X3359 1 107 264 1692 2 164 259 1646 ICV_109 $T=987520 434800 0 180 $X=984290 $Y=430245
X3360 1 719 1316 1689 2 667 1518 1672 ICV_109 $T=987520 536720 1 180 $X=984290 $Y=536330
X3361 1 1634 82 1679 2 1719 80 1716 ICV_109 $T=993680 575920 1 180 $X=990450 $Y=575530
X3362 1 1720 1627 1652 2 1720 1740 239 ICV_109 $T=998720 474000 1 180 $X=995490 $Y=473610
X3363 1 1775 1690 1318 2 1775 1700 1294 ICV_109 $T=1007680 474000 1 180 $X=1004450 $Y=473610
X3364 1 106 1609 1821 2 1795 93 1790 ICV_109 $T=1008800 544560 1 180 $X=1005570 $Y=544170
X3365 1 37 2061 2066 2 2066 2051 2064 ICV_109 $T=1151600 521040 0 180 $X=1148370 $Y=516485
X3366 1 2 682 80 676 ICV_102 $T=821200 450480 1 180 $X=817970 $Y=450090
X3367 1 2 708 670 702 ICV_102 $T=824000 489680 0 180 $X=820770 $Y=485125
X3368 1 2 106 785 877 ICV_102 $T=846960 544560 0 180 $X=843730 $Y=540005
X3369 1 2 719 728 927 ICV_102 $T=854800 575920 0 180 $X=851570 $Y=571365
X3370 1 2 149 80 916 ICV_102 $T=860400 434800 0 180 $X=857170 $Y=430245
X3371 1 2 707 982 1070 ICV_102 $T=876080 544560 1 180 $X=872850 $Y=544170
X3372 1 2 1381 185 1341 ICV_102 $T=946080 489680 0 180 $X=942850 $Y=485125
X3373 1 2 1497 1462 1320 ICV_102 $T=962320 536720 1 180 $X=959090 $Y=536330
X3374 1 2 1377 1061 242 ICV_102 $T=966800 450480 1 180 $X=963570 $Y=450090
X3375 1 2 662 615 1515 ICV_102 $T=966800 544560 1 180 $X=963570 $Y=544170
X3376 1 2 635 615 1532 ICV_102 $T=968480 544560 0 180 $X=965250 $Y=540005
X3377 1 2 667 1482 1557 ICV_102 $T=972400 466160 1 180 $X=969170 $Y=465770
X3378 1 2 635 1293 1561 ICV_102 $T=972960 536720 0 180 $X=969730 $Y=532165
X3379 1 2 696 1525 1617 ICV_102 $T=980240 575920 0 180 $X=977010 $Y=571365
X3380 1 2 1644 1552 259 ICV_102 $T=983040 513200 1 180 $X=979810 $Y=512810
X3381 1 2 1643 1175 1642 ICV_102 $T=983600 497520 0 180 $X=980370 $Y=492965
X3382 1 2 635 1238 1695 ICV_102 $T=990880 505360 1 180 $X=987650 $Y=504970
X3383 1 2 1703 1562 1371 ICV_102 $T=991440 513200 0 180 $X=988210 $Y=508645
X3384 1 2 1729 1701 1584 ICV_102 $T=995360 513200 0 180 $X=992130 $Y=508645
X3385 1 2 662 599 1728 ICV_102 $T=995920 489680 1 180 $X=992690 $Y=489290
X3386 1 2 1767 80 1761 ICV_102 $T=1002080 560240 1 180 $X=998850 $Y=559850
X3387 1 2 1742 130 275 ICV_102 $T=1002640 442640 0 180 $X=999410 $Y=438085
X3388 1 2 99 1732 1808 ICV_102 $T=1008800 466160 1 180 $X=1005570 $Y=465770
X3389 1 2 1773 93 1831 ICV_102 $T=1013280 552400 0 180 $X=1010050 $Y=547845
X3390 1 2 37 1971 2014 ICV_102 $T=1124720 474000 1 180 $X=1121490 $Y=473610
X3391 1 2 327 284 363 ICV_102 $T=1205920 615120 1 180 $X=1202690 $Y=614730
X3392 1 2 745 748 761 760 ICV_103 $T=827360 560240 0 0 $X=826930 $Y=559850
X3393 1 2 834 862 859 870 ICV_103 $T=841360 536720 1 0 $X=840930 $Y=532165
X3394 1 2 950 927 965 972 ICV_103 $T=855920 575920 1 0 $X=855490 $Y=571365
X3395 1 2 801 1000 991 1009 ICV_103 $T=860960 583760 0 0 $X=860530 $Y=583370
X3396 1 2 1148 1113 1152 1164 ICV_103 $T=882240 521040 0 0 $X=881810 $Y=520650
X3397 1 2 1059 1156 1163 1168 ICV_103 $T=882800 466160 0 0 $X=882370 $Y=465770
X3398 1 2 1250 1254 1258 662 ICV_103 $T=923680 583760 1 0 $X=923250 $Y=579205
X3399 1 2 1324 1305 1339 1341 ICV_103 $T=937120 481840 0 0 $X=936690 $Y=481450
X3400 1 2 227 1451 1464 1465 ICV_103 $T=952240 450480 1 0 $X=951810 $Y=445925
X3401 1 2 1512 1495 1528 1522 ICV_103 $T=962880 442640 1 0 $X=962450 $Y=438085
X3402 1 2 1508 1535 1540 80 ICV_103 $T=965680 458320 0 0 $X=965250 $Y=457930
X3403 1 2 1455 1539 1551 1520 ICV_103 $T=966800 591600 1 0 $X=966370 $Y=587045
X3404 1 2 1502 1577 1580 1540 ICV_103 $T=971840 458320 0 0 $X=971410 $Y=457930
X3405 1 2 1571 1560 1596 1601 ICV_103 $T=972960 505360 1 0 $X=972530 $Y=500805
X3406 1 2 1038 1593 1632 1633 ICV_103 $T=976880 528880 0 0 $X=976450 $Y=528490
X3407 1 2 1723 1808 1844 1832 ICV_103 $T=1009920 466160 0 0 $X=1009490 $Y=465770
X3408 1 2 1751 1801 1839 1825 ICV_103 $T=1011600 513200 1 0 $X=1011170 $Y=508645
X3409 1 2 347 348 2114 350 ICV_103 $T=1177360 615120 0 0 $X=1176930 $Y=614730
X3410 1 2 2151 349 2155 358 ICV_103 $T=1192480 607280 1 0 $X=1192050 $Y=602725
X3411 1 142 ANTENNA $T=858160 568080 1 0 $X=857730 $Y=563525
X3412 1 142 ANTENNA $T=859280 568080 1 0 $X=858850 $Y=563525
X3413 1 1218 ANTENNA $T=913600 489680 0 0 $X=913170 $Y=489290
X3414 1 1218 ANTENNA $T=917520 489680 0 0 $X=917090 $Y=489290
X3415 662 1 2 635 INVX4 $T=1025600 513200 1 180 $X=1022930 $Y=512810
X3416 1930 1 2 42 INVX4 $T=1075440 599440 0 0 $X=1075010 $Y=599050
.ENDS
***************************************
.SUBCKT ICV_81
** N=4 EP=0 IP=8 FDC=0
.ENDS
***************************************
.SUBCKT ICV_83
** N=4 EP=0 IP=8 FDC=0
.ENDS
***************************************
.SUBCKT ICV_56
** N=4 EP=0 IP=8 FDC=0
.ENDS
***************************************
.SUBCKT ICV_85 1 2 3 4 5 6
** N=8 EP=6 IP=12 FDC=6
X1 3 4 6 1 2 5 NAND3X1 $T=1680 0 0 0 $X=1250 $Y=-390
.ENDS
***************************************
.SUBCKT ICV_73 1 2 3 4 5
** N=7 EP=5 IP=11 FDC=4
X1 3 4 1 2 5 NAND2X1 $T=0 0 0 0 $X=-430 $Y=-390
.ENDS
***************************************
.SUBCKT ICV_95 1 2 3 4 5 6
** N=8 EP=6 IP=13 FDC=40
X1 4 6 2 5 1 2 3 DFFQSRX1 $T=0 0 0 0 $X=-430 $Y=-390
.ENDS
***************************************
.SUBCKT ICV_88 1 2 3 4 5 6
** N=8 EP=6 IP=12 FDC=6
X1 3 4 6 1 2 5 NAND3X1 $T=560 0 0 0 $X=130 $Y=-390
.ENDS
***************************************
.SUBCKT ICV_97 1 2 3 4 5 6
** N=8 EP=6 IP=12 FDC=6
X1 3 4 6 1 2 5 NAND3X1 $T=2240 0 0 0 $X=1810 $Y=-390
.ENDS
***************************************
.SUBCKT ICV_86 1 2 3 4 5
** N=7 EP=5 IP=11 FDC=4
X0 2 3 1 5 4 NAND2X1 $T=2800 0 0 0 $X=2370 $Y=-390
.ENDS
***************************************
.SUBCKT ICV_63 1 2 3 4 5
** N=7 EP=5 IP=11 FDC=4
X1 3 4 1 2 5 NAND2X1 $T=0 0 0 0 $X=-430 $Y=-390
.ENDS
***************************************
.SUBCKT ICV_94 1 2 3 4 5 6
** N=8 EP=6 IP=13 FDC=40
X1 4 6 2 5 1 2 3 DFFQSRX1 $T=1680 0 0 0 $X=1250 $Y=-390
.ENDS
***************************************
.SUBCKT ICV_84 1 2 3 4 5
** N=7 EP=5 IP=11 FDC=4
X1 3 4 1 2 5 NOR2X1 $T=1680 0 0 0 $X=1250 $Y=-390
.ENDS
***************************************
.SUBCKT ICV_98 1 2 3 4 5 6 7 8 9 10 11 12 13 14 15 16 17 18 19 20
+ 21 22 23 24 25 26 27 28 29 30 31 32 33 34 35 36 37 38 39 40
+ 41 42 43 44 45 46 47 48 49 50 51 52 53 54 55 56 57 58 59 60
+ 61 62 63 64 65 66 67 68 69 70 71 72 73 74 75 76 77 78 79 80
+ 81 82 83 84 85 86 87 88 89 90 91 92 93 94 95 96 97 98 99 100
+ 101 102 103 104 105 106 107 108 109 110 111 112 113 114 115 116 117 118 119 120
+ 121 122 123 124 125 126 127 128 129 130 131 132 133 134 135 136 137 138 139 140
+ 141 142 143 144 145 146 147 148 149 150 151 152 153 154 155 156 157 158 159 160
+ 161 162 163 164 165 166 167 168 169 170 171 172 173 174 175 176 177 178 179 180
+ 181 182 183 184 185 186 187 188 189 190 191 192 193 194 195 196 197 198 199 200
+ 201 202 203 204 205 206 207 208 209 210 211 212 213 214 215 216 217 218 219 220
+ 221 222 223 224 225 226 227 228 229 230 231 232 233 234 235 236 237 238 239 240
+ 241 242 243 244 245 246 247 248 249 250 251 252 253 254 255 256 257 258 259 260
+ 261 262 263 264 265 266 267 268 269 270 271 272 273 274 275 276 277 278 279 280
+ 281 282 283 284 285 286 287 288 289 290 291 292 293 294 295 296 297 298 299 300
+ 301 302 303 304 305 306 307 308 309 310 311 312 313 314 315 316 317 318 319 320
+ 321 322 323 324 325 326 327 328 329
** N=2141 EP=329 IP=20927 FDC=19107
X814 345 342 1 2 335 OR2X1 $T=627440 646480 0 180 $X=623650 $Y=641925
X815 12 352 1 2 344 OR2X1 $T=631920 622960 1 180 $X=628130 $Y=622570
X816 354 367 1 2 19 OR2X1 $T=635840 638640 0 0 $X=635410 $Y=638250
X817 356 19 1 2 21 OR2X1 $T=638080 622960 1 0 $X=637650 $Y=618405
X818 17 352 1 2 372 OR2X1 $T=640320 638640 1 0 $X=639890 $Y=634085
X819 10 369 1 2 374 OR2X1 $T=645360 662160 0 180 $X=641570 $Y=657605
X820 29 14 1 2 352 OR2X1 $T=649280 622960 0 180 $X=645490 $Y=618405
X821 380 23 1 2 389 OR2X1 $T=646480 654320 0 0 $X=646050 $Y=653930
X822 14 378 1 2 391 OR2X1 $T=648160 630800 0 0 $X=647730 $Y=630410
X823 490 455 1 2 488 OR2X1 $T=689600 662160 0 180 $X=685810 $Y=657605
X824 490 494 1 2 497 OR2X1 $T=686800 630800 1 0 $X=686370 $Y=626245
X825 490 544 1 2 545 OR2X1 $T=706400 638640 0 0 $X=705970 $Y=638250
X826 490 543 1 2 551 OR2X1 $T=708080 662160 0 0 $X=707650 $Y=661770
X827 623 630 1 2 638 OR2X1 $T=742240 732720 1 0 $X=741810 $Y=728165
X828 640 635 1 2 608 OR2X1 $T=746160 693520 1 180 $X=742370 $Y=693130
X829 686 676 1 2 651 OR2X1 $T=754000 701360 0 180 $X=750210 $Y=696805
X830 676 658 1 2 690 OR2X1 $T=751200 709200 1 0 $X=750770 $Y=704645
X831 640 685 1 2 700 OR2X1 $T=759600 740560 0 180 $X=755810 $Y=736005
X832 703 714 1 2 718 OR2X1 $T=757920 677840 0 0 $X=757490 $Y=677450
X833 699 672 1 2 726 OR2X1 $T=761280 717040 0 0 $X=760850 $Y=716650
X834 791 777 1 2 765 OR2X1 $T=778640 677840 1 180 $X=774850 $Y=677450
X835 687 672 1 2 794 OR2X1 $T=776400 717040 1 0 $X=775970 $Y=712485
X836 710 461 1 2 800 OR2X1 $T=778640 662160 1 0 $X=778210 $Y=657605
X837 769 634 1 2 804 OR2X1 $T=780320 724880 1 0 $X=779890 $Y=720325
X838 623 783 1 2 788 OR2X1 $T=780320 732720 1 0 $X=779890 $Y=728165
X839 785 46 1 2 812 OR2X1 $T=794880 662160 0 180 $X=791090 $Y=657605
X840 963 951 1 2 967 OR2X1 $T=869360 732720 0 180 $X=865570 $Y=728165
X841 142 984 1 2 981 OR2X1 $T=873280 803280 0 180 $X=869490 $Y=798725
X842 999 1000 1 2 993 OR2X1 $T=874960 787600 1 180 $X=871170 $Y=787210
X843 997 998 1 2 966 OR2X1 $T=875520 748400 0 180 $X=871730 $Y=743845
X844 991 1009 1 2 1003 OR2X1 $T=877200 732720 1 180 $X=873410 $Y=732330
X845 1013 1006 1 2 1002 OR2X1 $T=877760 795440 1 180 $X=873970 $Y=795050
X846 1012 1006 1 2 146 OR2X1 $T=875520 803280 0 0 $X=875090 $Y=802890
X847 1036 146 1 2 986 OR2X1 $T=880000 795440 0 180 $X=876210 $Y=790885
X848 963 1066 1 2 1075 OR2X1 $T=882800 717040 0 0 $X=882370 $Y=716650
X849 1054 1065 1 2 159 OR2X1 $T=887280 803280 0 180 $X=883490 $Y=798725
X850 1093 154 1 2 152 OR2X1 $T=887840 803280 1 180 $X=884050 $Y=802890
X851 1047 1043 1 2 1095 OR2X1 $T=885040 764080 0 0 $X=884610 $Y=763690
X852 1074 1064 1 2 1099 OR2X1 $T=886160 740560 0 0 $X=885730 $Y=740170
X853 164 1097 1 2 1090 OR2X1 $T=890080 662160 0 180 $X=886290 $Y=657605
X854 1123 1118 1 2 1063 OR2X1 $T=893440 771920 1 180 $X=889650 $Y=771530
X855 1013 172 1 2 1107 OR2X1 $T=895120 795440 1 180 $X=891330 $Y=795050
X856 1041 1081 1 2 1136 OR2X1 $T=896800 709200 1 180 $X=893010 $Y=708810
X857 1117 1127 1 2 1126 OR2X1 $T=897360 732720 1 180 $X=893570 $Y=732330
X858 1081 1001 1 2 1154 OR2X1 $T=895120 717040 1 0 $X=894690 $Y=712485
X859 1108 1174 1 2 1192 OR2X1 $T=899600 779760 1 0 $X=899170 $Y=775205
X860 1135 1069 1 2 1197 OR2X1 $T=900160 630800 1 0 $X=899730 $Y=626245
X861 997 1001 1 2 1198 OR2X1 $T=900160 724880 0 0 $X=899730 $Y=724490
X862 1213 164 1 2 1195 OR2X1 $T=905760 654320 0 180 $X=901970 $Y=649765
X863 1220 1149 1 2 1200 OR2X1 $T=907440 756240 1 180 $X=903650 $Y=755850
X864 1170 1219 1 2 1223 OR2X1 $T=904640 740560 1 0 $X=904210 $Y=736005
X865 1175 1163 1 2 1209 OR2X1 $T=909680 646480 0 180 $X=905890 $Y=641925
X866 1171 1195 1 2 1231 OR2X1 $T=907440 654320 1 0 $X=907010 $Y=649765
X867 1140 1226 1 2 1210 OR2X1 $T=910800 670000 0 180 $X=907010 $Y=665445
X868 169 185 1 2 188 OR2X1 $T=910240 622960 1 0 $X=909810 $Y=618405
X869 1235 1244 1 2 1226 OR2X1 $T=914160 662160 1 180 $X=910370 $Y=661770
X870 181 1244 1 2 191 OR2X1 $T=913600 622960 1 0 $X=913170 $Y=618405
X871 1013 1123 1 2 1255 OR2X1 $T=913600 803280 1 0 $X=913170 $Y=798725
X872 1111 1013 1 2 190 OR2X1 $T=916960 811120 0 180 $X=913170 $Y=806565
X873 1228 1245 1 2 1262 OR2X1 $T=916400 638640 0 0 $X=915970 $Y=638250
X874 1103 1204 1 2 1252 OR2X1 $T=922000 654320 0 180 $X=918210 $Y=649765
X875 1347 1337 1 2 1331 OR2X1 $T=954480 646480 0 180 $X=950690 $Y=641925
X876 1332 1371 1 2 1373 OR2X1 $T=958960 662160 1 0 $X=958530 $Y=657605
X877 1399 1337 1 2 1387 OR2X1 $T=966240 662160 0 180 $X=962450 $Y=657605
X878 1399 1402 1 2 1403 OR2X1 $T=969600 662160 0 180 $X=965810 $Y=657605
X879 1431 1400 1 2 1436 OR2X1 $T=974080 662160 0 0 $X=973650 $Y=661770
X880 1424 1442 1 2 1457 OR2X1 $T=976880 677840 0 0 $X=976450 $Y=677450
X881 1431 1452 1 2 1454 OR2X1 $T=981360 622960 0 0 $X=980930 $Y=622570
X882 1356 1424 1 2 1475 OR2X1 $T=984720 677840 1 180 $X=980930 $Y=677450
X883 1487 1454 1 2 1496 OR2X1 $T=985280 622960 0 0 $X=984850 $Y=622570
X884 1392 1351 1 2 1493 OR2X1 $T=989200 630800 1 180 $X=985410 $Y=630410
X885 1466 1402 1 2 1501 OR2X1 $T=989200 670000 0 0 $X=988770 $Y=669610
X886 1551 1544 1 2 1540 OR2X1 $T=1003760 771920 1 180 $X=999970 $Y=771530
X887 1546 1580 1 2 1573 OR2X1 $T=1011040 748400 1 180 $X=1007250 $Y=748010
X888 1585 1595 1 2 1584 OR2X1 $T=1011040 771920 0 0 $X=1010610 $Y=771530
X889 1605 1578 1 2 1544 OR2X1 $T=1014960 771920 0 180 $X=1011170 $Y=767365
X890 1546 1611 1 2 1610 OR2X1 $T=1013280 748400 1 0 $X=1012850 $Y=743845
X891 1546 1631 1 2 1635 OR2X1 $T=1024480 748400 0 180 $X=1020690 $Y=743845
X892 1562 1578 1 2 1648 OR2X1 $T=1028960 779760 1 180 $X=1025170 $Y=779370
X893 1656 1639 1 2 1662 OR2X1 $T=1028960 748400 0 0 $X=1028530 $Y=748010
X894 490 1764 1 2 1771 OR2X1 $T=1074880 654320 1 0 $X=1074450 $Y=649765
X895 490 1804 1 2 1800 OR2X1 $T=1092240 630800 0 180 $X=1088450 $Y=626245
X896 490 1830 1 2 1836 OR2X1 $T=1102880 638640 1 0 $X=1102450 $Y=634085
X897 302 303 1 2 2013 OR2X1 $T=1186880 630800 1 180 $X=1183090 $Y=630410
X898 300 2030 1 2 2023 OR2X1 $T=1184080 654320 1 0 $X=1183650 $Y=649765
X899 2010 2029 1 2 2037 OR2X1 $T=1192480 670000 0 180 $X=1188690 $Y=665445
X900 2044 2010 1 2 2036 OR2X1 $T=1193040 638640 1 180 $X=1189250 $Y=638250
X901 305 303 1 2 2044 OR2X1 $T=1194720 646480 0 180 $X=1190930 $Y=641925
X902 2065 309 1 2 2047 OR2X1 $T=1199200 662160 0 180 $X=1195410 $Y=657605
X903 2064 2069 1 2 2061 OR2X1 $T=1201440 662160 1 180 $X=1197650 $Y=661770
X904 2041 2005 1 2 2074 OR2X1 $T=1200320 638640 1 0 $X=1199890 $Y=634085
X905 1589 2075 1 2 303 OR2X1 $T=1205360 646480 0 180 $X=1201570 $Y=641925
X906 2041 2064 1 2 2081 OR2X1 $T=1205360 646480 0 0 $X=1204930 $Y=646090
X907 2087 2082 1 2 2063 OR2X1 $T=1212640 630800 0 180 $X=1208850 $Y=626245
X908 340 3 333 1 2 332 NAND3X1 $T=624640 622960 1 180 $X=620290 $Y=622570
X909 10 354 356 1 2 355 NAND3X1 $T=629120 630800 1 0 $X=628690 $Y=626245
X910 343 353 13 1 2 357 NAND3X1 $T=629120 638640 0 0 $X=628690 $Y=638250
X911 360 362 9 1 2 18 NAND3X1 $T=633040 630800 1 0 $X=632610 $Y=626245
X912 334 15 365 1 2 363 NAND3X1 $T=633040 646480 1 0 $X=632610 $Y=641925
X913 371 373 346 1 2 376 NAND3X1 $T=640320 654320 1 0 $X=639890 $Y=649765
X914 24 23 362 1 2 340 NAND3X1 $T=644800 622960 1 180 $X=640450 $Y=622570
X915 369 375 378 1 2 377 NAND3X1 $T=640880 638640 0 0 $X=640450 $Y=638250
X916 24 23 8 1 2 390 NAND3X1 $T=647600 622960 0 0 $X=647170 $Y=622570
X917 24 421 362 1 2 422 NAND3X1 $T=662160 630800 1 0 $X=661730 $Y=626245
X918 408 425 431 1 2 429 NAND3X1 $T=663840 779760 0 0 $X=663410 $Y=779370
X919 417 436 437 1 2 440 NAND3X1 $T=666640 764080 1 0 $X=666210 $Y=759525
X920 41 438 467 1 2 465 NAND3X1 $T=675600 803280 0 0 $X=675170 $Y=802890
X921 454 474 478 1 2 477 NAND3X1 $T=680080 795440 1 0 $X=679650 $Y=790885
X922 458 489 487 1 2 492 NAND3X1 $T=684560 670000 0 0 $X=684130 $Y=669610
X923 488 507 47 1 2 502 NAND3X1 $T=694640 662160 0 180 $X=690290 $Y=657605
X924 510 511 48 1 2 505 NAND3X1 $T=695200 646480 1 180 $X=690850 $Y=646090
X925 497 516 51 1 2 517 NAND3X1 $T=693520 630800 1 0 $X=693090 $Y=626245
X926 518 522 53 1 2 520 NAND3X1 $T=695760 638640 0 0 $X=695330 $Y=638250
X927 551 554 61 1 2 552 NAND3X1 $T=714240 638640 1 180 $X=709890 $Y=638250
X928 562 559 539 1 2 556 NAND3X1 $T=716480 654320 0 180 $X=712130 $Y=649765
X929 570 573 68 1 2 575 NAND3X1 $T=718160 638640 1 0 $X=717730 $Y=634085
X930 560 574 581 1 2 576 NAND3X1 $T=718160 662160 0 0 $X=717730 $Y=661770
X931 545 568 69 1 2 580 NAND3X1 $T=719840 622960 0 0 $X=719410 $Y=622570
X932 619 612 608 1 2 555 NAND3X1 $T=741120 693520 1 180 $X=736770 $Y=693130
X933 616 614 609 1 2 610 NAND3X1 $T=741680 638640 1 180 $X=737330 $Y=638250
X934 632 625 622 1 2 621 NAND3X1 $T=745040 709200 0 180 $X=740690 $Y=704645
X935 639 631 624 1 2 626 NAND3X1 $T=746160 670000 1 180 $X=741810 $Y=669610
X936 649 617 620 1 2 636 NAND3X1 $T=747840 654320 1 180 $X=743490 $Y=653930
X937 673 646 652 1 2 628 NAND3X1 $T=751200 717040 1 180 $X=746850 $Y=716650
X938 691 652 677 1 2 667 NAND3X1 $T=755120 724880 1 180 $X=750770 $Y=724490
X939 664 701 677 1 2 704 NAND3X1 $T=755120 693520 1 0 $X=754690 $Y=688965
X940 706 692 695 1 2 697 NAND3X1 $T=759600 654320 1 180 $X=755250 $Y=653930
X941 707 684 696 1 2 645 NAND3X1 $T=759600 701360 0 180 $X=755250 $Y=696805
X942 724 721 690 1 2 717 NAND3X1 $T=763520 701360 1 180 $X=759170 $Y=700970
X943 731 712 700 1 2 725 NAND3X1 $T=765760 732720 1 180 $X=761410 $Y=732330
X944 623 727 683 1 2 713 NAND3X1 $T=766320 732720 0 180 $X=761970 $Y=728165
X945 723 737 743 1 2 736 NAND3X1 $T=763520 709200 0 0 $X=763090 $Y=708810
X946 716 648 702 1 2 742 NAND3X1 $T=764640 693520 1 0 $X=764210 $Y=688965
X947 747 742 735 1 2 730 NAND3X1 $T=769120 693520 1 180 $X=764770 $Y=693130
X948 766 716 727 1 2 750 NAND3X1 $T=771920 724880 0 180 $X=767570 $Y=720325
X949 766 745 727 1 2 622 NAND3X1 $T=772480 709200 1 180 $X=768130 $Y=708810
X950 767 623 683 1 2 762 NAND3X1 $T=772480 724880 1 180 $X=768130 $Y=724490
X951 763 748 768 1 2 771 NAND3X1 $T=769680 748400 1 0 $X=769250 $Y=743845
X952 770 716 683 1 2 746 NAND3X1 $T=775280 677840 1 180 $X=770930 $Y=677450
X953 782 777 640 1 2 773 NAND3X1 $T=776400 701360 1 180 $X=772050 $Y=700970
X954 766 745 722 1 2 737 NAND3X1 $T=776400 709200 1 180 $X=772050 $Y=708810
X955 772 623 684 1 2 735 NAND3X1 $T=777520 685680 0 180 $X=773170 $Y=681125
X956 769 778 702 1 2 744 NAND3X1 $T=778080 717040 1 180 $X=773730 $Y=716650
X957 788 778 660 1 2 786 NAND3X1 $T=778640 732720 0 180 $X=774290 $Y=728165
X958 756 776 786 1 2 789 NAND3X1 $T=774720 732720 0 0 $X=774290 $Y=732330
X959 660 758 702 1 2 672 NAND3X1 $T=780320 709200 1 180 $X=775970 $Y=708810
X960 797 784 787 1 2 790 NAND3X1 $T=780880 748400 0 180 $X=776530 $Y=743845
X961 623 793 780 1 2 796 NAND3X1 $T=783120 701360 0 180 $X=778770 $Y=696805
X962 803 799 796 1 2 729 NAND3X1 $T=783680 693520 0 180 $X=779330 $Y=688965
X963 804 794 798 1 2 802 NAND3X1 $T=784800 717040 0 180 $X=780450 $Y=712485
X964 837 833 830 1 2 835 NAND3X1 $T=810560 724880 0 180 $X=806210 $Y=720325
X965 847 843 839 1 2 841 NAND3X1 $T=813920 717040 1 180 $X=809570 $Y=716650
X966 848 844 817 1 2 842 NAND3X1 $T=813920 764080 0 180 $X=809570 $Y=759525
X967 858 854 820 1 2 852 NAND3X1 $T=818960 709200 0 180 $X=814610 $Y=704645
X968 871 850 860 1 2 864 NAND3X1 $T=824000 732720 1 180 $X=819650 $Y=732330
X969 872 853 873 1 2 880 NAND3X1 $T=823440 748400 0 0 $X=823010 $Y=748010
X970 884 888 859 1 2 893 NAND3X1 $T=830160 724880 0 0 $X=829730 $Y=724490
X971 896 908 912 1 2 906 NAND3X1 $T=840240 740560 0 0 $X=839810 $Y=740170
X972 922 901 895 1 2 913 NAND3X1 $T=847520 764080 1 180 $X=843170 $Y=763690
X973 915 903 924 1 2 923 NAND3X1 $T=844160 748400 1 0 $X=843730 $Y=743845
X974 973 967 962 1 2 948 NAND3X1 $T=869360 724880 1 180 $X=865010 $Y=724490
X975 966 960 976 1 2 949 NAND3X1 $T=865440 748400 1 0 $X=865010 $Y=743845
X976 975 952 965 1 2 950 NAND3X1 $T=869920 732720 1 180 $X=865570 $Y=732330
X977 986 981 1002 1 2 992 NAND3X1 $T=870480 795440 1 0 $X=870050 $Y=790885
X978 1008 993 996 1 2 969 NAND3X1 $T=876080 779760 1 180 $X=871730 $Y=779370
X979 1010 1004 980 1 2 962 NAND3X1 $T=876640 724880 1 180 $X=872290 $Y=724490
X980 1003 885 997 1 2 995 NAND3X1 $T=876640 732720 0 180 $X=872290 $Y=728165
X981 1018 955 991 1 2 1011 NAND3X1 $T=877760 756240 1 180 $X=873410 $Y=755850
X982 1001 1015 1017 1 2 1023 NAND3X1 $T=874400 717040 0 0 $X=873970 $Y=716650
X983 1026 1030 1046 1 2 994 NAND3X1 $T=877200 732720 0 0 $X=876770 $Y=732330
X984 1047 998 1027 1 2 1021 NAND3X1 $T=881680 756240 1 180 $X=877330 $Y=755850
X985 998 1042 1045 1 2 1046 NAND3X1 $T=878320 740560 1 0 $X=877890 $Y=736005
X986 1031 151 1057 1 2 1055 NAND3X1 $T=878880 638640 0 0 $X=878450 $Y=638250
X987 1035 1054 1058 1 2 996 NAND3X1 $T=878880 779760 0 0 $X=878450 $Y=779370
X988 1083 1068 1063 1 2 1024 NAND3X1 $T=887280 771920 1 180 $X=882930 $Y=771530
X989 978 963 1052 1 2 1081 NAND3X1 $T=888400 717040 0 180 $X=884050 $Y=712485
X990 1108 1100 157 1 2 142 NAND3X1 $T=891200 803280 0 180 $X=886850 $Y=798725
X991 1004 1066 885 1 2 1110 NAND3X1 $T=887840 748400 1 0 $X=887410 $Y=743845
X992 1101 1075 1005 1 2 1104 NAND3X1 $T=892320 717040 0 180 $X=887970 $Y=712485
X993 1107 1070 1133 1 2 1113 NAND3X1 $T=889520 795440 1 0 $X=889090 $Y=790885
X994 1130 169 1103 1 2 1088 NAND3X1 $T=894000 646480 0 180 $X=889650 $Y=641925
X995 1124 164 1103 1 2 1128 NAND3X1 $T=895120 654320 0 180 $X=890770 $Y=649765
X996 174 1128 1090 1 2 1120 NAND3X1 $T=895120 654320 1 180 $X=890770 $Y=653930
X997 173 1100 1058 1 2 1133 NAND3X1 $T=892880 803280 0 0 $X=892450 $Y=802890
X998 1141 1136 1109 1 2 1155 NAND3X1 $T=894000 709200 1 0 $X=893570 $Y=704645
X999 1121 1154 1161 1 2 1158 NAND3X1 $T=894560 740560 1 0 $X=894130 $Y=736005
X1000 1116 164 175 1 2 1164 NAND3X1 $T=895680 662160 1 0 $X=895250 $Y=657605
X1001 1173 1036 180 1 2 1174 NAND3X1 $T=898480 787600 0 0 $X=898050 $Y=787210
X1002 1170 978 980 1 2 1161 NAND3X1 $T=902960 740560 0 180 $X=898610 $Y=736005
X1003 1138 1164 1202 1 2 1176 NAND3X1 $T=899600 662160 1 0 $X=899170 $Y=657605
X1004 1197 1087 1162 1 2 1180 NAND3X1 $T=904080 638640 1 180 $X=899730 $Y=638250
X1005 1170 1040 1131 1 2 1182 NAND3X1 $T=904080 732720 1 180 $X=899730 $Y=732330
X1006 1153 1191 1192 1 2 985 NAND3X1 $T=900160 771920 0 0 $X=899730 $Y=771530
X1007 1009 957 1170 1 2 1206 NAND3X1 $T=901280 740560 0 0 $X=900850 $Y=740170
X1008 955 1041 1020 1 2 1205 NAND3X1 $T=906880 724880 0 180 $X=902530 $Y=720325
X1009 1124 184 1162 1 2 1202 NAND3X1 $T=907440 662160 0 180 $X=903090 $Y=657605
X1010 1146 1211 1206 1 2 1189 NAND3X1 $T=907440 756240 0 180 $X=903090 $Y=751685
X1011 1194 1166 1186 1 2 1215 NAND3X1 $T=907440 771920 0 180 $X=903090 $Y=767365
X1012 1156 1196 1214 1 2 1225 NAND3X1 $T=905760 764080 0 0 $X=905330 $Y=763690
X1013 1195 1227 1016 1 2 1229 NAND3X1 $T=907440 662160 1 0 $X=907010 $Y=657605
X1014 1235 169 1143 1 2 1232 NAND3X1 $T=913600 630800 0 180 $X=909250 $Y=626245
X1015 1242 1142 1182 1 2 1233 NAND3X1 $T=913600 740560 1 180 $X=909250 $Y=740170
X1016 1236 1188 1239 1 2 1246 NAND3X1 $T=910240 724880 1 0 $X=909810 $Y=720325
X1017 185 1228 1016 1 2 1256 NAND3X1 $T=913600 638640 1 0 $X=913170 $Y=634085
X1018 192 1232 1260 1 2 1263 NAND3X1 $T=916400 622960 0 0 $X=915970 $Y=622570
X1019 1204 184 1016 1 2 1260 NAND3X1 $T=920320 630800 1 180 $X=915970 $Y=630410
X1020 1258 1167 1266 1 2 1270 NAND3X1 $T=917520 795440 1 0 $X=917090 $Y=790885
X1021 1212 1261 1256 1 2 1276 NAND3X1 $T=920320 638640 1 0 $X=919890 $Y=634085
X1022 1279 1268 1229 1 2 1283 NAND3X1 $T=924240 662160 0 0 $X=923810 $Y=661770
X1023 1288 1289 1284 1 2 1286 NAND3X1 $T=930960 756240 0 180 $X=926610 $Y=751685
X1024 1340 1331 1325 1 2 738 NAND3X1 $T=954480 638640 1 180 $X=950130 $Y=638250
X1025 1313 1344 1352 1 2 1349 NAND3X1 $T=951680 771920 1 0 $X=951250 $Y=767365
X1026 1358 1353 1348 1 2 1329 NAND3X1 $T=957840 670000 0 180 $X=953490 $Y=665445
X1027 1362 1357 1350 1 2 1354 NAND3X1 $T=958960 622960 1 180 $X=954610 $Y=622570
X1028 1370 1378 1385 1 2 1389 NAND3X1 $T=959520 771920 1 0 $X=959090 $Y=767365
X1029 1419 1410 1403 1 2 1322 NAND3X1 $T=969600 662160 1 180 $X=965250 $Y=661770
X1030 1407 1366 1361 1 2 1423 NAND3X1 $T=968480 638640 0 0 $X=968050 $Y=638250
X1031 1439 1404 1416 1 2 1433 NAND3X1 $T=974080 771920 1 180 $X=969730 $Y=771530
X1032 1407 1361 1431 1 2 1420 NAND3X1 $T=975760 654320 1 180 $X=971410 $Y=653930
X1033 1449 1417 1437 1 2 1441 NAND3X1 $T=976880 748400 1 180 $X=972530 $Y=748010
X1034 1450 1408 1460 1 2 1456 NAND3X1 $T=975760 646480 1 0 $X=975330 $Y=641925
X1035 1444 1448 1452 1 2 1450 NAND3X1 $T=978000 654320 1 0 $X=977570 $Y=649765
X1036 1469 1443 1457 1 2 1462 NAND3X1 $T=982480 685680 0 180 $X=978130 $Y=681125
X1037 1458 1479 1484 1 2 1482 NAND3X1 $T=980800 764080 0 0 $X=980370 $Y=763690
X1038 1363 1407 1338 1 2 1460 NAND3X1 $T=985840 646480 0 180 $X=981490 $Y=641925
X1039 1481 1486 1494 1 2 1491 NAND3X1 $T=983040 732720 0 0 $X=982610 $Y=732330
X1040 1337 1492 1402 1 2 1497 NAND3X1 $T=984160 654320 1 0 $X=983730 $Y=649765
X1041 1356 1338 1431 1 2 1489 NAND3X1 $T=984160 662160 0 0 $X=983730 $Y=661770
X1042 1501 1496 1485 1 2 1490 NAND3X1 $T=989200 670000 1 180 $X=984850 $Y=669610
X1043 1521 1527 1533 1 2 1526 NAND3X1 $T=995920 764080 0 0 $X=995490 $Y=763690
X1044 1531 1537 1542 1 2 1522 NAND3X1 $T=998160 779760 1 0 $X=997730 $Y=775205
X1045 1563 1556 1547 1 2 650 NAND3X1 $T=1006560 740560 1 180 $X=1002210 $Y=740170
X1046 1569 1562 1552 1 2 1556 NAND3X1 $T=1007680 740560 0 180 $X=1003330 $Y=736005
X1047 1558 1568 1571 1 2 1564 NAND3X1 $T=1003760 764080 1 0 $X=1003330 $Y=759525
X1048 1574 1561 1559 1 2 1543 NAND3X1 $T=1008800 795440 0 180 $X=1004450 $Y=790885
X1049 1584 1555 1572 1 2 1558 NAND3X1 $T=1011600 771920 0 180 $X=1007250 $Y=767365
X1050 1554 1610 1552 1 2 1612 NAND3X1 $T=1017200 748400 1 180 $X=1012850 $Y=748010
X1051 1624 1617 1614 1 2 1591 NAND3X1 $T=1019440 764080 0 180 $X=1015090 $Y=759525
X1052 1551 1634 1438 1 2 1624 NAND3X1 $T=1023360 771920 0 180 $X=1019010 $Y=767365
X1053 1438 1572 1588 1 2 1639 NAND3X1 $T=1021120 756240 0 0 $X=1020690 $Y=755850
X1054 1609 1616 1530 1 2 1645 NAND3X1 $T=1022240 779760 1 0 $X=1021810 $Y=775205
X1055 1647 1438 1637 1 2 1547 NAND3X1 $T=1026720 748400 1 180 $X=1022370 $Y=748010
X1056 1640 1657 1661 1 2 1659 NAND3X1 $T=1027840 724880 1 0 $X=1027410 $Y=720325
X1057 1625 1658 1653 1 2 1542 NAND3X1 $T=1032320 771920 1 180 $X=1027970 $Y=771530
X1058 1668 1565 1650 1 2 1660 NAND3X1 $T=1034000 779760 1 180 $X=1029650 $Y=779370
X1059 1672 1666 1660 1 2 1539 NAND3X1 $T=1035120 787600 1 180 $X=1030770 $Y=787210
X1060 1651 1669 1304 1 2 1672 NAND3X1 $T=1031200 795440 1 0 $X=1030770 $Y=790885
X1061 1634 1304 1588 1 2 1675 NAND3X1 $T=1034560 764080 0 0 $X=1034130 $Y=763690
X1062 1677 1630 1296 1 2 1683 NAND3X1 $T=1035680 787600 1 0 $X=1035250 $Y=783045
X1063 1696 1562 1588 1 2 1703 NAND3X1 $T=1040720 764080 1 0 $X=1040290 $Y=759525
X1064 1688 1674 1703 1 2 1694 NAND3X1 $T=1041840 771920 1 0 $X=1041410 $Y=767365
X1065 1710 1679 1698 1 2 1699 NAND3X1 $T=1046320 732720 0 180 $X=1041970 $Y=728165
X1066 1730 1728 1724 1 2 1725 NAND3X1 $T=1059200 717040 0 180 $X=1054850 $Y=712485
X1067 1739 1736 1720 1 2 1734 NAND3X1 $T=1066480 701360 0 180 $X=1062130 $Y=696805
X1068 1740 1738 1733 1 2 1735 NAND3X1 $T=1067040 677840 1 180 $X=1062690 $Y=677450
X1069 1737 1752 1757 1 2 1758 NAND3X1 $T=1069280 740560 1 0 $X=1068850 $Y=736005
X1070 1761 1747 1749 1 2 1754 NAND3X1 $T=1073760 701360 1 180 $X=1069410 $Y=700970
X1071 1772 1783 1789 1 2 1785 NAND3X1 $T=1081600 670000 0 0 $X=1081170 $Y=669610
X1072 1791 1784 1780 1 2 1782 NAND3X1 $T=1086640 709200 0 180 $X=1082290 $Y=704645
X1073 1805 1802 1797 1 2 1803 NAND3X1 $T=1092240 685680 1 180 $X=1087890 $Y=685290
X1074 1800 1788 270 1 2 1806 NAND3X1 $T=1089440 622960 0 0 $X=1089010 $Y=622570
X1075 1801 1807 1796 1 2 1808 NAND3X1 $T=1091680 662160 1 0 $X=1091250 $Y=657605
X1076 1821 1815 1810 1 2 1811 NAND3X1 $T=1102320 662160 1 180 $X=1097970 $Y=661770
X1077 1843 275 1829 1 2 1832 NAND3X1 $T=1107920 803280 1 180 $X=1103570 $Y=802890
X1078 1836 1844 276 1 2 1842 NAND3X1 $T=1110160 638640 0 180 $X=1105810 $Y=634085
X1079 1853 1852 277 1 2 1850 NAND3X1 $T=1116880 622960 1 180 $X=1112530 $Y=622570
X1080 1864 278 1856 1 2 1859 NAND3X1 $T=1120800 803280 1 180 $X=1116450 $Y=802890
X1081 279 281 1866 1 2 1870 NAND3X1 $T=1118560 811120 0 0 $X=1118130 $Y=810730
X1082 1888 1881 284 1 2 1883 NAND3X1 $T=1134800 638640 1 180 $X=1130450 $Y=638250
X1083 1897 1894 286 1 2 1890 NAND3X1 $T=1138160 630800 0 180 $X=1133810 $Y=626245
X1084 1917 1879 1902 1 2 1911 NAND3X1 $T=1143760 764080 0 180 $X=1139410 $Y=759525
X1085 1913 1915 290 1 2 1923 NAND3X1 $T=1141520 622960 0 0 $X=1141090 $Y=622570
X1086 1924 1912 289 1 2 1920 NAND3X1 $T=1146560 646480 0 180 $X=1142210 $Y=641925
X1087 1936 1919 291 1 2 1930 NAND3X1 $T=1151600 638640 1 180 $X=1147250 $Y=638250
X1088 1950 1925 1941 1 2 1943 NAND3X1 $T=1156640 779760 1 180 $X=1152290 $Y=779370
X1089 1957 1954 1951 1 2 1953 NAND3X1 $T=1160560 740560 0 180 $X=1156210 $Y=736005
X1090 1982 294 1975 1 2 1955 NAND3X1 $T=1171200 622960 0 180 $X=1166850 $Y=618405
X1091 1988 1984 1977 1 2 1980 NAND3X1 $T=1172880 779760 1 180 $X=1168530 $Y=779370
X1092 1992 1976 1985 1 2 1986 NAND3X1 $T=1175120 740560 0 180 $X=1170770 $Y=736005
X1093 1981 1990 1978 1 2 1987 NAND3X1 $T=1175120 764080 1 180 $X=1170770 $Y=763690
X1094 2000 1994 1989 1 2 1959 NAND3X1 $T=1176240 646480 1 180 $X=1171890 $Y=646090
X1095 2015 2006 296 1 2 2009 NAND3X1 $T=1178480 654320 1 0 $X=1178050 $Y=649765
X1096 2027 2023 301 1 2 2014 NAND3X1 $T=1186320 646480 1 180 $X=1181970 $Y=646090
X1097 2003 2026 2022 1 2 2031 NAND3X1 $T=1182960 630800 1 0 $X=1182530 $Y=626245
X1098 2033 2036 304 1 2 2020 NAND3X1 $T=1190800 630800 1 180 $X=1186450 $Y=630410
X1099 2035 2041 1589 1 2 2027 NAND3X1 $T=1193040 646480 1 180 $X=1188690 $Y=646090
X1100 307 2043 306 1 2 2001 NAND3X1 $T=1194160 622960 0 180 $X=1189810 $Y=618405
X1101 2047 1553 209 1 2 2038 NAND3X1 $T=1194160 654320 1 180 $X=1189810 $Y=653930
X1102 2058 2053 2045 1 2 2024 NAND3X1 $T=1198080 630800 1 180 $X=1193730 $Y=630410
X1103 2061 2055 2037 1 2 2052 NAND3X1 $T=1198640 670000 1 180 $X=1194290 $Y=669610
X1104 310 2059 2054 1 2 2056 NAND3X1 $T=1199760 622960 1 180 $X=1195410 $Y=622570
X1105 2005 2041 1553 1 2 2071 NAND3X1 $T=1200320 638640 0 0 $X=1199890 $Y=638250
X1106 2030 2072 2070 1 2 2051 NAND3X1 $T=1204240 670000 0 180 $X=1199890 $Y=665445
X1107 2076 2073 2071 1 2 2042 NAND3X1 $T=1204800 622960 1 180 $X=1200450 $Y=622570
X1108 2079 2049 312 1 2 2062 NAND3X1 $T=1205360 622960 0 180 $X=1201010 $Y=618405
X1109 302 2079 209 1 2 2076 NAND3X1 $T=1205360 622960 1 0 $X=1204930 $Y=618405
X1110 2081 2089 2086 1 2 2091 NAND3X1 $T=1212640 646480 0 0 $X=1212210 $Y=646090
X1111 335 332 1 2 334 NOR2X1 $T=622400 646480 0 180 $X=619170 $Y=641925
X1112 343 348 1 2 349 NOR2X1 $T=626320 638640 0 0 $X=625890 $Y=638250
X1113 341 351 1 2 342 NOR2X1 $T=627440 646480 1 0 $X=627010 $Y=641925
X1114 350 349 1 2 351 NOR2X1 $T=628000 646480 0 0 $X=627570 $Y=646090
X1115 356 341 1 2 347 NOR2X1 $T=633040 638640 0 180 $X=629810 $Y=634085
X1116 353 358 1 2 350 NOR2X1 $T=630800 646480 0 0 $X=630370 $Y=646090
X1117 16 341 1 2 10 NOR2X1 $T=635840 622960 0 180 $X=632610 $Y=618405
X1118 356 22 1 2 23 NOR2X1 $T=644240 622960 0 180 $X=641010 $Y=618405
X1119 356 25 1 2 26 NOR2X1 $T=647600 622960 1 180 $X=644370 $Y=622570
X1120 378 28 1 2 345 NOR2X1 $T=644800 630800 0 0 $X=644370 $Y=630410
X1121 379 381 1 2 358 NOR2X1 $T=645920 646480 0 0 $X=645490 $Y=646090
X1122 20 13 1 2 380 NOR2X1 $T=649840 646480 0 180 $X=646610 $Y=641925
X1123 4 28 1 2 397 NOR2X1 $T=656000 630800 0 180 $X=652770 $Y=626245
X1124 4 352 1 2 398 NOR2X1 $T=656000 630800 1 180 $X=652770 $Y=630410
X1125 392 396 1 2 399 NOR2X1 $T=653200 646480 0 0 $X=652770 $Y=646090
X1126 398 397 1 2 401 NOR2X1 $T=654320 638640 0 0 $X=653890 $Y=638250
X1127 20 27 1 2 379 NOR2X1 $T=654320 646480 1 0 $X=653890 $Y=641925
X1128 31 401 1 2 403 NOR2X1 $T=659920 638640 1 180 $X=656690 $Y=638250
X1129 403 402 1 2 404 NOR2X1 $T=657120 646480 1 0 $X=656690 $Y=641925
X1130 397 35 1 2 416 NOR2X1 $T=662720 638640 1 0 $X=662290 $Y=634085
X1131 376 426 1 2 428 NOR2X1 $T=664400 654320 1 0 $X=663970 $Y=649765
X1132 433 39 1 2 439 NOR2X1 $T=667760 638640 0 0 $X=667330 $Y=638250
X1133 20 22 1 2 421 NOR2X1 $T=671680 630800 1 180 $X=668450 $Y=630410
X1134 633 629 1 2 630 NOR2X1 $T=745040 724880 1 180 $X=741810 $Y=724490
X1135 653 664 1 2 654 NOR2X1 $T=747280 693520 1 0 $X=746850 $Y=688965
X1136 665 654 1 2 635 NOR2X1 $T=750080 701360 0 180 $X=746850 $Y=696805
X1137 648 680 1 2 679 NOR2X1 $T=750640 685680 1 0 $X=750210 $Y=681125
X1138 683 676 1 2 680 NOR2X1 $T=754000 685680 1 180 $X=750770 $Y=685290
X1139 687 652 1 2 629 NOR2X1 $T=754560 717040 1 180 $X=751330 $Y=716650
X1140 681 688 1 2 685 NOR2X1 $T=751760 740560 1 0 $X=751330 $Y=736005
X1141 653 684 1 2 648 NOR2X1 $T=752320 693520 1 0 $X=751890 $Y=688965
X1142 687 676 1 2 694 NOR2X1 $T=756800 709200 1 180 $X=753570 $Y=708810
X1143 696 679 1 2 698 NOR2X1 $T=757920 685680 0 180 $X=754690 $Y=681125
X1144 660 634 1 2 688 NOR2X1 $T=755120 724880 0 0 $X=754690 $Y=724490
X1145 652 683 1 2 693 NOR2X1 $T=759600 709200 1 180 $X=756370 $Y=708810
X1146 699 691 1 2 715 NOR2X1 $T=761280 717040 1 180 $X=758050 $Y=716650
X1147 715 698 1 2 720 NOR2X1 $T=762400 685680 0 180 $X=759170 $Y=681125
X1148 687 722 1 2 665 NOR2X1 $T=759600 709200 0 0 $X=759170 $Y=708810
X1149 640 720 1 2 714 NOR2X1 $T=762960 685680 1 180 $X=759730 $Y=685290
X1150 677 702 1 2 707 NOR2X1 $T=764080 701360 1 0 $X=763650 $Y=696805
X1151 730 736 1 2 731 NOR2X1 $T=764080 724880 1 0 $X=763650 $Y=720325
X1152 717 755 1 2 756 NOR2X1 $T=768560 732720 0 0 $X=768130 $Y=732330
X1153 780 684 1 2 778 NOR2X1 $T=775840 701360 0 180 $X=772610 $Y=696805
X1154 653 727 1 2 767 NOR2X1 $T=775840 701360 1 0 $X=775410 $Y=696805
X1155 793 629 1 2 783 NOR2X1 $T=780320 724880 0 180 $X=777090 $Y=720325
X1156 758 660 1 2 745 NOR2X1 $T=788720 701360 1 180 $X=785490 $Y=700970
X1157 683 702 1 2 793 NOR2X1 $T=785920 717040 1 0 $X=785490 $Y=712485
X1158 948 950 1 2 868 NOR2X1 $T=862080 717040 0 0 $X=861650 $Y=716650
X1159 969 139 1 2 927 NOR2X1 $T=866560 787600 1 0 $X=866130 $Y=783045
X1160 983 989 1 2 987 NOR2X1 $T=869920 764080 0 0 $X=869490 $Y=763690
X1161 985 992 1 2 887 NOR2X1 $T=870480 779760 1 0 $X=870050 $Y=775205
X1162 145 1024 1 2 828 NOR2X1 $T=875520 771920 0 0 $X=875090 $Y=771530
X1163 980 976 1 2 1033 NOR2X1 $T=881120 748400 0 180 $X=877890 $Y=743845
X1164 963 978 1 2 1040 NOR2X1 $T=878880 717040 1 0 $X=878450 $Y=712485
X1165 1020 1052 1 2 1045 NOR2X1 $T=879440 709200 0 0 $X=879010 $Y=708810
X1166 1041 978 1 2 1042 NOR2X1 $T=883920 748400 0 180 $X=880690 $Y=743845
X1167 885 978 1 2 1027 NOR2X1 $T=884480 756240 1 180 $X=881250 $Y=755850
X1168 157 152 1 2 1060 NOR2X1 $T=882800 811120 0 0 $X=882370 $Y=810730
X1169 980 1066 1 2 1014 NOR2X1 $T=883920 748400 1 0 $X=883490 $Y=743845
X1170 1052 980 1 2 955 NOR2X1 $T=884480 709200 1 0 $X=884050 $Y=704645
X1171 1087 160 1 2 1057 NOR2X1 $T=887840 646480 0 180 $X=884610 $Y=641925
X1172 1014 1033 1 2 1082 NOR2X1 $T=885040 756240 0 0 $X=884610 $Y=755850
X1173 1041 1005 1 2 1064 NOR2X1 $T=890080 748400 1 180 $X=886850 $Y=748010
X1174 1111 1100 1 2 1093 NOR2X1 $T=891760 811120 0 180 $X=888530 $Y=806565
X1175 1106 1113 1 2 1083 NOR2X1 $T=889520 779760 1 0 $X=889090 $Y=775205
X1176 160 1103 1 2 1069 NOR2X1 $T=890080 638640 0 0 $X=889650 $Y=638250
X1177 885 1131 1 2 1062 NOR2X1 $T=891200 724880 0 0 $X=890770 $Y=724490
X1178 169 143 1 2 164 NOR2X1 $T=893440 622960 0 0 $X=893010 $Y=622570
X1179 165 1103 1 2 151 NOR2X1 $T=896240 638640 1 180 $X=893010 $Y=638250
X1180 885 1082 1 2 1149 NOR2X1 $T=894560 756240 0 0 $X=894130 $Y=755850
X1181 1111 1151 1 2 1106 NOR2X1 $T=894560 779760 1 0 $X=894130 $Y=775205
X1182 169 175 1 2 1135 NOR2X1 $T=895680 630800 1 0 $X=895250 $Y=626245
X1183 1028 1158 1 2 1156 NOR2X1 $T=895680 764080 1 0 $X=895250 $Y=759525
X1184 1143 163 1 2 1084 NOR2X1 $T=899040 630800 1 180 $X=895810 $Y=630410
X1185 1051 997 1 2 1170 NOR2X1 $T=900160 732720 1 180 $X=896930 $Y=732330
X1186 1051 1041 1 2 991 NOR2X1 $T=900720 724880 0 180 $X=897490 $Y=720325
X1187 1176 1181 1 2 1178 NOR2X1 $T=899040 662160 0 0 $X=898610 $Y=661770
X1188 1189 1200 1 2 1194 NOR2X1 $T=901280 756240 0 0 $X=900850 $Y=755850
X1189 1058 1012 1 2 176 NOR2X1 $T=901280 803280 0 0 $X=900850 $Y=802890
X1190 1197 181 1 2 1216 NOR2X1 $T=904080 622960 0 0 $X=903650 $Y=622570
X1191 160 1175 1 2 1213 NOR2X1 $T=904080 638640 0 0 $X=903650 $Y=638250
X1192 1190 1205 1 2 1220 NOR2X1 $T=904640 748400 0 0 $X=904210 $Y=748010
X1193 1175 175 1 2 185 NOR2X1 $T=908000 622960 0 180 $X=904770 $Y=618405
X1194 1108 170 1 2 154 NOR2X1 $T=909120 795440 1 180 $X=905890 $Y=795050
X1195 157 170 1 2 1207 NOR2X1 $T=909680 787600 1 180 $X=906450 $Y=787210
X1196 165 1087 1 2 1204 NOR2X1 $T=911360 638640 1 180 $X=908130 $Y=638250
X1197 1105 1233 1 2 1236 NOR2X1 $T=910240 748400 0 0 $X=909810 $Y=748010
X1198 1058 183 1 2 182 NOR2X1 $T=911360 803280 0 0 $X=910930 $Y=802890
X1199 1098 1274 1 2 1258 NOR2X1 $T=922560 811120 1 0 $X=922130 $Y=806565
X1200 1086 1263 1 2 1278 NOR2X1 $T=923120 622960 0 0 $X=922690 $Y=622570
X1201 196 1276 1 2 1277 NOR2X1 $T=923120 630800 0 0 $X=922690 $Y=630410
X1202 1044 1254 1 2 1279 NOR2X1 $T=923680 654320 0 0 $X=923250 $Y=653930
X1203 1320 1327 1 2 1324 NOR2X1 $T=949440 630800 0 0 $X=949010 $Y=630410
X1204 1332 1324 1 2 1326 NOR2X1 $T=952800 662160 0 180 $X=949570 $Y=657605
X1205 1333 1326 1 2 1323 NOR2X1 $T=952800 662160 1 180 $X=949570 $Y=661770
X1206 1341 1321 1 2 1339 NOR2X1 $T=954480 654320 0 180 $X=951250 $Y=649765
X1207 1338 1346 1 2 1320 NOR2X1 $T=952240 630800 1 0 $X=951810 $Y=626245
X1208 1339 1354 1 2 1340 NOR2X1 $T=954480 638640 0 0 $X=954050 $Y=638250
X1209 1372 1363 1 2 1341 NOR2X1 $T=961760 638640 0 180 $X=958530 $Y=634085
X1210 1356 1369 1 2 1367 NOR2X1 $T=959520 654320 1 0 $X=959090 $Y=649765
X1211 1388 1394 1 2 1333 NOR2X1 $T=961760 670000 1 0 $X=961330 $Y=665445
X1212 1338 1364 1 2 1395 NOR2X1 $T=962320 654320 1 0 $X=961890 $Y=649765
X1213 1369 1394 1 2 1397 NOR2X1 $T=962880 670000 0 0 $X=962450 $Y=669610
X1214 1395 1405 1 2 1369 NOR2X1 $T=965120 654320 1 0 $X=964690 $Y=649765
X1215 1418 1414 1 2 1348 NOR2X1 $T=969600 670000 0 180 $X=966370 $Y=665445
X1216 1420 1415 1 2 1414 NOR2X1 $T=969600 677840 0 180 $X=966370 $Y=673285
X1217 1399 1423 1 2 1418 NOR2X1 $T=967360 654320 0 0 $X=966930 $Y=653930
X1218 1361 1407 1 2 1413 NOR2X1 $T=972400 646480 0 180 $X=969170 $Y=641925
X1219 1338 1420 1 2 1440 NOR2X1 $T=975200 677840 0 180 $X=971970 $Y=673285
X1220 1392 1364 1 2 1429 NOR2X1 $T=975760 646480 0 180 $X=972530 $Y=641925
X1221 1445 1440 1 2 1442 NOR2X1 $T=975760 677840 1 180 $X=972530 $Y=677450
X1222 1446 1397 1 2 1443 NOR2X1 $T=975760 685680 0 180 $X=972530 $Y=681125
X1223 1434 1400 1 2 1446 NOR2X1 $T=974080 670000 0 0 $X=973650 $Y=669610
X1224 1431 1366 1 2 1363 NOR2X1 $T=975200 630800 0 0 $X=974770 $Y=630410
X1225 1452 1448 1 2 1451 NOR2X1 $T=978000 654320 0 180 $X=974770 $Y=649765
X1226 1461 1451 1 2 1371 NOR2X1 $T=978560 654320 0 0 $X=978130 $Y=653930
X1227 1466 1452 1 2 1434 NOR2X1 $T=981360 670000 0 180 $X=978130 $Y=665445
X1228 1462 1391 1 2 1465 NOR2X1 $T=978560 685680 0 0 $X=978130 $Y=685290
X1229 1467 1359 1 2 1448 NOR2X1 $T=981920 662160 0 180 $X=978690 $Y=657605
X1230 1338 1407 1 2 1351 NOR2X1 $T=982480 638640 1 180 $X=979250 $Y=638250
X1231 1454 1459 1 2 1473 NOR2X1 $T=983040 630800 0 180 $X=979810 $Y=626245
X1232 1363 1476 1 2 1478 NOR2X1 $T=984160 638640 0 180 $X=980930 $Y=634085
X1233 1431 1466 1 2 1467 NOR2X1 $T=981920 662160 1 0 $X=981490 $Y=657605
X1234 1478 1456 1 2 1483 NOR2X1 $T=985280 638640 1 180 $X=982050 $Y=638250
X1235 1425 1473 1 2 1476 NOR2X1 $T=983040 630800 1 0 $X=982610 $Y=626245
X1236 1539 1543 1 2 1507 NOR2X1 $T=999840 795440 1 0 $X=999410 $Y=790885
X1237 1554 1536 1 2 1541 NOR2X1 $T=1004880 748400 1 180 $X=1001650 $Y=748010
X1238 1538 1564 1 2 1563 NOR2X1 $T=1004880 748400 0 0 $X=1004450 $Y=748010
X1239 1572 1438 1 2 1554 NOR2X1 $T=1008240 764080 1 180 $X=1005010 $Y=763690
X1240 1304 1562 1 2 1580 NOR2X1 $T=1008800 740560 0 0 $X=1008370 $Y=740170
X1241 1587 1546 1 2 1555 NOR2X1 $T=1012720 756240 1 180 $X=1009490 $Y=755850
X1242 1592 1600 1 2 1574 NOR2X1 $T=1011600 795440 1 0 $X=1011170 $Y=790885
X1243 46 50 1 2 461 NOR2X1 $T=1012720 732720 1 0 $X=1012290 $Y=728165
X1244 1606 1582 1 2 1592 NOR2X1 $T=1015520 787600 1 180 $X=1012290 $Y=787210
X1245 1562 1438 1 2 1578 NOR2X1 $T=1014960 771920 1 0 $X=1014530 $Y=767365
X1246 1572 1616 1 2 1605 NOR2X1 $T=1015520 764080 0 0 $X=1015090 $Y=763690
X1247 1625 1618 1 2 1622 NOR2X1 $T=1019440 787600 0 180 $X=1016210 $Y=783045
X1248 1555 1622 1 2 1600 NOR2X1 $T=1016640 795440 1 0 $X=1016210 $Y=790885
X1249 1588 1630 1 2 1609 NOR2X1 $T=1022240 779760 0 180 $X=1019010 $Y=775205
X1250 1566 1618 1 2 1633 NOR2X1 $T=1019440 787600 1 0 $X=1019010 $Y=783045
X1251 1572 1551 1 2 1625 NOR2X1 $T=1021120 771920 0 0 $X=1020690 $Y=771530
X1252 1630 1639 1 2 1618 NOR2X1 $T=1021680 779760 0 0 $X=1021250 $Y=779370
X1253 1637 1530 1 2 1587 NOR2X1 $T=1025040 756240 0 0 $X=1024610 $Y=755850
X1254 1296 1530 1 2 1634 NOR2X1 $T=1027840 764080 1 180 $X=1024610 $Y=763690
X1255 1588 1616 1 2 1565 NOR2X1 $T=1030080 756240 0 0 $X=1029650 $Y=755850
X1256 1653 1633 1 2 1665 NOR2X1 $T=1034000 779760 0 180 $X=1030770 $Y=775205
X1257 1653 1304 1 2 1655 NOR2X1 $T=1035120 740560 0 180 $X=1031890 $Y=736005
X1258 1588 1304 1 2 1629 NOR2X1 $T=1032880 756240 0 0 $X=1032450 $Y=755850
X1259 1687 1671 1 2 1685 NOR2X1 $T=1040720 748400 0 180 $X=1037490 $Y=743845
X1260 1562 1675 1 2 1687 NOR2X1 $T=1041280 756240 0 180 $X=1038050 $Y=751685
X1261 1665 1694 1 2 1690 NOR2X1 $T=1039040 771920 1 0 $X=1038610 $Y=767365
X1262 43 213 1 2 40 NOR2X1 $T=1095600 677840 0 180 $X=1092370 $Y=673285
X1263 37 293 1 2 34 NOR2X1 $T=1162800 693520 1 180 $X=1159570 $Y=693130
X1264 2001 1995 1 2 1982 NOR2X1 $T=1176240 622960 0 180 $X=1173010 $Y=618405
X1265 2012 2014 1 2 1994 NOR2X1 $T=1177360 646480 0 0 $X=1176930 $Y=646090
X1266 2016 296 1 2 1996 NOR2X1 $T=1180720 630800 1 180 $X=1177490 $Y=630410
X1267 2020 2024 1 2 1958 NOR2X1 $T=1182400 638640 1 0 $X=1181970 $Y=634085
X1268 272 2007 1 2 2028 NOR2X1 $T=1186880 670000 0 180 $X=1183650 $Y=665445
X1269 2028 2003 1 2 2029 NOR2X1 $T=1186880 670000 1 180 $X=1183650 $Y=669610
X1270 2032 2034 1 2 2033 NOR2X1 $T=1185760 638640 1 0 $X=1185330 $Y=634085
X1271 305 2011 1 2 2032 NOR2X1 $T=1189680 646480 0 180 $X=1186450 $Y=641925
X1272 2021 2057 1 2 2025 NOR2X1 $T=1194720 646480 1 0 $X=1194290 $Y=641925
X1273 2056 2052 1 2 1775 NOR2X1 $T=1197520 677840 0 180 $X=1194290 $Y=673285
X1274 2066 2064 1 2 2060 NOR2X1 $T=1200320 646480 0 180 $X=1197090 $Y=641925
X1275 2068 309 1 2 2057 NOR2X1 $T=1200320 654320 0 180 $X=1197090 $Y=649765
X1276 2041 311 1 2 2069 NOR2X1 $T=1203120 646480 1 180 $X=1199890 $Y=646090
X1277 209 305 1 2 2041 NOR2X1 $T=1205360 638640 0 0 $X=1204930 $Y=638250
X1278 305 2080 1 2 2078 NOR2X1 $T=1208720 630800 1 180 $X=1205490 $Y=630410
X1279 1553 2021 1 2 2082 NOR2X1 $T=1207600 646480 1 0 $X=1207170 $Y=641925
X1280 2086 1553 1 2 2077 NOR2X1 $T=1211520 646480 1 180 $X=1208290 $Y=646090
X1281 272 2086 1 2 2049 NOR2X1 $T=1214320 630800 1 180 $X=1211090 $Y=630410
X1282 2088 2083 1 2 2072 NOR2X1 $T=1214880 670000 0 180 $X=1211650 $Y=665445
X1283 2085 1589 1 2 309 NOR2X1 $T=1215440 662160 0 180 $X=1212210 $Y=657605
X1284 209 2085 1 2 2088 NOR2X1 $T=1213200 662160 0 0 $X=1212770 $Y=661770
X1285 6 341 1 2 337 NAND2X1 $T=626880 638640 0 180 $X=623650 $Y=634085
X1286 344 5 1 2 7 NAND2X1 $T=627440 622960 1 180 $X=624210 $Y=622570
X1287 347 9 1 2 339 NAND2X1 $T=626880 638640 1 0 $X=626450 $Y=634085
X1288 22 9 1 2 354 NAND2X1 $T=642000 630800 0 180 $X=638770 $Y=626245
X1289 23 27 1 2 348 NAND2X1 $T=644240 646480 1 0 $X=643810 $Y=641925
X1290 381 29 1 2 395 NAND2X1 $T=654320 622960 1 180 $X=651090 $Y=622570
X1291 406 391 1 2 407 NAND2X1 $T=661040 630800 1 180 $X=657810 $Y=630410
X1292 407 31 1 2 410 NAND2X1 $T=662720 638640 1 180 $X=659490 $Y=638250
X1293 385 37 1 2 434 NAND2X1 $T=675600 732720 1 180 $X=672370 $Y=732330
X1294 461 414 1 2 458 NAND2X1 $T=678960 670000 1 180 $X=675730 $Y=669610
X1295 40 450 1 2 463 NAND2X1 $T=679520 732720 0 180 $X=676290 $Y=728165
X1296 461 423 1 2 469 NAND2X1 $T=681200 654320 1 180 $X=677970 $Y=653930
X1297 43 444 1 2 468 NAND2X1 $T=681200 717040 1 180 $X=677970 $Y=716650
X1298 471 468 1 2 470 NAND2X1 $T=681200 756240 1 180 $X=677970 $Y=755850
X1299 485 37 1 2 478 NAND2X1 $T=686240 771920 1 180 $X=683010 $Y=771530
X1300 46 45 1 2 487 NAND2X1 $T=687920 646480 1 180 $X=684690 $Y=646090
X1301 40 485 1 2 471 NAND2X1 $T=688480 756240 1 180 $X=685250 $Y=755850
X1302 463 496 1 2 495 NAND2X1 $T=687360 724880 0 0 $X=686930 $Y=724490
X1303 43 500 1 2 448 NAND2X1 $T=689040 701360 1 0 $X=688610 $Y=696805
X1304 43 501 1 2 481 NAND2X1 $T=689040 724880 1 0 $X=688610 $Y=720325
X1305 461 508 1 2 513 NAND2X1 $T=695200 677840 0 180 $X=691970 $Y=673285
X1306 43 512 1 2 504 NAND2X1 $T=692400 748400 1 0 $X=691970 $Y=743845
X1307 40 493 1 2 523 NAND2X1 $T=700800 779760 1 180 $X=697570 $Y=779370
X1308 34 49 1 2 535 NAND2X1 $T=703040 795440 0 0 $X=702610 $Y=795050
X1309 43 533 1 2 532 NAND2X1 $T=706960 748400 1 180 $X=703730 $Y=748010
X1310 36 59 1 2 540 NAND2X1 $T=704160 811120 0 0 $X=703730 $Y=810730
X1311 461 529 1 2 554 NAND2X1 $T=715360 638640 0 180 $X=712130 $Y=634085
X1312 461 561 1 2 562 NAND2X1 $T=716480 654320 1 0 $X=716050 $Y=649765
X1313 566 50 1 2 570 NAND2X1 $T=718720 654320 0 0 $X=718290 $Y=653930
X1314 50 63 1 2 559 NAND2X1 $T=722080 654320 0 180 $X=718850 $Y=649765
X1315 582 572 1 2 579 NAND2X1 $T=722640 787600 0 180 $X=719410 $Y=783045
X1316 40 546 1 2 577 NAND2X1 $T=723200 764080 0 180 $X=719970 $Y=759525
X1317 40 549 1 2 587 NAND2X1 $T=724880 764080 1 180 $X=721650 $Y=763690
X1318 40 558 1 2 592 NAND2X1 $T=727120 787600 1 0 $X=726690 $Y=783045
X1319 43 601 1 2 584 NAND2X1 $T=728800 748400 0 0 $X=728370 $Y=748010
X1320 600 604 1 2 602 NAND2X1 $T=729920 787600 1 0 $X=729490 $Y=783045
X1321 578 37 1 2 71 NAND2X1 $T=730480 803280 0 0 $X=730050 $Y=802890
X1322 618 50 1 2 616 NAND2X1 $T=741120 670000 1 180 $X=737890 $Y=669610
X1323 627 623 1 2 612 NAND2X1 $T=743920 717040 0 180 $X=740690 $Y=712485
X1324 43 607 1 2 597 NAND2X1 $T=741120 771920 0 0 $X=740690 $Y=771530
X1325 628 634 1 2 627 NAND2X1 $T=742240 717040 0 0 $X=741810 $Y=716650
X1326 46 77 1 2 624 NAND2X1 $T=743360 630800 1 0 $X=742930 $Y=626245
X1327 611 37 1 2 76 NAND2X1 $T=743360 811120 0 0 $X=742930 $Y=810730
X1328 641 629 1 2 637 NAND2X1 $T=746720 717040 0 180 $X=743490 $Y=712485
X1329 50 75 1 2 631 NAND2X1 $T=746160 670000 0 0 $X=745730 $Y=669610
X1330 461 642 1 2 639 NAND2X1 $T=751760 670000 1 180 $X=748530 $Y=669610
X1331 648 677 1 2 666 NAND2X1 $T=751200 709200 0 0 $X=750770 $Y=708810
X1332 461 595 1 2 692 NAND2X1 $T=752880 654320 0 0 $X=752450 $Y=653930
X1333 699 687 1 2 673 NAND2X1 $T=757360 717040 1 180 $X=754130 $Y=716650
X1334 708 652 1 2 712 NAND2X1 $T=760720 724880 1 180 $X=757490 $Y=724490
X1335 694 707 1 2 723 NAND2X1 $T=763520 709200 0 180 $X=760290 $Y=704645
X1336 40 79 1 2 734 NAND2X1 $T=766320 811120 0 180 $X=763090 $Y=806565
X1337 43 740 1 2 83 NAND2X1 $T=766880 795440 1 0 $X=766450 $Y=790885
X1338 778 687 1 2 634 NAND2X1 $T=778080 717040 0 0 $X=777650 $Y=716650
X1339 696 758 1 2 769 NAND2X1 $T=781440 709200 1 0 $X=781010 $Y=704645
X1340 461 774 1 2 797 NAND2X1 $T=784240 748400 0 0 $X=783810 $Y=748010
X1341 461 752 1 2 807 NAND2X1 $T=785360 748400 1 0 $X=784930 $Y=743845
X1342 806 745 1 2 803 NAND2X1 $T=785920 693520 0 0 $X=785490 $Y=693130
X1343 46 564 1 2 830 NAND2X1 $T=802720 701360 1 180 $X=799490 $Y=700970
X1344 461 849 1 2 847 NAND2X1 $T=816720 717040 1 180 $X=813490 $Y=716650
X1345 891 883 1 2 117 NAND2X1 $T=834080 622960 0 180 $X=830850 $Y=618405
X1346 461 829 1 2 888 NAND2X1 $T=833520 740560 1 0 $X=833090 $Y=736005
X1347 897 50 1 2 896 NAND2X1 $T=837440 740560 1 180 $X=834210 $Y=740170
X1348 113 911 1 2 907 NAND2X1 $T=841360 654320 1 0 $X=840930 $Y=649765
X1349 910 907 1 2 909 NAND2X1 $T=844160 662160 1 180 $X=840930 $Y=661770
X1350 914 920 1 2 918 NAND2X1 $T=844160 662160 0 0 $X=843730 $Y=661770
X1351 46 889 1 2 912 NAND2X1 $T=846960 717040 1 180 $X=843730 $Y=716650
X1352 126 911 1 2 914 NAND2X1 $T=849760 662160 1 180 $X=846530 $Y=661770
X1353 50 125 1 2 937 NAND2X1 $T=851440 740560 0 0 $X=851010 $Y=740170
X1354 461 886 1 2 932 NAND2X1 $T=856480 748400 0 180 $X=853250 $Y=743845
X1355 126 919 1 2 946 NAND2X1 $T=860960 677840 1 180 $X=857730 $Y=677450
X1356 113 958 1 2 954 NAND2X1 $T=863200 677840 1 0 $X=862770 $Y=673285
X1357 946 954 1 2 970 NAND2X1 $T=866000 677840 1 0 $X=865570 $Y=673285
X1358 968 974 1 2 971 NAND2X1 $T=866560 756240 0 0 $X=866130 $Y=755850
X1359 955 885 1 2 959 NAND2X1 $T=869920 732720 0 0 $X=869490 $Y=732330
X1360 978 982 1 2 1005 NAND2X1 $T=876080 709200 1 180 $X=872850 $Y=708810
X1361 955 1020 1 2 1017 NAND2X1 $T=874960 709200 1 0 $X=874530 $Y=704645
X1362 1014 1004 1 2 965 NAND2X1 $T=875520 748400 1 0 $X=875090 $Y=743845
X1363 1013 1012 1 2 990 NAND2X1 $T=878320 803280 0 180 $X=875090 $Y=798725
X1364 1023 1040 1 2 1026 NAND2X1 $T=878320 717040 0 0 $X=877890 $Y=716650
X1365 1005 1041 1 2 1034 NAND2X1 $T=878320 748400 0 0 $X=877890 $Y=748010
X1366 1029 156 1 2 1048 NAND2X1 $T=880000 795440 1 0 $X=879570 $Y=790885
X1367 1062 1052 1 2 1015 NAND2X1 $T=884480 717040 0 180 $X=881250 $Y=712485
X1368 1062 1045 1 2 951 NAND2X1 $T=884480 732720 0 180 $X=881250 $Y=728165
X1369 1078 152 1 2 1068 NAND2X1 $T=886720 779760 0 180 $X=883490 $Y=775205
X1370 1064 1014 1 2 1077 NAND2X1 $T=887280 748400 1 180 $X=884050 $Y=748010
X1371 1020 997 1 2 1096 NAND2X1 $T=887840 724880 0 0 $X=887410 $Y=724490
X1372 1077 1091 1 2 1105 NAND2X1 $T=891760 756240 0 180 $X=888530 $Y=751685
X1373 167 1111 1 2 168 NAND2X1 $T=890080 811120 0 0 $X=889650 $Y=810730
X1374 126 101 1 2 1134 NAND2X1 $T=894560 677840 0 180 $X=891330 $Y=673285
X1375 1104 1062 1 2 1139 NAND2X1 $T=892320 717040 1 0 $X=891890 $Y=712485
X1376 1140 151 1 2 1138 NAND2X1 $T=895680 662160 0 180 $X=892450 $Y=657605
X1377 1069 163 1 2 1102 NAND2X1 $T=896240 630800 1 180 $X=893010 $Y=630410
X1378 1145 1005 1 2 1160 NAND2X1 $T=896240 748400 0 0 $X=895810 $Y=748010
X1379 1168 170 1 2 1157 NAND2X1 $T=899600 803280 1 180 $X=896370 $Y=802890
X1380 1160 1110 1 2 1165 NAND2X1 $T=901840 748400 1 180 $X=898610 $Y=748010
X1381 971 978 1 2 1186 NAND2X1 $T=902400 756240 0 180 $X=899170 $Y=751685
X1382 1155 980 1 2 1188 NAND2X1 $T=902960 709200 0 180 $X=899730 $Y=704645
X1383 126 958 1 2 1199 NAND2X1 $T=904640 685680 1 180 $X=901410 $Y=685290
X1384 1207 182 1 2 1179 NAND2X1 $T=904640 779760 1 180 $X=901410 $Y=779370
X1385 154 1059 1 2 1201 NAND2X1 $T=901840 795440 0 0 $X=901410 $Y=795050
X1386 1173 156 1 2 1208 NAND2X1 $T=902400 787600 0 0 $X=901970 $Y=787210
X1387 1184 143 1 2 1212 NAND2X1 $T=904080 630800 0 0 $X=903650 $Y=630410
X1388 1217 1040 1 2 1214 NAND2X1 $T=906880 732720 1 180 $X=903650 $Y=732330
X1389 1198 1205 1 2 1217 NAND2X1 $T=905760 732720 1 0 $X=905330 $Y=728165
X1390 113 1241 1 2 1237 NAND2X1 $T=909680 685680 1 0 $X=909250 $Y=681125
X1391 1207 1108 1 2 1243 NAND2X1 $T=910800 779760 0 0 $X=910370 $Y=779370
X1392 1163 1224 1 2 1227 NAND2X1 $T=914160 662160 0 180 $X=910930 $Y=657605
X1393 1123 1238 1 2 1230 NAND2X1 $T=914720 795440 0 180 $X=911490 $Y=790885
X1394 1163 1228 1 2 1124 NAND2X1 $T=912480 646480 0 0 $X=912050 $Y=646090
X1395 180 1108 1 2 1250 NAND2X1 $T=913600 779760 0 0 $X=913170 $Y=779370
X1396 1235 1124 1 2 1247 NAND2X1 $T=916960 662160 0 180 $X=913730 $Y=657605
X1397 1244 1016 1 2 1257 NAND2X1 $T=918080 670000 0 180 $X=914850 $Y=665445
X1398 1264 1103 1 2 1261 NAND2X1 $T=920320 638640 0 180 $X=917090 $Y=634085
X1399 184 1103 1 2 1271 NAND2X1 $T=921440 662160 1 0 $X=921010 $Y=657605
X1400 1282 1280 1 2 1281 NAND2X1 $T=927600 670000 0 180 $X=924370 $Y=665445
X1401 113 1072 1 2 1285 NAND2X1 $T=929280 677840 1 180 $X=926050 $Y=677450
X1402 1290 1285 1 2 1287 NAND2X1 $T=929840 685680 0 180 $X=926610 $Y=681125
X1403 1293 50 1 2 1288 NAND2X1 $T=929840 764080 0 180 $X=926610 $Y=759525
X1404 461 1275 1 2 1295 NAND2X1 $T=936560 764080 1 180 $X=933330 $Y=763690
X1405 126 1301 1 2 1290 NAND2X1 $T=935440 685680 1 0 $X=935010 $Y=681125
X1406 46 1292 1 2 1300 NAND2X1 $T=935440 732720 0 0 $X=935010 $Y=732330
X1407 1315 50 1 2 1313 NAND2X1 $T=948320 771920 0 180 $X=945090 $Y=767365
X1408 1345 1341 1 2 1355 NAND2X1 $T=957840 662160 0 180 $X=954610 $Y=657605
X1409 1364 1361 1 2 1332 NAND2X1 $T=959520 654320 0 180 $X=956290 $Y=649765
X1410 1367 1341 1 2 1357 NAND2X1 $T=960080 638640 1 180 $X=956850 $Y=638250
X1411 113 1301 1 2 1365 NAND2X1 $T=960080 693520 0 180 $X=956850 $Y=688965
X1412 1381 1363 1 2 1325 NAND2X1 $T=962880 638640 1 180 $X=959650 $Y=638250
X1413 1382 1365 1 2 1377 NAND2X1 $T=962880 693520 0 180 $X=959650 $Y=688965
X1414 1393 1400 1 2 1381 NAND2X1 $T=962880 638640 0 0 $X=962450 $Y=638250
X1415 126 1241 1 2 1398 NAND2X1 $T=965680 693520 0 180 $X=962450 $Y=688965
X1416 1413 1338 1 2 1393 NAND2X1 $T=968480 638640 1 180 $X=965250 $Y=638250
X1417 1425 1372 1 2 1410 NAND2X1 $T=970720 630800 1 180 $X=967490 $Y=630410
X1418 1429 1434 1 2 1390 NAND2X1 $T=970160 670000 0 0 $X=969730 $Y=669610
X1419 1429 1407 1 2 1328 NAND2X1 $T=978560 654320 1 180 $X=975330 $Y=653930
X1420 46 1435 1 2 1437 NAND2X1 $T=977440 732720 0 0 $X=977010 $Y=732330
X1421 461 1406 1 2 1458 NAND2X1 $T=980240 771920 0 180 $X=977010 $Y=767365
X1422 1493 1452 1 2 1492 NAND2X1 $T=988080 638640 1 180 $X=984850 $Y=638250
X1423 1506 1392 1 2 1504 NAND2X1 $T=990880 646480 0 0 $X=990450 $Y=646090
X1424 1508 1489 1 2 1512 NAND2X1 $T=995360 662160 0 180 $X=992130 $Y=657605
X1425 1513 1392 1 2 1334 NAND2X1 $T=995360 670000 1 180 $X=992130 $Y=669610
X1426 1505 1364 1 2 1514 NAND2X1 $T=994240 646480 1 0 $X=993810 $Y=641925
X1427 1519 1388 1 2 1518 NAND2X1 $T=997040 654320 0 180 $X=993810 $Y=649765
X1428 1498 1520 1 2 1519 NAND2X1 $T=995360 662160 1 0 $X=994930 $Y=657605
X1429 1529 1515 1 2 1525 NAND2X1 $T=999280 693520 1 180 $X=996050 $Y=693130
X1430 1536 1544 1 2 1533 NAND2X1 $T=999840 764080 1 0 $X=999410 $Y=759525
X1431 46 1471 1 2 1502 NAND2X1 $T=1000400 732720 0 0 $X=999970 $Y=732330
X1432 1549 1555 1 2 1537 NAND2X1 $T=1002080 779760 1 0 $X=1001650 $Y=775205
X1433 1566 1550 1 2 1561 NAND2X1 $T=1006560 787600 0 180 $X=1003330 $Y=783045
X1434 1565 1562 1 2 1567 NAND2X1 $T=1004880 771920 1 0 $X=1004450 $Y=767365
X1435 1576 1554 1 2 1559 NAND2X1 $T=1009360 787600 0 180 $X=1006130 $Y=783045
X1436 1583 1588 1 2 1535 NAND2X1 $T=1009920 756240 1 0 $X=1009490 $Y=751685
X1437 1398 1597 1 2 1590 NAND2X1 $T=1011040 685680 0 0 $X=1010610 $Y=685290
X1438 1627 1620 1 2 1623 NAND2X1 $T=1020000 630800 0 180 $X=1016770 $Y=626245
X1439 113 1608 1 2 1620 NAND2X1 $T=1020000 638640 1 180 $X=1016770 $Y=638250
X1440 113 1524 1 2 1602 NAND2X1 $T=1017200 654320 0 0 $X=1016770 $Y=653930
X1441 1629 1587 1 2 1614 NAND2X1 $T=1021120 756240 1 180 $X=1017890 $Y=755850
X1442 1565 1611 1 2 1617 NAND2X1 $T=1022240 748400 1 180 $X=1019010 $Y=748010
X1443 1618 1296 1 2 1579 NAND2X1 $T=1021120 787600 0 0 $X=1020690 $Y=787210
X1444 1632 50 1 2 1640 NAND2X1 $T=1022240 724880 1 0 $X=1021810 $Y=720325
X1445 126 1528 1 2 1643 NAND2X1 $T=1026160 677840 0 180 $X=1022930 $Y=673285
X1446 1612 1662 1 2 1671 NAND2X1 $T=1032320 748400 1 0 $X=1031890 $Y=743845
X1447 126 1604 1 2 242 NAND2X1 $T=1036240 654320 1 180 $X=1033010 $Y=653930
X1448 1642 1565 1 2 1676 NAND2X1 $T=1037920 748400 0 180 $X=1034690 $Y=743845
X1449 1680 1616 1 2 1666 NAND2X1 $T=1038480 771920 1 180 $X=1035250 $Y=771530
X1450 1562 1653 1 2 1677 NAND2X1 $T=1039040 779760 1 180 $X=1035810 $Y=779370
X1451 1296 1588 1 2 1682 NAND2X1 $T=1039600 787600 1 180 $X=1036370 $Y=787210
X1452 43 1670 1 2 243 NAND2X1 $T=1037360 811120 0 0 $X=1036930 $Y=810730
X1453 1562 1682 1 2 1669 NAND2X1 $T=1040720 795440 0 180 $X=1037490 $Y=790885
X1454 1695 1678 1 2 1696 NAND2X1 $T=1045760 756240 1 180 $X=1042530 $Y=755850
X1455 113 1707 1 2 1692 NAND2X1 $T=1045200 638640 0 0 $X=1044770 $Y=638250
X1456 1717 1697 1 2 1715 NAND2X1 $T=1048560 685680 1 180 $X=1045330 $Y=685290
X1457 43 1704 1 2 1722 NAND2X1 $T=1054720 811120 0 180 $X=1051490 $Y=806565
X1458 461 1203 1 2 1736 NAND2X1 $T=1065920 701360 1 180 $X=1062690 $Y=700970
X1459 1741 50 1 2 1740 NAND2X1 $T=1067600 670000 1 180 $X=1064370 $Y=669610
X1460 1742 50 1 2 1739 NAND2X1 $T=1068160 693520 1 180 $X=1064930 $Y=693130
X1461 46 1732 1 2 1749 NAND2X1 $T=1070960 693520 1 180 $X=1067730 $Y=693130
X1462 50 1560 1 2 1752 NAND2X1 $T=1068720 732720 0 0 $X=1068290 $Y=732330
X1463 46 1760 1 2 1757 NAND2X1 $T=1070960 693520 0 0 $X=1070530 $Y=693130
X1464 126 1707 1 2 260 NAND2X1 $T=1078240 622960 0 180 $X=1075010 $Y=618405
X1465 43 1751 1 2 1769 NAND2X1 $T=1075440 787600 0 0 $X=1075010 $Y=787210
X1466 1774 1769 1 2 1773 NAND2X1 $T=1081040 787600 1 180 $X=1077810 $Y=787210
X1467 1776 1778 1 2 1777 NAND2X1 $T=1079920 803280 1 0 $X=1079490 $Y=798725
X1468 46 1753 1 2 1780 NAND2X1 $T=1082160 685680 0 0 $X=1081730 $Y=685290
X1469 43 1766 1 2 1786 NAND2X1 $T=1086080 787600 0 180 $X=1082850 $Y=783045
X1470 461 257 1 2 1788 NAND2X1 $T=1083840 622960 0 0 $X=1083410 $Y=622570
X1471 46 266 1 2 1789 NAND2X1 $T=1083840 662160 1 0 $X=1083410 $Y=657605
X1472 46 267 1 2 1796 NAND2X1 $T=1086640 622960 0 0 $X=1086210 $Y=622570
X1473 43 1798 1 2 1778 NAND2X1 $T=1088320 764080 1 0 $X=1087890 $Y=759525
X1474 461 1770 1 2 1807 NAND2X1 $T=1095600 662160 1 180 $X=1092370 $Y=661770
X1475 43 1795 1 2 1813 NAND2X1 $T=1098400 748400 1 0 $X=1097970 $Y=743845
X1476 50 1596 1 2 1815 NAND2X1 $T=1100640 654320 0 0 $X=1100210 $Y=653930
X1477 40 1828 1 2 1819 NAND2X1 $T=1101760 787600 0 0 $X=1101330 $Y=787210
X1478 40 1822 1 2 1816 NAND2X1 $T=1104560 787600 0 0 $X=1104130 $Y=787210
X1479 1841 37 1 2 1829 NAND2X1 $T=1107920 803280 0 180 $X=1104690 $Y=798725
X1480 50 257 1 2 1852 NAND2X1 $T=1115760 622960 0 180 $X=1112530 $Y=618405
X1481 43 1839 1 2 1862 NAND2X1 $T=1117440 740560 1 0 $X=1117010 $Y=736005
X1482 1845 37 1 2 282 NAND2X1 $T=1122480 795440 0 180 $X=1119250 $Y=790885
X1483 36 1847 1 2 1879 NAND2X1 $T=1128640 803280 0 180 $X=1125410 $Y=798725
X1484 34 1882 1 2 1864 NAND2X1 $T=1128640 803280 1 0 $X=1128210 $Y=798725
X1485 34 285 1 2 1884 NAND2X1 $T=1133680 787600 1 180 $X=1130450 $Y=787210
X1486 1900 1889 1 2 1895 NAND2X1 $T=1138720 709200 0 180 $X=1135490 $Y=704645
X1487 461 1904 1 2 1888 NAND2X1 $T=1137040 646480 1 0 $X=1136610 $Y=641925
X1488 461 898 1 2 1894 NAND2X1 $T=1140960 630800 0 180 $X=1137730 $Y=626245
X1489 40 1903 1 2 1892 NAND2X1 $T=1141520 740560 0 180 $X=1138290 $Y=736005
X1490 1910 37 1 2 1906 NAND2X1 $T=1141520 748400 1 180 $X=1138290 $Y=748010
X1491 1907 1906 1 2 1908 NAND2X1 $T=1141520 779760 0 180 $X=1138290 $Y=775205
X1492 34 1909 1 2 1907 NAND2X1 $T=1142080 787600 1 180 $X=1138850 $Y=787210
X1493 50 898 1 2 1912 NAND2X1 $T=1142640 646480 0 180 $X=1139410 $Y=641925
X1494 1933 50 1 2 1913 NAND2X1 $T=1151040 622960 1 180 $X=1147810 $Y=622570
X1495 461 1944 1 2 1936 NAND2X1 $T=1151600 638640 0 0 $X=1151170 $Y=638250
X1496 43 1945 1 2 1938 NAND2X1 $T=1151600 701360 1 0 $X=1151170 $Y=696805
X1497 1939 37 1 2 1941 NAND2X1 $T=1152720 779760 1 0 $X=1152290 $Y=775205
X1498 1918 37 1 2 1951 NAND2X1 $T=1157200 724880 0 0 $X=1156770 $Y=724490
X1499 34 1940 1 2 1960 NAND2X1 $T=1161120 779760 0 180 $X=1157890 $Y=775205
X1500 1969 1921 1 2 1965 NAND2X1 $T=1166160 717040 1 180 $X=1162930 $Y=716650
X1501 40 1974 1 2 1971 NAND2X1 $T=1165040 764080 1 0 $X=1164610 $Y=759525
X1502 1971 1967 1 2 1973 NAND2X1 $T=1168400 748400 0 180 $X=1165170 $Y=743845
X1503 1974 37 1 2 1977 NAND2X1 $T=1169520 779760 0 180 $X=1166290 $Y=775205
X1504 1979 37 1 2 1978 NAND2X1 $T=1170640 764080 0 180 $X=1167410 $Y=759525
X1505 34 1983 1 2 1981 NAND2X1 $T=1168400 764080 0 0 $X=1167970 $Y=763690
X1506 34 1993 1 2 1992 NAND2X1 $T=1171760 740560 0 0 $X=1171330 $Y=740170
X1507 2009 2005 1 2 1989 NAND2X1 $T=1178480 654320 0 180 $X=1175250 $Y=649765
X1508 2048 2040 1 2 2043 NAND2X1 $T=1194720 622960 1 180 $X=1191490 $Y=622570
X1509 2082 299 1 2 2073 NAND2X1 $T=1211520 630800 1 180 $X=1208290 $Y=630410
X1510 2079 2086 1 2 314 NAND2X1 $T=1209280 622960 1 0 $X=1208850 $Y=618405
X1511 2021 2085 1 2 2089 NAND2X1 $T=1216560 654320 0 180 $X=1213330 $Y=649765
X1512 2091 302 1 2 2090 NAND2X1 $T=1217120 630800 1 180 $X=1213890 $Y=630410
X1513 17 357 355 1 2 370 MUX2X1 $T=634160 638640 1 0 $X=633730 $Y=634085
X1514 414 42 445 1 2 442 MUX2X1 $T=677280 693520 1 180 $X=671250 $Y=693130
X1515 423 42 444 1 2 449 MUX2X1 $T=679520 677840 1 180 $X=673490 $Y=677450
X1516 486 42 480 1 2 476 MUX2X1 $T=688480 677840 1 180 $X=682450 $Y=677450
X1517 519 42 512 1 2 509 MUX2X1 $T=698000 732720 0 180 $X=691970 $Y=728165
X1518 52 42 503 1 2 514 MUX2X1 $T=700240 701360 0 180 $X=694210 $Y=696805
X1519 508 42 500 1 2 524 MUX2X1 $T=695200 685680 0 0 $X=694770 $Y=685290
X1520 529 42 501 1 2 542 MUX2X1 $T=701360 717040 1 0 $X=700930 $Y=712485
X1521 541 42 531 1 2 567 MUX2X1 $T=712560 693520 0 0 $X=712130 $Y=693130
X1522 63 42 506 1 2 557 MUX2X1 $T=718720 717040 0 180 $X=712690 $Y=712485
X1523 561 42 533 1 2 571 MUX2X1 $T=713680 701360 0 0 $X=713250 $Y=700970
X1524 66 67 564 1 2 563 MUX2X1 $T=721520 693520 0 180 $X=715490 $Y=688965
X1525 521 42 569 1 2 565 MUX2X1 $T=722640 724880 1 180 $X=716610 $Y=724490
X1526 595 42 589 1 2 585 MUX2X1 $T=728240 732720 1 180 $X=722210 $Y=732330
X1527 75 42 601 1 2 647 MUX2X1 $T=741120 740560 1 0 $X=740690 $Y=736005
X1528 642 42 607 1 2 670 MUX2X1 $T=744480 748400 0 0 $X=744050 $Y=748010
X1529 643 42 606 1 2 671 MUX2X1 $T=744480 771920 1 0 $X=744050 $Y=767365
X1530 80 67 674 1 2 668 MUX2X1 $T=755120 622960 1 180 $X=749090 $Y=622570
X1531 81 67 593 1 2 669 MUX2X1 $T=755120 638640 0 180 $X=749090 $Y=634085
X1532 653 702 684 1 2 701 MUX2X1 $T=764640 693520 0 180 $X=758610 $Y=688965
X1533 752 42 689 1 2 732 MUX2X1 $T=770240 764080 0 180 $X=764210 $Y=759525
X1534 709 42 740 1 2 733 MUX2X1 $T=770240 771920 1 180 $X=764210 $Y=771530
X1535 84 67 759 1 2 753 MUX2X1 $T=774720 654320 0 180 $X=768690 $Y=649765
X1536 774 42 644 1 2 754 MUX2X1 $T=774720 779760 0 180 $X=768690 $Y=775205
X1537 785 42 779 1 2 775 MUX2X1 $T=778640 795440 0 180 $X=772610 $Y=790885
X1538 85 67 711 1 2 795 MUX2X1 $T=774720 630800 0 0 $X=774290 $Y=630410
X1539 86 67 710 1 2 801 MUX2X1 $T=776400 630800 1 0 $X=775970 $Y=626245
X1540 88 67 815 1 2 816 MUX2X1 $T=788720 630800 0 0 $X=788290 $Y=630410
X1541 89 67 781 1 2 814 MUX2X1 $T=796000 654320 0 180 $X=789970 $Y=649765
X1542 64 42 92 1 2 825 MUX2X1 $T=794320 764080 1 0 $X=793890 $Y=759525
X1543 826 42 90 1 2 818 MUX2X1 $T=801040 787600 1 180 $X=795010 $Y=787210
X1544 829 42 91 1 2 819 MUX2X1 $T=801600 811120 0 180 $X=795570 $Y=806565
X1545 831 42 93 1 2 821 MUX2X1 $T=802720 803280 0 180 $X=796690 $Y=798725
X1546 100 67 840 1 2 836 MUX2X1 $T=815040 662160 1 180 $X=809010 $Y=661770
X1547 99 67 855 1 2 857 MUX2X1 $T=812240 646480 0 0 $X=811810 $Y=646090
X1548 103 105 101 1 2 845 MUX2X1 $T=818400 630800 1 180 $X=812370 $Y=630410
X1549 103 67 827 1 2 846 MUX2X1 $T=818400 677840 0 180 $X=812370 $Y=673285
X1550 849 42 96 1 2 861 MUX2X1 $T=815040 803280 0 0 $X=814610 $Y=802890
X1551 108 67 867 1 2 863 MUX2X1 $T=826240 646480 1 180 $X=820210 $Y=646090
X1552 109 67 869 1 2 865 MUX2X1 $T=826800 677840 0 180 $X=820770 $Y=673285
X1553 876 42 107 1 2 870 MUX2X1 $T=827920 787600 0 180 $X=821890 $Y=783045
X1554 116 67 894 1 2 892 MUX2X1 $T=838560 701360 0 180 $X=832530 $Y=696805
X1555 862 42 119 1 2 900 MUX2X1 $T=842480 803280 0 180 $X=836450 $Y=798725
X1556 108 105 114 1 2 916 MUX2X1 $T=840240 638640 1 0 $X=839810 $Y=634085
X1557 109 105 911 1 2 917 MUX2X1 $T=840240 638640 0 0 $X=839810 $Y=638250
X1558 121 67 905 1 2 904 MUX2X1 $T=846400 693520 1 180 $X=840370 $Y=693130
X1559 116 105 919 1 2 921 MUX2X1 $T=841360 677840 0 0 $X=840930 $Y=677450
X1560 886 42 123 1 2 122 MUX2X1 $T=850320 811120 1 180 $X=844290 $Y=810730
X1561 882 42 111 1 2 934 MUX2X1 $T=845280 803280 1 0 $X=844850 $Y=798725
X1562 124 67 889 1 2 936 MUX2X1 $T=846400 693520 0 0 $X=845970 $Y=693130
X1563 129 67 925 1 2 928 MUX2X1 $T=854240 701360 0 180 $X=848210 $Y=696805
X1564 939 67 931 1 2 929 MUX2X1 $T=854800 709200 0 180 $X=848770 $Y=704645
X1565 838 42 131 1 2 942 MUX2X1 $T=851440 787600 1 0 $X=851010 $Y=783045
X1566 926 42 130 1 2 128 MUX2X1 $T=857040 811120 1 180 $X=851010 $Y=810730
X1567 121 105 940 1 2 961 MUX2X1 $T=860400 646480 1 0 $X=859970 $Y=641925
X1568 124 105 930 1 2 977 MUX2X1 $T=874960 654320 1 180 $X=868930 $Y=653930
X1569 129 105 958 1 2 1007 MUX2X1 $T=869920 677840 1 0 $X=869490 $Y=673285
X1570 939 105 1115 1 2 1147 MUX2X1 $T=890640 685680 0 0 $X=890210 $Y=685290
X1571 172 1092 1123 1 2 1137 MUX2X1 $T=892880 787600 0 0 $X=892450 $Y=787210
X1572 1209 1197 1159 1 2 1177 MUX2X1 $T=905760 646480 1 180 $X=899730 $Y=646090
X1573 197 105 1072 1 2 1273 MUX2X1 $T=927040 685680 0 180 $X=921010 $Y=681125
X1574 197 67 1291 1 2 1294 MUX2X1 $T=924800 709200 1 0 $X=924370 $Y=704645
X1575 1275 42 201 1 2 200 MUX2X1 $T=935440 803280 1 180 $X=929410 $Y=802890
X1576 204 105 1301 1 2 1303 MUX2X1 $T=943840 693520 1 180 $X=937810 $Y=693130
X1577 204 67 1292 1 2 1311 MUX2X1 $T=938800 724880 1 0 $X=938370 $Y=720325
X1578 1309 105 1241 1 2 1305 MUX2X1 $T=944960 709200 1 180 $X=938930 $Y=708810
X1579 1309 67 1308 1 2 1307 MUX2X1 $T=945520 732720 1 180 $X=939490 $Y=732330
X1580 1298 42 210 1 2 1316 MUX2X1 $T=953360 795440 1 180 $X=947330 $Y=795050
X1581 1336 42 203 1 2 1317 MUX2X1 $T=953360 803280 1 180 $X=947330 $Y=802890
X1582 1332 1338 1328 1 2 1321 MUX2X1 $T=955600 654320 1 180 $X=949570 $Y=653930
X1583 1306 42 212 1 2 1376 MUX2X1 $T=956160 803280 0 0 $X=955730 $Y=802890
X1584 1401 105 1343 1 2 1375 MUX2X1 $T=966800 709200 0 180 $X=960770 $Y=704645
X1585 215 67 1335 1 2 1383 MUX2X1 $T=967360 717040 1 180 $X=961330 $Y=716650
X1586 1368 67 1386 1 2 1384 MUX2X1 $T=967360 732720 0 180 $X=961330 $Y=728165
X1587 214 213 1368 1 2 218 MUX2X1 $T=962320 622960 1 0 $X=961890 $Y=618405
X1588 1401 67 1421 1 2 1426 MUX2X1 $T=964560 740560 1 0 $X=964130 $Y=736005
X1589 1368 105 1430 1 2 1447 MUX2X1 $T=970160 701360 1 0 $X=969730 $Y=696805
X1590 219 67 1435 1 2 1468 MUX2X1 $T=975760 709200 0 0 $X=975330 $Y=708810
X1591 1409 42 220 1 2 1453 MUX2X1 $T=982480 795440 0 180 $X=976450 $Y=790885
X1592 1406 42 223 1 2 221 MUX2X1 $T=985280 811120 1 180 $X=979250 $Y=810730
X1593 225 67 1480 1 2 1477 MUX2X1 $T=987520 693520 1 180 $X=981490 $Y=693130
X1594 215 105 1528 1 2 1532 MUX2X1 $T=994240 685680 1 0 $X=993810 $Y=681125
X1595 1463 42 234 1 2 1570 MUX2X1 $T=1001520 803280 1 0 $X=1001090 $Y=798725
X1596 233 67 1471 1 2 1581 MUX2X1 $T=1004320 709200 1 0 $X=1003890 $Y=704645
X1597 1575 67 1470 1 2 1557 MUX2X1 $T=1009920 717040 1 180 $X=1003890 $Y=716650
X1598 1578 1551 1554 1 2 1549 MUX2X1 $T=1010480 779760 0 180 $X=1004450 $Y=775205
X1599 953 42 236 1 2 1607 MUX2X1 $T=1009360 803280 1 0 $X=1008930 $Y=798725
X1600 219 105 1604 1 2 1613 MUX2X1 $T=1010480 670000 0 0 $X=1010050 $Y=669610
X1601 233 105 239 1 2 1619 MUX2X1 $T=1012720 622960 0 0 $X=1012290 $Y=622570
X1602 238 105 1608 1 2 1621 MUX2X1 $T=1012720 646480 1 0 $X=1012290 $Y=641925
X1603 1575 105 1638 1 2 1649 MUX2X1 $T=1021120 701360 1 0 $X=1020690 $Y=696805
X1604 1464 42 1670 1 2 1664 MUX2X1 $T=1037920 795440 1 180 $X=1031890 $Y=795050
X1605 1691 105 1524 1 2 1681 MUX2X1 $T=1043520 701360 0 180 $X=1037490 $Y=696805
X1606 1691 67 1701 1 2 1708 MUX2X1 $T=1039600 709200 1 0 $X=1039170 $Y=704645
X1607 241 105 1707 1 2 1711 MUX2X1 $T=1040720 622960 1 0 $X=1040290 $Y=618405
X1608 241 67 1663 1 2 1713 MUX2X1 $T=1041280 670000 1 0 $X=1040850 $Y=665445
X1609 238 67 1709 1 2 1714 MUX2X1 $T=1041280 677840 0 0 $X=1040850 $Y=677450
X1610 245 67 1716 1 2 1712 MUX2X1 $T=1051920 654320 0 180 $X=1045890 $Y=649765
X1611 246 105 244 1 2 1718 MUX2X1 $T=1054160 622960 0 180 $X=1048130 $Y=618405
X1612 246 67 1721 1 2 1719 MUX2X1 $T=1057520 654320 0 180 $X=1051490 $Y=649765
X1613 1646 42 1704 1 2 1729 MUX2X1 $T=1052480 795440 0 0 $X=1052050 $Y=795050
X1614 251 67 1753 1 2 1755 MUX2X1 $T=1066480 638640 0 0 $X=1066050 $Y=638250
X1615 251 105 1706 1 2 258 MUX2X1 $T=1067040 622960 1 0 $X=1066610 $Y=618405
X1616 1560 42 1746 1 2 1743 MUX2X1 $T=1072640 779760 1 180 $X=1066610 $Y=779370
X1617 1759 42 1750 1 2 1744 MUX2X1 $T=1073760 748400 1 180 $X=1067730 $Y=748010
X1618 1203 42 1751 1 2 1745 MUX2X1 $T=1073760 771920 1 180 $X=1067730 $Y=771530
X1619 256 67 1732 1 2 1767 MUX2X1 $T=1069280 622960 0 0 $X=1068850 $Y=622570
X1620 259 67 1760 1 2 1756 MUX2X1 $T=1077120 662160 0 180 $X=1071090 $Y=657605
X1621 1727 42 1766 1 2 1762 MUX2X1 $T=1078240 779760 1 180 $X=1072210 $Y=779370
X1622 1787 42 1793 1 2 1790 MUX2X1 $T=1090560 748400 0 180 $X=1084530 $Y=743845
X1623 1748 42 1795 1 2 1792 MUX2X1 $T=1091120 732720 1 180 $X=1085090 $Y=732330
X1624 1770 42 1798 1 2 1794 MUX2X1 $T=1092240 717040 1 180 $X=1086210 $Y=716650
X1625 1765 42 1825 1 2 1826 MUX2X1 $T=1109040 724880 1 180 $X=1103010 $Y=724490
X1626 1596 42 1837 1 2 1831 MUX2X1 $T=1110160 709200 1 180 $X=1104130 $Y=708810
X1627 254 42 1839 1 2 1834 MUX2X1 $T=1110720 693520 1 180 $X=1104690 $Y=693130
X1628 1049 42 1848 1 2 1851 MUX2X1 $T=1109040 724880 0 0 $X=1108610 $Y=724490
X1629 257 42 1855 1 2 1858 MUX2X1 $T=1112400 685680 1 0 $X=1111970 $Y=681125
X1630 1812 42 1874 1 2 1871 MUX2X1 $T=1128640 662160 0 180 $X=1122610 $Y=657605
X1631 1820 42 1875 1 2 1872 MUX2X1 $T=1128640 701360 1 180 $X=1122610 $Y=700970
X1632 947 42 1876 1 2 1873 MUX2X1 $T=1129200 685680 1 180 $X=1123170 $Y=685290
X1633 1516 42 1878 1 2 1877 MUX2X1 $T=1130880 677840 0 180 $X=1124850 $Y=673285
X1634 898 42 1886 1 2 1927 MUX2X1 $T=1142080 677840 1 0 $X=1141650 $Y=673285
X1635 1944 42 1945 1 2 1942 MUX2X1 $T=1158880 670000 0 180 $X=1152850 $Y=665445
X1636 1937 42 1948 1 2 1946 MUX2X1 $T=1160000 677840 0 180 $X=1153970 $Y=673285
X1637 1904 42 1949 1 2 1947 MUX2X1 $T=1160000 693520 1 180 $X=1153970 $Y=693130
X1638 272 1589 2019 1 2 2017 MUX2X1 $T=1188560 654320 1 180 $X=1182530 $Y=653930
X1639 2046 2010 2038 1 2 1998 MUX2X1 $T=1194160 654320 0 180 $X=1188130 $Y=649765
X1640 2060 2005 2049 1 2 2034 MUX2X1 $T=1199200 638640 1 180 $X=1193170 $Y=638250
X1724 377 372 1 2 371 AND2X1 $T=644240 646480 0 180 $X=640450 $Y=641925
X1725 369 381 1 2 392 AND2X1 $T=649280 646480 0 0 $X=648850 $Y=646090
X1726 31 362 1 2 369 AND2X1 $T=653200 638640 1 180 $X=649410 $Y=638250
X1727 30 31 1 2 396 AND2X1 $T=650960 646480 1 0 $X=650530 $Y=641925
X1728 691 648 1 2 681 AND2X1 $T=755680 732720 0 180 $X=751890 $Y=728165
X1729 726 744 1 2 743 AND2X1 $T=765760 717040 0 0 $X=765330 $Y=716650
X1730 957 955 1 2 983 AND2X1 $T=868240 764080 1 0 $X=867810 $Y=759525
X1731 999 990 1 2 984 AND2X1 $T=873840 803280 1 180 $X=870050 $Y=802890
X1732 1014 1034 1 2 989 AND2X1 $T=883360 764080 0 180 $X=879570 $Y=759525
X1733 978 1041 1 2 957 AND2X1 $T=881120 748400 0 0 $X=880690 $Y=748010
X1734 152 1059 1 2 1029 AND2X1 $T=884480 787600 1 180 $X=880690 $Y=787210
X1735 957 963 1 2 1074 AND2X1 $T=882800 740560 1 0 $X=882370 $Y=736005
X1736 1004 1062 1 2 1117 AND2X1 $T=894560 732720 0 180 $X=890770 $Y=728165
X1737 1040 885 1 2 1127 AND2X1 $T=895680 724880 0 180 $X=891890 $Y=720325
X1738 991 997 1 2 1145 AND2X1 $T=896800 748400 1 0 $X=896370 $Y=743845
X1739 1174 1179 1 2 1151 AND2X1 $T=898480 779760 0 0 $X=898050 $Y=779370
X1740 1112 1172 1 2 1196 AND2X1 $T=900160 764080 1 0 $X=899730 $Y=759525
X1741 164 1162 1 2 1140 AND2X1 $T=905760 654320 1 180 $X=901970 $Y=653930
X1742 1210 1204 1 2 1181 AND2X1 $T=905760 662160 1 180 $X=901970 $Y=661770
X1743 955 1051 1 2 1219 AND2X1 $T=906880 732720 0 0 $X=906450 $Y=732330
X1744 1139 1218 1 2 1239 AND2X1 $T=908560 717040 0 0 $X=908130 $Y=716650
X1745 185 1162 1 2 1235 AND2X1 $T=913600 638640 0 180 $X=909810 $Y=634085
X1746 185 160 1 2 1244 AND2X1 $T=913040 622960 0 0 $X=912610 $Y=622570
X1747 1341 1351 1 2 1327 AND2X1 $T=957280 638640 0 180 $X=953490 $Y=634085
X1748 1366 1431 1 2 1372 AND2X1 $T=973520 622960 1 180 $X=969730 $Y=622570
X1749 1429 1351 1 2 1425 AND2X1 $T=975200 630800 1 180 $X=971410 $Y=630410
X1750 1455 1400 1 2 1459 AND2X1 $T=976320 630800 1 0 $X=975890 $Y=626245
X1751 1429 1431 1 2 1445 AND2X1 $T=977440 662160 0 0 $X=977010 $Y=661770
X1752 1466 1431 1 2 1359 AND2X1 $T=980800 662160 0 0 $X=980370 $Y=661770
X1753 1363 1356 1 2 1461 AND2X1 $T=984720 654320 1 180 $X=980930 $Y=653930
X1754 1545 1304 1 2 1536 AND2X1 $T=1003200 756240 1 180 $X=999410 $Y=755850
X1755 1578 1585 1 2 1566 AND2X1 $T=1009360 779760 0 0 $X=1008930 $Y=779370
X1756 1578 1609 1 2 1595 AND2X1 $T=1017760 771920 0 0 $X=1017330 $Y=771530
X1757 1654 1645 1 2 1674 AND2X1 $T=1032320 771920 0 0 $X=1031890 $Y=771530
X1758 1991 1998 1 2 2000 AND2X1 $T=1172320 654320 1 0 $X=1171890 $Y=649765
X1759 2010 2004 1 2 2002 AND2X1 $T=1178480 638640 0 180 $X=1174690 $Y=634085
X1760 2025 2016 1 2 2012 AND2X1 $T=1185760 646480 0 180 $X=1181970 $Y=641925
X1761 308 2062 1 2 2059 AND2X1 $T=1196400 622960 1 0 $X=1195970 $Y=618405
X1762 2031 2067 1 2 2053 AND2X1 $T=1201440 630800 1 180 $X=1197650 $Y=630410
X1763 2077 2050 1 2 2083 AND2X1 $T=1207040 670000 1 0 $X=1206610 $Y=665445
X1764 2065 1589 1 2 2087 AND2X1 $T=1209280 638640 0 0 $X=1208850 $Y=638250
X1790 6 1 2 353 INVX2 $T=629120 654320 0 0 $X=628690 $Y=653930
X1791 11 1 2 341 INVX2 $T=629680 622960 1 0 $X=629250 $Y=618405
X1792 4 1 2 359 INVX2 $T=632480 662160 1 0 $X=632050 $Y=657605
X1793 348 1 2 360 INVX2 $T=635840 638640 1 180 $X=633730 $Y=638250
X1794 20 1 2 356 INVX2 $T=640320 622960 1 180 $X=638210 $Y=622570
X1795 10 1 2 367 INVX2 $T=640880 638640 1 180 $X=638770 $Y=638250
X1796 378 1 2 381 INVX2 $T=651520 630800 0 0 $X=651090 $Y=630410
X1797 362 1 2 8 INVX2 $T=662160 630800 0 180 $X=660050 $Y=626245
X1798 648 1 2 646 INVX2 $T=747280 717040 1 180 $X=745170 $Y=716650
X1799 693 1 2 686 INVX2 $T=755680 693520 1 180 $X=753570 $Y=693130
X1800 691 1 2 664 INVX2 $T=755680 701360 0 180 $X=753570 $Y=696805
X1801 702 1 2 652 INVX2 $T=757920 717040 0 180 $X=755810 $Y=712485
X1802 683 1 2 687 INVX2 $T=760160 717040 0 180 $X=758050 $Y=712485
X1803 707 1 2 640 INVX2 $T=762960 693520 1 180 $X=760850 $Y=693130
X1804 715 1 2 705 INVX2 $T=764080 724880 0 180 $X=761970 $Y=720325
X1805 745 1 2 749 INVX2 $T=767440 701360 1 0 $X=767010 $Y=696805
X1806 758 1 2 677 INVX2 $T=770800 701360 0 180 $X=768690 $Y=696805
X1807 770 1 2 772 INVX2 $T=771920 685680 1 0 $X=771490 $Y=681125
X1808 767 1 2 699 INVX2 $T=773600 724880 0 180 $X=771490 $Y=720325
X1809 769 1 2 716 INVX2 $T=774160 724880 1 180 $X=772050 $Y=724490
X1810 778 1 2 722 INVX2 $T=775280 717040 0 180 $X=773170 $Y=712485
X1811 783 1 2 766 INVX2 $T=776400 724880 0 180 $X=774290 $Y=720325
X1812 780 1 2 653 INVX2 $T=777520 693520 1 180 $X=775410 $Y=693130
X1813 684 1 2 727 INVX2 $T=783120 685680 1 180 $X=781010 $Y=685290
X1814 696 1 2 660 INVX2 $T=787600 709200 0 0 $X=787170 $Y=708810
X1815 963 1 2 982 INVX2 $T=869360 709200 0 0 $X=868930 $Y=708810
X1816 994 1 2 975 INVX2 $T=872720 732720 0 180 $X=870610 $Y=728165
X1817 978 1 2 979 INVX2 $T=873840 748400 1 180 $X=871730 $Y=748010
X1818 976 1 2 1004 INVX2 $T=876080 740560 1 180 $X=873970 $Y=740170
X1819 998 1 2 1009 INVX2 $T=876080 740560 0 0 $X=875650 $Y=740170
X1820 1018 1 2 1043 INVX2 $T=879440 764080 0 0 $X=879010 $Y=763690
X1821 152 1 2 1035 INVX2 $T=881680 779760 0 180 $X=879570 $Y=775205
X1822 1052 1 2 997 INVX2 $T=884480 732720 1 0 $X=884050 $Y=728165
X1823 885 1 2 1041 INVX2 $T=886160 724880 0 0 $X=885730 $Y=724490
X1824 1031 1 2 1071 INVX2 $T=887280 630800 0 0 $X=886850 $Y=630410
X1825 1066 1 2 1073 INVX2 $T=887280 732720 0 0 $X=886850 $Y=732330
X1826 1084 1 2 1097 INVX2 $T=887840 654320 1 0 $X=887410 $Y=649765
X1827 1036 1 2 1092 INVX2 $T=887840 795440 1 0 $X=887410 $Y=790885
X1828 163 1 2 1087 INVX2 $T=888400 646480 1 0 $X=887970 $Y=641925
X1829 142 1 2 1065 INVX2 $T=888400 795440 0 0 $X=887970 $Y=795050
X1830 1094 1 2 1047 INVX2 $T=890080 764080 1 0 $X=889650 $Y=759525
X1831 1124 1 2 1116 INVX2 $T=892880 662160 0 180 $X=890770 $Y=657605
X1832 170 1 2 1100 INVX2 $T=892880 803280 1 180 $X=890770 $Y=802890
X1833 1137 1 2 1114 INVX2 $T=894560 787600 0 180 $X=892450 $Y=783045
X1834 173 1 2 1053 INVX2 $T=894560 811120 1 180 $X=892450 $Y=810730
X1835 143 1 2 1175 INVX2 $T=898480 630800 1 0 $X=898050 $Y=626245
X1836 1163 1 2 1130 INVX2 $T=898480 654320 0 0 $X=898050 $Y=653930
X1837 980 1 2 1131 INVX2 $T=898480 732720 1 0 $X=898050 $Y=728165
X1838 1058 1 2 178 INVX2 $T=901280 803280 1 180 $X=899170 $Y=802890
X1839 1020 1 2 1051 INVX2 $T=902960 724880 0 180 $X=900850 $Y=720325
X1840 1005 1 2 1190 INVX2 $T=903520 748400 1 180 $X=901410 $Y=748010
X1841 165 1 2 1143 INVX2 $T=904080 630800 1 180 $X=901970 $Y=630410
X1842 1123 1 2 1173 INVX2 $T=904080 787600 0 180 $X=901970 $Y=783045
X1843 175 1 2 1103 INVX2 $T=908560 638640 1 0 $X=908130 $Y=634085
X1844 1016 1 2 1162 INVX2 $T=911360 646480 0 180 $X=909250 $Y=641925
X1845 1059 1 2 157 INVX2 $T=910240 795440 1 0 $X=909810 $Y=790885
X1846 154 1 2 1238 INVX2 $T=910240 803280 1 0 $X=909810 $Y=798725
X1847 1111 1 2 1108 INVX2 $T=913600 779760 1 0 $X=913170 $Y=775205
X1848 180 1 2 1012 INVX2 $T=914160 803280 0 0 $X=913730 $Y=802890
X1849 1328 1 2 1345 INVX2 $T=952800 662160 0 0 $X=952370 $Y=661770
X1850 1363 1 2 1346 INVX2 $T=958960 630800 1 180 $X=956850 $Y=630410
X1851 1341 1 2 1379 INVX2 $T=960640 646480 1 0 $X=960210 $Y=641925
X1852 1399 1 2 1405 INVX2 $T=967360 646480 1 180 $X=965250 $Y=646090
X1853 1424 1 2 1415 INVX2 $T=970160 677840 1 180 $X=968050 $Y=677450
X1854 1366 1 2 1452 INVX2 $T=976320 622960 1 0 $X=975890 $Y=618405
X1855 1407 1 2 1356 INVX2 $T=982480 654320 1 0 $X=982050 $Y=649765
X1856 1361 1 2 1392 INVX2 $T=985840 646480 1 0 $X=985410 $Y=641925
X1857 1351 1 2 1487 INVX2 $T=988080 630800 0 180 $X=985970 $Y=626245
X1858 1338 1 2 1466 INVX2 $T=989760 662160 1 180 $X=987650 $Y=661770
X1859 1364 1 2 1388 INVX2 $T=994240 654320 0 180 $X=992130 $Y=649765
X1860 1546 1 2 1550 INVX2 $T=1002080 779760 0 0 $X=1001650 $Y=779370
X1861 1555 1 2 1545 INVX2 $T=1005440 756240 0 180 $X=1003330 $Y=751685
X1862 1572 1 2 1562 INVX2 $T=1012160 740560 0 180 $X=1010050 $Y=736005
X1863 1551 1 2 1585 INVX2 $T=1010480 779760 1 0 $X=1010050 $Y=775205
X1864 1569 1 2 1598 INVX2 $T=1012160 732720 0 0 $X=1011730 $Y=732330
X1865 1552 1 2 1588 INVX2 $T=1014400 756240 0 180 $X=1012290 $Y=751685
X1866 1611 1 2 1631 INVX2 $T=1019440 740560 0 0 $X=1019010 $Y=740170
X1867 1628 1 2 1606 INVX2 $T=1019440 756240 1 0 $X=1019010 $Y=751685
X1868 1530 1 2 1653 INVX2 $T=1026720 748400 0 0 $X=1026290 $Y=748010
X1869 1296 1 2 1637 INVX2 $T=1029520 756240 1 180 $X=1027410 $Y=755850
X1870 1587 1 2 1656 INVX2 $T=1028400 756240 1 0 $X=1027970 $Y=751685
X1871 1625 1 2 1673 INVX2 $T=1035680 779760 0 180 $X=1033570 $Y=775205
X1872 1304 1 2 1630 INVX2 $T=1036800 787600 1 180 $X=1034690 $Y=787210
X1873 1438 1 2 1616 INVX2 $T=1037360 756240 1 180 $X=1035250 $Y=755850
X1874 1634 1 2 1686 INVX2 $T=1038480 771920 0 0 $X=1038050 $Y=771530
X1875 461 1 2 249 INVX2 $T=1063680 622960 0 0 $X=1063250 $Y=622570
X1876 50 1 2 490 INVX2 $T=1064800 654320 0 0 $X=1064370 $Y=653930
X1877 2003 1 2 2006 INVX2 $T=1175680 654320 0 0 $X=1175250 $Y=653930
X1878 2011 1 2 2004 INVX2 $T=1178480 646480 0 180 $X=1176370 $Y=641925
X1879 2016 1 2 2005 INVX2 $T=1180720 638640 1 180 $X=1178610 $Y=638250
X1880 2018 1 2 2007 INVX2 $T=1181840 670000 0 180 $X=1179730 $Y=665445
X1881 2021 1 2 2019 INVX2 $T=1184080 654320 0 180 $X=1181970 $Y=649765
X1882 272 1 2 305 INVX2 $T=1188560 622960 0 180 $X=1186450 $Y=618405
X1883 2010 1 2 2035 INVX2 $T=1189120 646480 1 180 $X=1187010 $Y=646090
X1884 2022 1 2 2040 INVX2 $T=1189120 630800 1 0 $X=1188690 $Y=626245
X1885 2042 1 2 1975 INVX2 $T=1191920 622960 1 180 $X=1189810 $Y=622570
X1886 2065 1 2 2066 INVX2 $T=1200320 646480 1 180 $X=1198210 $Y=646090
X1887 2077 1 2 2075 INVX2 $T=1205360 646480 1 180 $X=1203250 $Y=646090
X1888 2080 1 2 2068 INVX2 $T=1207040 654320 0 180 $X=1204930 $Y=649765
X1889 2064 1 2 2079 INVX2 $T=1205920 622960 0 0 $X=1205490 $Y=622570
X1890 1553 1 2 2085 INVX2 $T=1210960 662160 1 0 $X=1210530 $Y=657605
X1891 209 1 2 2086 INVX2 $T=1216560 646480 0 0 $X=1216130 $Y=646090
X1949 449 452 2 316 1 2 444 DFFQSRX1 $T=648160 693520 1 0 $X=647730 $Y=688965
X1950 447 452 2 316 1 2 383 DFFQSRX1 $T=673360 709200 1 180 $X=647730 $Y=708810
X1951 460 452 2 316 1 2 384 DFFQSRX1 $T=673360 717040 1 180 $X=647730 $Y=716650
X1952 479 452 2 316 1 2 385 DFFQSRX1 $T=673360 724880 0 180 $X=647730 $Y=720325
X1953 430 452 2 316 1 2 386 DFFQSRX1 $T=673360 756240 0 180 $X=647730 $Y=751685
X1954 429 527 2 316 1 2 387 DFFQSRX1 $T=673360 787600 1 180 $X=647730 $Y=787210
X1955 477 527 2 316 1 2 388 DFFQSRX1 $T=673360 803280 0 180 $X=647730 $Y=798725
X1956 440 527 2 316 1 2 394 DFFQSRX1 $T=677840 771920 1 180 $X=652210 $Y=771530
X1957 457 527 2 316 1 2 413 DFFQSRX1 $T=686800 779760 0 180 $X=661170 $Y=775205
X1958 492 603 2 316 1 2 414 DFFQSRX1 $T=687360 670000 0 180 $X=661730 $Y=665445
X1959 475 603 2 316 1 2 423 DFFQSRX1 $T=689600 662160 1 180 $X=663970 $Y=661770
X1960 470 452 2 316 1 2 485 DFFQSRX1 $T=675040 764080 1 0 $X=674610 $Y=759525
X1961 495 452 2 316 1 2 450 DFFQSRX1 $T=678960 732720 0 0 $X=678530 $Y=732330
X1962 499 452 2 316 1 2 464 DFFQSRX1 $T=678960 756240 1 0 $X=678530 $Y=751685
X1963 505 72 2 316 1 2 521 DFFQSRX1 $T=682320 654320 0 0 $X=681890 $Y=653930
X1964 509 452 2 316 1 2 512 DFFQSRX1 $T=682320 740560 1 0 $X=681890 $Y=736005
X1965 517 72 2 316 1 2 52 DFFQSRX1 $T=684000 622960 1 0 $X=683570 $Y=618405
X1966 520 72 2 316 1 2 486 DFFQSRX1 $T=684000 630800 0 0 $X=683570 $Y=630410
X1967 514 603 2 316 1 2 503 DFFQSRX1 $T=684560 709200 1 0 $X=684130 $Y=704645
X1968 547 527 2 316 1 2 491 DFFQSRX1 $T=712000 787600 1 180 $X=686370 $Y=787210
X1969 502 603 2 316 1 2 519 DFFQSRX1 $T=687360 670000 1 0 $X=686930 $Y=665445
X1970 525 527 2 316 1 2 493 DFFQSRX1 $T=712560 779760 0 180 $X=686930 $Y=775205
X1971 530 527 2 316 1 2 534 DFFQSRX1 $T=687920 771920 1 0 $X=687490 $Y=767365
X1972 317 527 2 316 1 2 59 DFFQSRX1 $T=690720 811120 1 0 $X=690290 $Y=806565
X1973 557 832 2 316 1 2 506 DFFQSRX1 $T=717040 724880 1 180 $X=691410 $Y=724490
X1974 538 603 2 316 1 2 508 DFFQSRX1 $T=717600 677840 1 180 $X=691970 $Y=677450
X1975 550 527 2 316 1 2 49 DFFQSRX1 $T=718160 803280 1 180 $X=692530 $Y=802890
X1976 567 603 2 316 1 2 531 DFFQSRX1 $T=728240 701360 0 180 $X=702610 $Y=696805
X1977 571 603 2 316 1 2 533 DFFQSRX1 $T=728800 709200 1 180 $X=703170 $Y=708810
X1978 542 603 2 316 1 2 501 DFFQSRX1 $T=728800 717040 1 180 $X=703170 $Y=716650
X1979 556 72 2 316 1 2 561 DFFQSRX1 $T=705280 662160 1 0 $X=704850 $Y=657605
X1980 552 72 2 316 1 2 529 DFFQSRX1 $T=705840 646480 1 0 $X=705410 $Y=641925
X1981 576 603 2 316 1 2 541 DFFQSRX1 $T=731600 670000 1 180 $X=705970 $Y=669610
X1982 575 72 2 316 1 2 63 DFFQSRX1 $T=706960 630800 1 0 $X=706530 $Y=626245
X1983 580 72 2 316 1 2 64 DFFQSRX1 $T=709200 622960 1 0 $X=708770 $Y=618405
X1984 583 832 2 316 1 2 546 DFFQSRX1 $T=734400 756240 0 180 $X=708770 $Y=751685
X1985 591 728 2 316 1 2 549 DFFQSRX1 $T=735520 771920 1 180 $X=709890 $Y=771530
X1986 579 527 2 316 1 2 594 DFFQSRX1 $T=712000 787600 0 0 $X=711570 $Y=787210
X1987 596 728 2 316 1 2 558 DFFQSRX1 $T=738880 779760 0 180 $X=713250 $Y=775205
X1988 599 728 2 316 1 2 515 DFFQSRX1 $T=738880 811120 1 180 $X=713250 $Y=810730
X1989 602 728 2 316 1 2 578 DFFQSRX1 $T=746160 795440 1 180 $X=720530 $Y=795050
X1990 626 603 2 316 1 2 642 DFFQSRX1 $T=731040 677840 0 0 $X=730610 $Y=677450
X1991 647 832 2 316 1 2 601 DFFQSRX1 $T=756800 748400 0 180 $X=731170 $Y=743845
X1992 318 72 2 316 1 2 73 DFFQSRX1 $T=734400 622960 1 0 $X=733970 $Y=618405
X1993 671 728 2 316 1 2 606 DFFQSRX1 $T=760160 764080 0 180 $X=734530 $Y=759525
X1994 670 728 2 316 1 2 607 DFFQSRX1 $T=760720 756240 1 180 $X=735090 $Y=755850
X1995 661 728 2 316 1 2 611 DFFQSRX1 $T=763520 811120 0 180 $X=737890 $Y=806565
X1996 669 95 2 316 1 2 593 DFFQSRX1 $T=764080 646480 0 180 $X=738450 $Y=641925
X1997 678 728 2 316 1 2 613 DFFQSRX1 $T=764080 795440 0 180 $X=738450 $Y=790885
X1998 757 97 2 316 1 2 79 DFFQSRX1 $T=778080 811120 1 180 $X=752450 $Y=810730
X1999 754 728 2 316 1 2 644 DFFQSRX1 $T=779760 779760 1 180 $X=754130 $Y=779370
X2000 732 728 2 316 1 2 689 DFFQSRX1 $T=780320 771920 0 180 $X=754690 $Y=767365
X2001 771 832 2 316 1 2 709 DFFQSRX1 $T=783680 756240 0 180 $X=758050 $Y=751685
X2002 801 95 2 316 1 2 710 DFFQSRX1 $T=784240 622960 1 180 $X=758610 $Y=622570
X2003 795 834 2 316 1 2 711 DFFQSRX1 $T=784240 638640 1 180 $X=758610 $Y=638250
X2004 753 95 2 316 1 2 759 DFFQSRX1 $T=759040 670000 1 0 $X=758610 $Y=665445
X2005 790 832 2 316 1 2 774 DFFQSRX1 $T=759040 748400 0 0 $X=758610 $Y=748010
X2006 733 728 2 316 1 2 740 DFFQSRX1 $T=759040 787600 1 0 $X=758610 $Y=783045
X2007 775 728 2 316 1 2 779 DFFQSRX1 $T=759040 803280 1 0 $X=758610 $Y=798725
X2008 811 97 2 316 1 2 752 DFFQSRX1 $T=799920 771920 1 180 $X=774290 $Y=771530
X2009 814 834 2 316 1 2 781 DFFQSRX1 $T=800480 662160 1 180 $X=774850 $Y=661770
X2010 816 834 2 316 1 2 815 DFFQSRX1 $T=789840 638640 0 0 $X=789410 $Y=638250
X2011 818 97 2 316 1 2 90 DFFQSRX1 $T=789840 795440 1 0 $X=789410 $Y=790885
X2012 821 97 2 316 1 2 93 DFFQSRX1 $T=789840 803280 0 0 $X=789410 $Y=802890
X2013 819 97 2 316 1 2 91 DFFQSRX1 $T=789840 811120 0 0 $X=789410 $Y=810730
X2014 822 832 2 316 1 2 785 DFFQSRX1 $T=798240 748400 0 0 $X=797810 $Y=748010
X2015 836 834 2 316 1 2 840 DFFQSRX1 $T=799920 670000 0 0 $X=799490 $Y=669610
X2016 841 832 2 316 1 2 849 DFFQSRX1 $T=800480 740560 1 0 $X=800050 $Y=736005
X2017 835 832 2 316 1 2 102 DFFQSRX1 $T=801040 732720 1 0 $X=800610 $Y=728165
X2018 864 899 2 316 1 2 826 DFFQSRX1 $T=826800 740560 1 180 $X=801170 $Y=740170
X2019 845 834 2 316 1 2 103 DFFQSRX1 $T=802720 646480 1 0 $X=802290 $Y=641925
X2020 857 834 2 316 1 2 855 DFFQSRX1 $T=802720 654320 1 0 $X=802290 $Y=649765
X2021 880 899 2 316 1 2 831 DFFQSRX1 $T=827920 756240 1 180 $X=802290 $Y=755850
X2022 842 97 2 316 1 2 882 DFFQSRX1 $T=802720 771920 0 0 $X=802290 $Y=771530
X2023 846 834 2 316 1 2 827 DFFQSRX1 $T=829040 685680 0 180 $X=803410 $Y=681125
X2024 861 97 2 316 1 2 96 DFFQSRX1 $T=830160 811120 0 180 $X=804530 $Y=806565
X2025 865 834 2 316 1 2 869 DFFQSRX1 $T=806080 685680 0 0 $X=805650 $Y=685290
X2026 863 834 2 316 1 2 867 DFFQSRX1 $T=809440 662160 1 0 $X=809010 $Y=657605
X2027 875 97 2 316 1 2 876 DFFQSRX1 $T=810000 779760 0 0 $X=809570 $Y=779370
X2028 877 834 2 316 1 2 114 DFFQSRX1 $T=811120 638640 1 0 $X=810690 $Y=634085
X2029 892 899 2 316 1 2 894 DFFQSRX1 $T=823440 709200 1 0 $X=823010 $Y=704645
X2030 934 899 2 316 1 2 111 DFFQSRX1 $T=852000 795440 1 180 $X=826370 $Y=795050
X2031 916 132 2 316 1 2 108 DFFQSRX1 $T=854800 630800 0 180 $X=829170 $Y=626245
X2032 917 132 2 316 1 2 109 DFFQSRX1 $T=855360 646480 0 180 $X=829730 $Y=641925
X2033 909 834 2 316 1 2 911 DFFQSRX1 $T=830160 654320 0 0 $X=829730 $Y=653930
X2034 921 132 2 316 1 2 116 DFFQSRX1 $T=856480 677840 0 180 $X=830850 $Y=673285
X2035 904 899 2 316 1 2 905 DFFQSRX1 $T=831280 693520 1 0 $X=830850 $Y=688965
X2036 936 132 2 316 1 2 889 DFFQSRX1 $T=857600 685680 1 180 $X=831970 $Y=685290
X2037 923 899 2 316 1 2 862 DFFQSRX1 $T=858720 756240 0 180 $X=833090 $Y=751685
X2038 893 899 2 316 1 2 829 DFFQSRX1 $T=834080 732720 1 0 $X=833650 $Y=728165
X2039 906 899 2 316 1 2 125 DFFQSRX1 $T=834080 732720 0 0 $X=833650 $Y=732330
X2040 938 899 2 316 1 2 886 DFFQSRX1 $T=859840 756240 1 180 $X=834210 $Y=755850
X2041 928 899 2 316 1 2 925 DFFQSRX1 $T=838000 701360 0 0 $X=837570 $Y=700970
X2042 322 132 2 316 1 2 138 DFFQSRX1 $T=840800 622960 1 0 $X=840370 $Y=618405
X2043 942 899 2 316 1 2 131 DFFQSRX1 $T=841920 795440 1 0 $X=841490 $Y=790885
X2044 961 132 2 316 1 2 121 DFFQSRX1 $T=875520 638640 1 180 $X=849890 $Y=638250
X2045 944 132 2 316 1 2 940 DFFQSRX1 $T=850880 646480 0 0 $X=850450 $Y=646090
X2046 977 132 2 316 1 2 124 DFFQSRX1 $T=859840 662160 1 0 $X=859410 $Y=657605
X2047 1007 1037 2 316 1 2 129 DFFQSRX1 $T=885040 693520 0 180 $X=859410 $Y=688965
X2048 1019 1037 2 316 1 2 930 DFFQSRX1 $T=885600 670000 1 180 $X=859970 $Y=669610
X2049 1147 1037 2 316 1 2 939 DFFQSRX1 $T=895680 693520 1 180 $X=870050 $Y=693130
X2050 1273 1037 2 316 1 2 197 DFFQSRX1 $T=911920 693520 1 0 $X=911490 $Y=688965
X2051 1281 1302 2 316 1 2 1115 DFFQSRX1 $T=937680 677840 0 180 $X=912050 $Y=673285
X2052 1299 217 2 316 1 2 1275 DFFQSRX1 $T=947760 771920 1 180 $X=922130 $Y=771530
X2053 1303 1037 2 316 1 2 204 DFFQSRX1 $T=928720 701360 0 0 $X=928290 $Y=700970
X2054 1311 1302 2 316 1 2 1292 DFFQSRX1 $T=953920 724880 1 180 $X=928290 $Y=724490
X2055 1305 1037 2 316 1 2 1309 DFFQSRX1 $T=929280 717040 0 0 $X=928850 $Y=716650
X2056 1307 1037 2 316 1 2 1308 DFFQSRX1 $T=930400 740560 0 0 $X=929970 $Y=740170
X2057 1441 1302 2 316 1 2 149 DFFQSRX1 $T=962880 756240 0 180 $X=937250 $Y=751685
X2058 1316 206 2 316 1 2 210 DFFQSRX1 $T=937680 803280 1 0 $X=937250 $Y=798725
X2059 1317 217 2 316 1 2 203 DFFQSRX1 $T=962880 811120 0 180 $X=937250 $Y=806565
X2060 1349 217 2 316 1 2 1336 DFFQSRX1 $T=938800 764080 1 0 $X=938370 $Y=759525
X2061 1342 217 2 316 1 2 1306 DFFQSRX1 $T=964560 795440 0 180 $X=938930 $Y=790885
X2062 1389 217 2 316 1 2 205 DFFQSRX1 $T=965120 787600 0 180 $X=939490 $Y=783045
X2063 1377 1302 2 316 1 2 1301 DFFQSRX1 $T=970160 701360 0 180 $X=944530 $Y=696805
X2064 1383 1302 2 316 1 2 1335 DFFQSRX1 $T=976880 717040 0 180 $X=951250 $Y=712485
X2065 1375 1302 2 316 1 2 1401 DFFQSRX1 $T=952240 724880 1 0 $X=951810 $Y=720325
X2066 1384 1302 2 316 1 2 1386 DFFQSRX1 $T=952240 732720 0 0 $X=951810 $Y=732330
X2067 1426 1302 2 316 1 2 1421 DFFQSRX1 $T=955040 748400 1 0 $X=954610 $Y=743845
X2068 1447 1302 2 316 1 2 1368 DFFQSRX1 $T=984160 701360 1 180 $X=958530 $Y=700970
X2069 1376 217 2 316 1 2 212 DFFQSRX1 $T=964000 803280 0 0 $X=963570 $Y=802890
X2070 1482 217 2 316 1 2 1406 DFFQSRX1 $T=991440 787600 1 180 $X=965810 $Y=787210
X2071 1500 217 2 316 1 2 1409 DFFQSRX1 $T=992000 756240 1 180 $X=966370 $Y=755850
X2072 1477 1302 2 316 1 2 1480 DFFQSRX1 $T=972400 709200 1 0 $X=971970 $Y=704645
X2073 1468 1302 2 316 1 2 1435 DFFQSRX1 $T=997600 717040 1 180 $X=971970 $Y=716650
X2074 1491 1302 2 316 1 2 953 DFFQSRX1 $T=997600 724880 1 180 $X=971970 $Y=724490
X2075 1532 1594 2 316 1 2 215 DFFQSRX1 $T=1006560 685680 1 180 $X=980930 $Y=685290
X2076 1525 1594 2 316 1 2 1430 DFFQSRX1 $T=1006560 701360 0 180 $X=980930 $Y=696805
X2077 1557 1594 2 316 1 2 1470 DFFQSRX1 $T=1006560 709200 1 180 $X=980930 $Y=708810
X2078 1581 1594 2 316 1 2 1471 DFFQSRX1 $T=1006560 717040 0 180 $X=980930 $Y=712485
X2079 1599 1594 2 316 1 2 1524 DFFQSRX1 $T=1022800 662160 1 180 $X=997170 $Y=661770
X2080 1613 1594 2 316 1 2 219 DFFQSRX1 $T=1022800 670000 0 180 $X=997170 $Y=665445
X2081 1649 1594 2 316 1 2 1575 DFFQSRX1 $T=1012160 709200 1 0 $X=1011730 $Y=704645
X2082 1607 324 2 316 1 2 236 DFFQSRX1 $T=1012160 811120 0 0 $X=1011730 $Y=810730
X2083 1664 324 2 316 1 2 1670 DFFQSRX1 $T=1022240 811120 1 0 $X=1021810 $Y=806565
X2084 1718 323 2 316 1 2 246 DFFQSRX1 $T=1031200 630800 1 0 $X=1030770 $Y=626245
X2085 1715 1723 2 316 1 2 1638 DFFQSRX1 $T=1056400 693520 1 180 $X=1030770 $Y=693130
X2086 1711 323 2 316 1 2 241 DFFQSRX1 $T=1056960 622960 1 180 $X=1031330 $Y=622570
X2087 1713 1723 2 316 1 2 1663 DFFQSRX1 $T=1056960 670000 1 180 $X=1031330 $Y=669610
X2088 1699 1594 2 316 1 2 1646 DFFQSRX1 $T=1034560 717040 0 0 $X=1034130 $Y=716650
X2089 1712 1723 2 316 1 2 1716 DFFQSRX1 $T=1036240 654320 0 0 $X=1035810 $Y=653930
X2090 1729 253 2 316 1 2 1704 DFFQSRX1 $T=1068720 803280 0 180 $X=1043090 $Y=798725
X2091 1726 324 2 316 1 2 252 DFFQSRX1 $T=1043520 811120 0 0 $X=1043090 $Y=810730
X2092 1725 1768 2 316 1 2 1560 DFFQSRX1 $T=1049680 732720 1 0 $X=1049250 $Y=728165
X2093 1734 1768 2 316 1 2 1203 DFFQSRX1 $T=1077680 709200 0 180 $X=1052050 $Y=704645
X2094 1758 253 2 316 1 2 1727 DFFQSRX1 $T=1083280 748400 0 180 $X=1057650 $Y=743845
X2095 1744 253 2 316 1 2 1750 DFFQSRX1 $T=1058640 756240 1 0 $X=1058210 $Y=751685
X2096 1767 1723 2 316 1 2 1732 DFFQSRX1 $T=1084960 630800 0 180 $X=1059330 $Y=626245
X2097 1754 1768 2 316 1 2 1759 DFFQSRX1 $T=1059760 717040 0 0 $X=1059330 $Y=716650
X2098 1756 1723 2 316 1 2 1760 DFFQSRX1 $T=1063120 662160 0 0 $X=1062690 $Y=661770
X2099 1773 253 2 316 1 2 265 DFFQSRX1 $T=1065920 795440 0 0 $X=1065490 $Y=795050
X2100 1777 326 2 316 1 2 250 DFFQSRX1 $T=1092240 811120 0 180 $X=1066610 $Y=806565
X2101 1781 1723 2 316 1 2 254 DFFQSRX1 $T=1094480 654320 1 180 $X=1068850 $Y=653930
X2102 1806 1723 2 316 1 2 257 DFFQSRX1 $T=1096160 638640 0 180 $X=1070530 $Y=634085
X2103 1785 1768 2 316 1 2 1748 DFFQSRX1 $T=1096160 677840 1 180 $X=1070530 $Y=677450
X2104 1808 1768 2 316 1 2 1770 DFFQSRX1 $T=1102320 670000 0 180 $X=1076690 $Y=665445
X2105 1794 1768 2 316 1 2 1798 DFFQSRX1 $T=1078240 724880 0 0 $X=1077810 $Y=724490
X2106 1803 1768 2 316 1 2 1765 DFFQSRX1 $T=1106240 685680 0 180 $X=1080610 $Y=681125
X2107 325 327 2 316 1 2 274 DFFQSRX1 $T=1087760 622960 1 0 $X=1087330 $Y=618405
X2108 1824 283 2 316 1 2 269 DFFQSRX1 $T=1114640 764080 1 180 $X=1089010 $Y=763690
X2109 1814 253 2 316 1 2 1822 DFFQSRX1 $T=1090000 779760 0 0 $X=1089570 $Y=779370
X2110 1850 1723 2 316 1 2 1812 DFFQSRX1 $T=1092240 630800 1 0 $X=1091810 $Y=626245
X2111 1858 1768 2 316 1 2 1855 DFFQSRX1 $T=1092240 685680 0 0 $X=1091810 $Y=685290
X2112 1834 1768 2 316 1 2 1839 DFFQSRX1 $T=1092240 701360 0 0 $X=1091810 $Y=700970
X2113 1865 253 2 316 1 2 1857 DFFQSRX1 $T=1092240 756240 1 0 $X=1091810 $Y=751685
X2114 1838 253 2 316 1 2 1841 DFFQSRX1 $T=1092240 756240 0 0 $X=1091810 $Y=755850
X2115 1817 253 2 316 1 2 1828 DFFQSRX1 $T=1092240 795440 1 0 $X=1091810 $Y=790885
X2116 1832 326 2 316 1 2 1847 DFFQSRX1 $T=1092240 811120 0 0 $X=1091810 $Y=810730
X2117 1863 328 2 316 1 2 1596 DFFQSRX1 $T=1127520 662160 1 180 $X=1101890 $Y=661770
X2118 1811 328 2 316 1 2 1820 DFFQSRX1 $T=1127520 670000 0 180 $X=1101890 $Y=665445
X2119 1860 283 2 316 1 2 1827 DFFQSRX1 $T=1128640 771920 1 180 $X=1103010 $Y=771530
X2120 1868 283 2 316 1 2 1845 DFFQSRX1 $T=1133120 779760 0 180 $X=1107490 $Y=775205
X2121 1873 328 2 316 1 2 1876 DFFQSRX1 $T=1123600 693520 1 0 $X=1123170 $Y=688965
X2122 1872 328 2 316 1 2 1875 DFFQSRX1 $T=1123600 709200 0 0 $X=1123170 $Y=708810
X2123 1890 329 2 316 1 2 898 DFFQSRX1 $T=1124160 622960 1 0 $X=1123730 $Y=618405
X2124 1923 328 2 316 1 2 1516 DFFQSRX1 $T=1124720 638640 1 0 $X=1124290 $Y=634085
X2125 1859 283 2 316 1 2 1882 DFFQSRX1 $T=1124720 811120 1 0 $X=1124290 $Y=806565
X2126 1870 283 2 316 1 2 292 DFFQSRX1 $T=1124720 811120 0 0 $X=1124290 $Y=810730
X2127 1901 283 2 316 1 2 285 DFFQSRX1 $T=1125280 795440 1 0 $X=1124850 $Y=790885
X2128 1891 1926 2 316 1 2 1903 DFFQSRX1 $T=1126400 732720 0 0 $X=1125970 $Y=732330
X2129 1871 328 2 316 1 2 1874 DFFQSRX1 $T=1127520 670000 1 0 $X=1127090 $Y=665445
X2130 1935 1926 2 316 1 2 1885 DFFQSRX1 $T=1157760 756240 0 180 $X=1132130 $Y=751685
X2131 1927 1926 2 316 1 2 1886 DFFQSRX1 $T=1158320 685680 1 180 $X=1132690 $Y=685290
X2132 1911 283 2 316 1 2 1928 DFFQSRX1 $T=1133680 764080 0 0 $X=1133250 $Y=763690
X2133 1930 328 2 316 1 2 1944 DFFQSRX1 $T=1137040 662160 1 0 $X=1136610 $Y=657605
X2134 1946 1926 2 316 1 2 1948 DFFQSRX1 $T=1148800 677840 0 0 $X=1148370 $Y=677450
X2135 1947 1926 2 316 1 2 1949 DFFQSRX1 $T=1148800 693520 1 0 $X=1148370 $Y=688965
X2136 1970 283 2 316 1 2 1940 DFFQSRX1 $T=1176800 803280 0 180 $X=1151170 $Y=798725
X2137 1931 1926 2 316 1 2 1952 DFFQSRX1 $T=1153280 709200 1 0 $X=1152850 $Y=704645
X2138 1972 1926 2 316 1 2 1963 DFFQSRX1 $T=1153280 717040 1 0 $X=1152850 $Y=712485
X2139 1965 1926 2 316 1 2 1979 DFFQSRX1 $T=1153280 724880 1 0 $X=1152850 $Y=720325
X2140 1953 1926 2 316 1 2 1964 DFFQSRX1 $T=1153840 732720 0 0 $X=1153410 $Y=732330
X2141 1986 1926 2 316 1 2 1993 DFFQSRX1 $T=1160000 748400 0 0 $X=1159570 $Y=748010
X2142 1973 1926 2 316 1 2 1974 DFFQSRX1 $T=1160000 756240 1 0 $X=1159570 $Y=751685
X2143 1987 283 2 316 1 2 1983 DFFQSRX1 $T=1160000 771920 0 0 $X=1159570 $Y=771530
X2214 456 1 2 452 BUFX1 $T=677840 740560 0 180 $X=674610 $Y=736005
X2215 456 1 2 527 BUFX1 $T=699120 764080 0 0 $X=698690 $Y=763690
X2216 605 1 2 603 BUFX1 $T=733840 685680 0 180 $X=730610 $Y=681125
X2217 605 1 2 72 BUFX1 $T=738320 670000 0 180 $X=735090 $Y=665445
X2218 82 1 2 728 BUFX1 $T=766880 795440 0 180 $X=763650 $Y=790885
X2219 456 1 2 832 BUFX1 $T=799920 732720 0 0 $X=799490 $Y=732330
X2220 605 1 2 834 BUFX1 $T=801040 677840 0 0 $X=800610 $Y=677450
X2221 456 1 2 95 BUFX1 $T=806640 670000 0 180 $X=803410 $Y=665445
X2222 82 1 2 97 BUFX1 $T=810000 779760 1 180 $X=806770 $Y=779370
X2223 82 1 2 899 BUFX1 $T=839120 764080 0 180 $X=835890 $Y=759525
X2224 82 1 2 120 BUFX1 $T=840800 811120 0 180 $X=837570 $Y=806565
X2225 605 1 2 132 BUFX1 $T=857600 685680 0 0 $X=857170 $Y=685290
X2226 135 1 2 964 BUFX1 $T=863760 677840 0 0 $X=863330 $Y=677450
X2227 964 1 2 605 BUFX1 $T=867680 677840 0 0 $X=867250 $Y=677450
X2228 964 1 2 456 BUFX1 $T=870480 701360 0 0 $X=870050 $Y=700970
X2229 964 1 2 82 BUFX1 $T=876080 764080 0 180 $X=872850 $Y=759525
X2230 456 1 2 1037 BUFX1 $T=877760 701360 1 0 $X=877330 $Y=696805
X2231 964 1 2 1061 BUFX1 $T=881120 764080 0 0 $X=880690 $Y=763690
X2232 1061 1 2 195 BUFX1 $T=918640 811120 0 0 $X=918210 $Y=810730
X2233 605 1 2 1302 BUFX1 $T=936000 677840 0 0 $X=935570 $Y=677450
X2234 195 1 2 206 BUFX1 $T=939920 811120 0 0 $X=939490 $Y=810730
X2235 195 1 2 217 BUFX1 $T=965120 811120 0 0 $X=964690 $Y=810730
X2236 964 1 2 1577 BUFX1 $T=1006560 709200 0 0 $X=1006130 $Y=708810
X2237 1577 1 2 1594 BUFX1 $T=1010480 709200 0 0 $X=1010050 $Y=708810
X2238 1577 1 2 1723 BUFX1 $T=1057520 701360 0 180 $X=1054290 $Y=696805
X2239 1577 1 2 253 BUFX1 $T=1071520 756240 1 180 $X=1068290 $Y=755850
X2240 1577 1 2 1768 BUFX1 $T=1078240 724880 0 180 $X=1075010 $Y=720325
X2241 1577 1 2 283 BUFX1 $T=1128640 771920 0 0 $X=1128210 $Y=771530
X2242 1577 1 2 1926 BUFX1 $T=1144320 740560 0 0 $X=1143890 $Y=740170
X2385 1 2 348 20 366 ICV_61 $T=638080 646480 0 0 $X=637650 $Y=646090
X2386 1 2 34 387 408 ICV_61 $T=658240 779760 1 0 $X=657810 $Y=775205
X2387 1 2 34 386 415 ICV_61 $T=660480 748400 0 0 $X=660050 $Y=748010
X2388 1 2 36 386 418 ICV_61 $T=664960 748400 1 0 $X=664530 $Y=743845
X2389 1 2 370 435 433 ICV_61 $T=665520 638640 1 0 $X=665090 $Y=634085
X2390 1 2 466 37 467 ICV_61 $T=677840 771920 0 0 $X=677410 $Y=771530
X2391 1 2 472 50 510 ICV_61 $T=690720 646480 1 0 $X=690290 $Y=641925
X2392 1 2 50 52 522 ICV_61 $T=699680 638640 0 0 $X=699250 $Y=638250
X2393 1 2 528 532 530 ICV_61 $T=700800 756240 0 0 $X=700370 $Y=755850
X2394 1 2 50 529 536 ICV_61 $T=703040 662160 0 0 $X=702610 $Y=661770
X2395 1 2 534 37 60 ICV_61 $T=706960 811120 0 0 $X=706530 $Y=810730
X2396 1 2 43 569 572 ICV_61 $T=717600 748400 1 0 $X=717170 $Y=743845
X2397 1 2 594 37 598 ICV_61 $T=726000 795440 1 0 $X=725570 $Y=790885
X2398 1 2 655 666 641 ICV_61 $T=746720 717040 1 0 $X=746290 $Y=712485
X2399 1 2 675 682 678 ICV_61 $T=750080 779760 0 0 $X=749650 $Y=779370
X2400 1 2 672 749 741 ICV_61 $T=767440 701360 0 0 $X=767010 $Y=700970
X2401 1 2 50 785 784 ICV_61 $T=773600 748400 1 0 $X=773170 $Y=743845
X2402 1 2 745 793 782 ICV_61 $T=776400 701360 0 0 $X=775970 $Y=700970
X2403 1 2 684 758 791 ICV_61 $T=777520 677840 1 0 $X=777090 $Y=673285
X2404 1 2 623 693 798 ICV_61 $T=780320 709200 0 0 $X=779890 $Y=708810
X2405 1 2 46 815 820 ICV_61 $T=794880 662160 1 0 $X=794450 $Y=657605
X2406 1 2 46 827 813 ICV_61 $T=797120 701360 1 0 $X=796690 $Y=696805
X2407 1 2 46 840 839 ICV_61 $T=808880 709200 1 0 $X=808450 $Y=704645
X2408 1 2 106 879 877 ICV_61 $T=822320 622960 0 0 $X=821890 $Y=622570
X2409 1 2 46 894 895 ICV_61 $T=834080 717040 0 0 $X=833650 $Y=716650
X2410 1 2 50 862 901 ICV_61 $T=836880 771920 1 0 $X=836450 $Y=767365
X2411 1 2 113 919 920 ICV_61 $T=848080 662160 1 0 $X=847650 $Y=657605
X2412 1 2 955 963 960 ICV_61 $T=863200 748400 0 0 $X=862770 $Y=748010
X2413 1 2 148 1050 1038 ICV_61 $T=878320 622960 0 0 $X=877890 $Y=622570
X2414 1 2 151 1087 1076 ICV_61 $T=884480 654320 1 0 $X=884050 $Y=649765
X2415 1 2 1135 1143 1129 ICV_61 $T=892320 630800 1 0 $X=891890 $Y=626245
X2416 1 2 1127 1051 1141 ICV_61 $T=892880 717040 0 0 $X=892450 $Y=716650
X2417 1 2 1165 980 1172 ICV_61 $T=897360 756240 0 0 $X=896930 $Y=755850
X2418 1 2 1230 1012 1234 ICV_61 $T=908560 787600 1 0 $X=908130 $Y=783045
X2419 1 2 1255 1272 1267 ICV_61 $T=918080 795440 0 0 $X=917650 $Y=795050
X2420 1 2 1345 1359 1353 ICV_61 $T=954480 662160 0 0 $X=954050 $Y=661770
X2421 1 2 461 205 1378 ICV_61 $T=960080 771920 0 0 $X=959650 $Y=771530
X2422 1 2 126 1430 1382 ICV_61 $T=968480 693520 0 0 $X=968050 $Y=693130
X2423 1 2 1359 1407 1508 ICV_61 $T=989200 662160 1 0 $X=988770 $Y=657605
X2424 1 2 1544 1609 1582 ICV_61 $T=1012160 779760 1 0 $X=1011730 $Y=775205
X2425 1 2 1601 1603 1576 ICV_61 $T=1012720 779760 0 0 $X=1012290 $Y=779370
X2426 1 2 1530 1296 1628 ICV_61 $T=1024480 748400 1 0 $X=1024050 $Y=743845
X2427 1 2 46 1663 1661 ICV_61 $T=1031200 717040 0 0 $X=1030770 $Y=716650
X2428 1 2 1546 1438 1678 ICV_61 $T=1034560 756240 1 0 $X=1034130 $Y=751685
X2429 1 2 113 1706 1700 ICV_61 $T=1041840 638640 0 0 $X=1041410 $Y=638250
X2430 1 2 46 1709 1720 ICV_61 $T=1050240 701360 1 0 $X=1049810 $Y=696805
X2431 1 2 126 248 1627 ICV_61 $T=1054160 622960 1 0 $X=1053730 $Y=618405
X2432 1 2 461 1765 1805 ICV_61 $T=1097840 693520 1 0 $X=1097410 $Y=688965
X2433 1 2 43 1875 1880 ICV_61 $T=1125840 724880 1 0 $X=1125410 $Y=720325
X2434 1 2 36 1909 287 ICV_61 $T=1138160 803280 1 0 $X=1137730 $Y=798725
X2435 1 2 1932 1938 1935 ICV_61 $T=1148240 748400 0 0 $X=1147810 $Y=748010
X2436 1 2 299 300 2016 ICV_61 $T=1179600 630800 1 0 $X=1179170 $Y=626245
X2437 1 2 2068 2041 2070 ICV_61 $T=1200320 654320 1 0 $X=1199890 $Y=649765
X2438 1 2 338 4 333 ICV_62 $T=620160 630800 1 0 $X=619730 $Y=626245
X2439 1 2 8 9 343 ICV_62 $T=624640 630800 1 0 $X=624210 $Y=626245
X2440 1 2 4 341 361 ICV_62 $T=630800 654320 0 0 $X=630370 $Y=653930
X2441 1 2 368 19 364 ICV_62 $T=635280 654320 0 0 $X=634850 $Y=653930
X2442 1 2 13 27 378 ICV_62 $T=644800 638640 0 0 $X=644370 $Y=638250
X2443 1 2 4 8 406 ICV_62 $T=656000 630800 1 0 $X=655570 $Y=626245
X2444 1 2 34 420 412 ICV_62 $T=660480 748400 1 0 $X=660050 $Y=743845
X2445 1 2 482 483 484 ICV_62 $T=682320 740560 0 0 $X=681890 $Y=740170
X2446 1 2 523 526 525 ICV_62 $T=697440 771920 0 0 $X=697010 $Y=771530
X2447 1 2 491 37 56 ICV_62 $T=701920 795440 1 0 $X=701490 $Y=790885
X2448 1 2 46 58 539 ICV_62 $T=702480 630800 1 0 $X=702050 $Y=626245
X2449 1 2 43 506 526 ICV_62 $T=706400 748400 1 0 $X=705970 $Y=743845
X2450 1 2 558 37 553 ICV_62 $T=712560 795440 0 0 $X=712130 $Y=795050
X2451 1 2 461 63 573 ICV_62 $T=716480 638640 0 0 $X=716050 $Y=638250
X2452 1 2 577 584 583 ICV_62 $T=718720 748400 0 0 $X=718290 $Y=748010
X2453 1 2 40 594 582 ICV_62 $T=722640 787600 1 0 $X=722210 $Y=783045
X2454 1 2 592 597 596 ICV_62 $T=723200 779760 0 0 $X=722770 $Y=779370
X2455 1 2 40 613 675 ICV_62 $T=747840 787600 1 0 $X=747410 $Y=783045
X2456 1 2 43 689 682 ICV_62 $T=750080 779760 1 0 $X=749650 $Y=775205
X2457 1 2 648 623 739 ICV_62 $T=762400 685680 1 0 $X=761970 $Y=681125
X2458 1 2 716 684 760 ICV_62 $T=766880 685680 1 0 $X=766450 $Y=681125
X2459 1 2 461 838 854 ICV_62 $T=812800 709200 0 0 $X=812370 $Y=708810
X2460 1 2 46 867 860 ICV_62 $T=818960 709200 1 0 $X=818530 $Y=704645
X2461 1 2 949 957 952 ICV_62 $T=860960 748400 1 0 $X=860530 $Y=743845
X2462 1 2 951 959 956 ICV_62 $T=861520 732720 1 0 $X=861090 $Y=728165
X2463 1 2 146 1053 150 ICV_62 $T=877200 811120 0 0 $X=876770 $Y=810730
X2464 1 2 126 1115 1022 ICV_62 $T=887840 670000 0 0 $X=887410 $Y=669610
X2465 1 2 1120 1016 1144 ICV_62 $T=891760 670000 1 0 $X=891330 $Y=665445
X2466 1 2 156 1058 1036 ICV_62 $T=892320 779760 0 0 $X=891890 $Y=779370
X2467 1 2 1148 1157 1152 ICV_62 $T=893440 795440 1 0 $X=893010 $Y=790885
X2468 1 2 1084 1162 1159 ICV_62 $T=894560 646480 0 0 $X=894130 $Y=646090
X2469 1 2 170 157 1123 ICV_62 $T=905760 795440 1 0 $X=905330 $Y=790885
X2470 1 2 1222 157 1240 ICV_62 $T=908560 811120 1 0 $X=908130 $Y=806565
X2471 1 2 1199 1312 1310 ICV_62 $T=940480 685680 0 0 $X=940050 $Y=685290
X2472 1 2 46 1335 1352 ICV_62 $T=952800 740560 1 0 $X=952370 $Y=736005
X2473 1 2 1364 1338 1399 ICV_62 $T=961760 638640 1 0 $X=961330 $Y=634085
X2474 1 2 1372 1407 1402 ICV_62 $T=962880 654320 0 0 $X=962450 $Y=653930
X2475 1 2 1413 1388 1427 ICV_62 $T=967360 646480 0 0 $X=966930 $Y=646090
X2476 1 2 1432 1424 1419 ICV_62 $T=969600 662160 0 0 $X=969170 $Y=661770
X2477 1 2 1425 1454 1350 ICV_62 $T=973520 622960 0 0 $X=973090 $Y=622570
X2478 1 2 461 953 1486 ICV_62 $T=981920 724880 1 0 $X=981490 $Y=720325
X2479 1 2 1499 1388 1510 ICV_62 $T=988640 677840 0 0 $X=988210 $Y=677450
X2480 1 2 1428 1593 1586 ICV_62 $T=1008800 685680 1 0 $X=1008370 $Y=681125
X2481 1 2 113 1528 1597 ICV_62 $T=1013840 685680 0 0 $X=1013410 $Y=685290
X2482 1 2 1555 1565 1636 ICV_62 $T=1019440 795440 1 0 $X=1019010 $Y=790885
X2483 1 2 461 1464 1657 ICV_62 $T=1027840 732720 0 0 $X=1027410 $Y=732330
X2484 1 2 1673 1675 1647 ICV_62 $T=1032320 748400 0 0 $X=1031890 $Y=748010
X2485 1 2 1683 1686 1668 ICV_62 $T=1039040 779760 0 0 $X=1038610 $Y=779370
X2486 1 2 461 1049 1738 ICV_62 $T=1063680 685680 1 0 $X=1063250 $Y=681125
X2487 1 2 461 1787 1791 ICV_62 $T=1082160 701360 1 0 $X=1081730 $Y=696805
X2488 1 2 50 1770 1784 ICV_62 $T=1087760 701360 0 0 $X=1087330 $Y=700970
X2489 1 2 1835 1840 1838 ICV_62 $T=1102880 748400 0 0 $X=1102450 $Y=748010
X2490 1 2 34 1847 1843 ICV_62 $T=1107920 803280 1 0 $X=1107490 $Y=798725
X2491 1 2 1833 50 1849 ICV_62 $T=1110160 646480 0 0 $X=1109730 $Y=646090
X2492 1 2 43 1848 1854 ICV_62 $T=1112960 740560 0 0 $X=1112530 $Y=740170
X2493 1 2 1828 37 1856 ICV_62 $T=1113520 795440 0 0 $X=1113090 $Y=795050
X2494 1 2 34 1928 1917 ICV_62 $T=1143760 764080 1 0 $X=1143330 $Y=759525
X2495 1 2 461 1937 1924 ICV_62 $T=1147120 646480 0 0 $X=1146690 $Y=646090
X2496 1 2 34 1964 1957 ICV_62 $T=1160560 740560 1 0 $X=1160130 $Y=736005
X2497 1 2 36 1993 1990 ICV_62 $T=1169520 756240 0 0 $X=1169090 $Y=755850
X2498 1 2 36 1983 1984 ICV_62 $T=1169520 779760 1 0 $X=1169090 $Y=775205
X2499 1 2 298 300 2022 ICV_62 $T=1180720 622960 0 0 $X=1180290 $Y=622570
X2500 1 2 2039 2050 2048 ICV_62 $T=1191360 662160 1 0 $X=1190930 $Y=657605
X2501 1 2 2077 1589 296 ICV_62 $T=1201440 662160 0 0 $X=1201010 $Y=661770
X2502 1 2 1589 1553 2064 ICV_62 $T=1203120 654320 0 0 $X=1202690 $Y=653930
X2503 1 2 25 20 375 ICV_87 $T=642000 630800 1 0 $X=641570 $Y=626245
X2504 1 2 395 8 411 ICV_87 $T=658800 622960 0 0 $X=658370 $Y=622570
X2505 1 2 50 521 473 ICV_87 $T=694640 662160 1 0 $X=694210 $Y=657605
X2506 1 2 549 37 65 ICV_87 $T=717040 795440 0 0 $X=716610 $Y=795050
X2507 1 2 656 648 663 ICV_87 $T=746160 732720 0 0 $X=745730 $Y=732330
X2508 1 2 46 674 695 ICV_87 $T=755120 646480 0 0 $X=754690 $Y=646090
X2509 1 2 694 741 724 ICV_87 $T=763520 701360 0 0 $X=763090 $Y=700970
X2510 1 2 50 752 748 ICV_87 $T=765760 748400 1 0 $X=765330 $Y=743845
X2511 1 2 43 779 764 ICV_87 $T=771360 811120 1 0 $X=770930 $Y=806565
X2512 1 2 46 781 817 ICV_87 $T=792080 677840 0 0 $X=791650 $Y=677450
X2513 1 2 856 50 858 ICV_87 $T=815600 717040 1 0 $X=815170 $Y=712485
X2514 1 2 995 1001 972 ICV_87 $T=870480 717040 0 0 $X=870050 $Y=716650
X2515 1 2 126 1072 943 ICV_87 $T=882240 677840 1 0 $X=881810 $Y=673285
X2516 1 2 163 165 1163 ICV_87 $T=896240 638640 0 0 $X=895810 $Y=638250
X2517 1 2 1053 178 1168 ICV_87 $T=896800 811120 1 0 $X=896370 $Y=806565
X2518 1 2 113 1343 1312 ICV_87 $T=950560 693520 1 0 $X=950130 $Y=688965
X2519 1 2 1369 1363 1374 ICV_87 $T=957840 670000 1 0 $X=957410 $Y=665445
X2520 1 2 50 149 1404 ICV_87 $T=963440 771920 0 0 $X=963010 $Y=771530
X2521 1 2 1399 1407 1412 ICV_87 $T=966240 638640 1 0 $X=965810 $Y=634085
X2522 1 2 1328 1436 1432 ICV_87 $T=969600 662160 1 0 $X=969170 $Y=657605
X2523 1 2 126 1608 1282 ICV_87 $T=1011600 662160 1 0 $X=1011170 $Y=657605
X2524 1 2 1609 1606 1601 ICV_87 $T=1015520 779760 1 0 $X=1015090 $Y=775205
X2525 1 2 1684 1692 1689 ICV_87 $T=1037920 638640 0 0 $X=1037490 $Y=638250
X2526 1 2 46 1701 1698 ICV_87 $T=1040720 724880 1 0 $X=1040290 $Y=720325
X2527 1 2 461 1646 1710 ICV_87 $T=1047440 732720 0 0 $X=1047010 $Y=732330
X2528 1 2 50 1203 1747 ICV_87 $T=1065920 701360 0 0 $X=1065490 $Y=700970
X2529 1 2 40 265 1774 ICV_87 $T=1081040 787600 0 0 $X=1080610 $Y=787210
X2530 1 2 1799 50 1801 ICV_87 $T=1087200 693520 1 0 $X=1086770 $Y=688965
X2531 1 2 461 947 1844 ICV_87 $T=1110160 638640 1 0 $X=1109730 $Y=634085
X2532 1 2 40 1952 1934 ICV_87 $T=1153840 701360 0 0 $X=1153410 $Y=700970
X2533 1 2 34 295 1988 ICV_87 $T=1172880 779760 0 0 $X=1172450 $Y=779370
X2534 1 2 2008 2013 1997 ICV_87 $T=1175680 630800 1 0 $X=1175250 $Y=626245
X2535 1 2 2003 298 2008 ICV_87 $T=1176800 622960 0 0 $X=1176370 $Y=622570
X2536 1 2 2079 305 2084 ICV_87 $T=1207600 622960 0 0 $X=1207170 $Y=622570
X2756 1 2 8 356 14 ICV_69 $T=633600 622960 0 0 $X=633170 $Y=622570
X2757 1 2 364 366 365 ICV_69 $T=635280 654320 1 0 $X=634850 $Y=649765
X2758 1 2 34 394 417 ICV_69 $T=661600 764080 1 0 $X=661170 $Y=759525
X2759 1 2 384 37 437 ICV_69 $T=667760 732720 0 0 $X=667330 $Y=732330
X2760 1 2 446 481 479 ICV_69 $T=682320 724880 0 0 $X=681890 $Y=724490
X2761 1 2 36 515 474 ICV_69 $T=692960 795440 0 0 $X=692530 $Y=795050
X2762 1 2 461 521 511 ICV_69 $T=697440 646480 0 0 $X=697010 $Y=646090
X2763 1 2 493 37 54 ICV_69 $T=698000 795440 0 0 $X=697570 $Y=795050
X2764 1 2 461 519 507 ICV_69 $T=700240 662160 1 0 $X=699810 $Y=657605
X2765 1 2 46 74 609 ICV_69 $T=738320 630800 1 0 $X=737890 $Y=626245
X2766 1 2 50 595 617 ICV_69 $T=738880 662160 1 0 $X=738450 $Y=657605
X2767 1 2 638 667 656 ICV_69 $T=747280 732720 1 0 $X=746850 $Y=728165
X2768 1 2 705 713 708 ICV_69 $T=757360 732720 1 0 $X=756930 $Y=728165
X2769 1 2 719 50 706 ICV_69 $T=762400 654320 1 0 $X=761970 $Y=649765
X2770 1 2 761 693 747 ICV_69 $T=770800 693520 0 0 $X=770370 $Y=693130
X2771 1 2 802 727 799 ICV_69 $T=780880 693520 0 0 $X=780450 $Y=693130
X2772 1 2 461 876 866 ICV_69 $T=821760 779760 1 0 $X=821330 $Y=775205
X2773 1 2 461 926 922 ICV_69 $T=845840 771920 0 0 $X=845410 $Y=771530
X2774 1 2 461 125 908 ICV_69 $T=846400 740560 0 0 $X=845970 $Y=740170
X2775 1 2 1066 1096 1094 ICV_69 $T=886160 732720 1 0 $X=885730 $Y=728165
X2776 1 2 1045 978 1109 ICV_69 $T=888960 709200 1 0 $X=888530 $Y=704645
X2777 1 2 1056 176 1167 ICV_69 $T=896800 795440 0 0 $X=896370 $Y=795050
X2778 1 2 175 1087 1224 ICV_69 $T=907440 646480 0 0 $X=907010 $Y=646090
X2779 1 2 1429 1338 1455 ICV_69 $T=976320 638640 1 0 $X=975890 $Y=634085
X2780 1 2 461 1463 1439 ICV_69 $T=977440 771920 0 0 $X=977010 $Y=771530
X2781 1 2 46 1470 1484 ICV_69 $T=995360 732720 0 0 $X=994930 $Y=732330
X2782 1 2 1534 1530 1531 ICV_69 $T=998720 787600 1 0 $X=998290 $Y=783045
X2783 1 2 1517 1602 1599 ICV_69 $T=1012160 654320 0 0 $X=1011730 $Y=653930
X2784 1 2 1626 1644 1642 ICV_69 $T=1022800 732720 0 0 $X=1022370 $Y=732330
X2785 1 2 1656 1616 1658 ICV_69 $T=1029520 764080 0 0 $X=1029090 $Y=763690
X2786 1 2 46 1716 1724 ICV_69 $T=1057520 701360 1 0 $X=1057090 $Y=696805
X2787 1 2 461 1748 1772 ICV_69 $T=1076560 670000 0 0 $X=1076130 $Y=669610
X2788 1 2 43 1825 1823 ICV_69 $T=1100640 740560 0 0 $X=1100210 $Y=740170
X2789 1 2 40 1845 1869 ICV_69 $T=1119680 779760 0 0 $X=1119250 $Y=779370
X2790 1 2 34 1961 1950 ICV_69 $T=1158880 779760 0 0 $X=1158450 $Y=779370
X2791 1 2 1963 37 1966 ICV_69 $T=1163360 764080 0 0 $X=1162930 $Y=763690
X2792 1 2 36 1961 1968 ICV_69 $T=1163920 779760 0 0 $X=1163490 $Y=779370
X2793 1 2 1589 2085 2080 ICV_69 $T=1208720 654320 1 0 $X=1208290 $Y=649765
X2794 1 27 362 432 2 ICV_93 $T=662720 622960 0 0 $X=662290 $Y=622570
X2795 1 40 383 443 2 ICV_93 $T=667200 717040 1 0 $X=666770 $Y=712485
X2796 1 546 37 62 2 ICV_93 $T=706400 795440 1 0 $X=705970 $Y=790885
X2797 1 46 73 620 2 ICV_93 $T=735520 638640 1 0 $X=735090 $Y=634085
X2798 1 1094 1033 1091 2 ICV_93 $T=882800 756240 1 0 $X=882370 $Y=751685
X2799 1 1040 1041 1169 2 ICV_93 $T=894000 724880 0 0 $X=893570 $Y=724490
X2800 1 1187 1169 1185 2 ICV_93 $T=896240 717040 0 0 $X=895810 $Y=716650
X2801 1 1360 1356 1358 2 ICV_93 $T=952240 677840 1 0 $X=951810 $Y=673285
X2802 1 1422 50 1370 2 ICV_93 $T=963440 771920 1 0 $X=963010 $Y=767365
X2803 1 461 1409 1474 2 ICV_93 $T=976880 748400 0 0 $X=976450 $Y=748010
X2804 1 262 1763 261 2 ICV_93 $T=1074320 811120 0 0 $X=1073890 $Y=810730
X2805 1 126 1706 263 2 ICV_93 $T=1078240 622960 1 0 $X=1077810 $Y=618405
X2806 1 1822 37 273 2 ICV_93 $T=1096160 803280 1 0 $X=1095730 $Y=798725
X2807 1 1903 37 1902 2 ICV_93 $T=1133680 764080 1 0 $X=1133250 $Y=759525
X2808 1 1885 37 288 2 ICV_93 $T=1137040 771920 0 0 $X=1136610 $Y=771530
X2809 1 1962 1956 1972 2 ICV_93 $T=1162240 709200 0 0 $X=1161810 $Y=708810
X2810 1 1952 37 1985 2 ICV_93 $T=1166160 732720 1 0 $X=1165730 $Y=728165
X2811 1 1997 272 1991 2 ICV_93 $T=1168960 646480 1 0 $X=1168530 $Y=641925
X2883 1 2 389 10 382 ICV_91 $T=645360 662160 1 0 $X=644930 $Y=657605
X2884 1 2 382 361 393 ICV_91 $T=649840 654320 0 0 $X=649410 $Y=653930
X2885 1 2 32 362 400 ICV_91 $T=653760 622960 1 0 $X=653330 $Y=618405
X2886 1 2 34 413 441 ICV_91 $T=667760 779760 0 0 $X=667330 $Y=779370
X2887 1 2 450 37 431 ICV_91 $T=670560 764080 1 0 $X=670130 $Y=759525
X2888 1 2 34 388 454 ICV_91 $T=672800 795440 1 0 $X=672370 $Y=790885
X2889 1 2 40 466 482 ICV_91 $T=681200 756240 0 0 $X=680770 $Y=755850
X2890 1 2 34 515 588 ICV_91 $T=720400 803280 0 0 $X=719970 $Y=802890
X2891 1 2 760 739 761 ICV_91 $T=767440 685680 0 0 $X=767010 $Y=685290
X2892 1 2 461 709 763 ICV_91 $T=769120 740560 0 0 $X=768690 $Y=740170
X2893 1 2 693 660 777 ICV_91 $T=779760 701360 0 0 $X=779330 $Y=700970
X2894 1 2 902 50 871 ICV_91 $T=835760 764080 0 0 $X=835330 $Y=763690
X2895 1 2 998 991 974 ICV_91 $T=869360 756240 0 0 $X=868930 $Y=755850
X2896 1 2 1051 1052 1066 ICV_91 $T=881680 724880 1 0 $X=881250 $Y=720325
X2897 1 2 1004 1096 1101 ICV_91 $T=886160 724880 1 0 $X=885730 $Y=720325
X2898 1 2 1114 1108 1008 ICV_91 $T=887840 779760 0 0 $X=887410 $Y=779370
X2899 1 2 1126 1073 1121 ICV_91 $T=888960 732720 0 0 $X=888530 $Y=732330
X2900 1 2 177 1058 1118 ICV_91 $T=896240 771920 1 0 $X=895810 $Y=767365
X2901 1 2 991 978 1187 ICV_91 $T=898480 717040 1 0 $X=898050 $Y=712485
X2902 1 2 1185 955 1218 ICV_91 $T=902960 717040 1 0 $X=902530 $Y=712485
X2903 1 2 1087 1143 1228 ICV_91 $T=906880 630800 0 0 $X=906450 $Y=630410
X2904 1 2 1140 1124 1259 ICV_91 $T=915280 646480 0 0 $X=914850 $Y=646090
X2905 1 2 1251 1092 1266 ICV_91 $T=916400 787600 1 0 $X=915970 $Y=783045
X2906 1 2 1269 1163 1268 ICV_91 $T=916960 662160 1 0 $X=916530 $Y=657605
X2907 1 2 1361 1338 1347 ICV_91 $T=954480 646480 1 0 $X=954050 $Y=641925
X2908 1 2 1411 1396 1380 ICV_91 $T=964000 622960 0 0 $X=963570 $Y=622570
X2909 1 2 461 149 1417 ICV_91 $T=965120 756240 1 0 $X=964690 $Y=751685
X2910 1 2 126 1343 1428 ICV_91 $T=967360 685680 0 0 $X=966930 $Y=685290
X2911 1 2 1512 1452 1511 ICV_91 $T=990320 670000 1 0 $X=989890 $Y=665445
X2912 1 2 113 1430 1515 ICV_91 $T=992000 693520 0 0 $X=991570 $Y=693130
X2913 1 2 1509 1392 1520 ICV_91 $T=993120 662160 0 0 $X=992690 $Y=661770
X2914 1 2 1652 1636 1651 ICV_91 $T=1023920 795440 1 0 $X=1023490 $Y=790885
X2915 1 2 1675 1667 1680 ICV_91 $T=1034560 771920 1 0 $X=1034130 $Y=767365
X2916 1 2 43 1750 255 ICV_91 $T=1067600 795440 1 0 $X=1067170 $Y=790885
X2917 1 2 50 254 1783 ICV_91 $T=1085520 670000 0 0 $X=1085090 $Y=669610
X2918 1 2 461 1596 1846 ICV_91 $T=1105680 646480 0 0 $X=1105250 $Y=646090
X2919 1 2 1857 37 1866 ICV_91 $T=1117440 787600 1 0 $X=1117010 $Y=783045
X2920 1 2 1922 1914 1916 ICV_91 $T=1139840 740560 0 0 $X=1139410 $Y=740170
X2921 1 2 1929 50 1897 ICV_91 $T=1144880 630800 0 0 $X=1144450 $Y=630410
X2922 1 2 2017 1553 2015 ICV_91 $T=1177360 654320 0 0 $X=1176930 $Y=653930
X2923 1 2 2018 1553 2011 ICV_91 $T=1177920 662160 0 0 $X=1177490 $Y=661770
X2924 1 2 302 272 2026 ICV_91 $T=1185200 622960 0 0 $X=1184770 $Y=622570
X2925 1 2 2018 272 2039 ICV_91 $T=1186880 662160 0 0 $X=1186450 $Y=661770
X2926 4 6 2 1 336 XOR2X1 $T=627440 654320 1 180 $X=620850 $Y=653930
X2927 428 414 2 1 455 XOR2X1 $T=671120 662160 1 0 $X=670690 $Y=657605
X2928 439 423 2 1 472 XOR2X1 $T=675600 646480 1 0 $X=675170 $Y=641925
X2929 409 486 2 1 494 XOR2X1 $T=684000 638640 0 0 $X=683570 $Y=638250
X2930 363 541 2 1 544 XOR2X1 $T=704160 646480 0 0 $X=703730 $Y=646090
X2931 555 508 2 1 543 XOR2X1 $T=713120 693520 0 180 $X=706530 $Y=688965
X2932 586 561 2 1 566 XOR2X1 $T=723760 670000 0 180 $X=717170 $Y=665445
X2933 650 642 2 1 618 XOR2X1 $T=747840 685680 0 180 $X=741250 $Y=681125
X2934 683 660 2 1 691 XOR2X1 $T=762400 724880 0 180 $X=755810 $Y=720325
X2935 738 643 2 1 719 XOR2X1 $T=766880 646480 1 180 $X=760290 $Y=646090
X2936 725 709 2 1 751 XOR2X1 $T=762960 740560 0 0 $X=762530 $Y=740170
X2937 702 653 2 1 770 XOR2X1 $T=773600 685680 0 0 $X=773170 $Y=685290
X2938 770 727 2 1 805 XOR2X1 $T=778640 685680 1 0 $X=778210 $Y=681125
X2939 87 595 2 1 684 XOR2X1 $T=787040 677840 0 180 $X=780450 $Y=673285
X2940 828 774 2 1 824 XOR2X1 $T=796000 771920 1 0 $X=795570 $Y=767365
X2941 94 831 2 1 20 XOR2X1 $T=803280 638640 0 180 $X=796690 $Y=634085
X2942 98 838 2 1 683 XOR2X1 $T=811120 677840 0 180 $X=804530 $Y=673285
X2943 104 862 2 1 780 XOR2X1 $T=821760 693520 1 180 $X=815170 $Y=693130
X2944 868 849 2 1 856 XOR2X1 $T=822880 724880 0 180 $X=816290 $Y=720325
X2945 115 826 2 1 702 XOR2X1 $T=831840 709200 1 180 $X=825250 $Y=708810
X2946 110 752 2 1 885 XOR2X1 $T=825680 732720 0 0 $X=825250 $Y=732330
X2947 887 876 2 1 874 XOR2X1 $T=832960 779760 0 180 $X=826370 $Y=775205
X2948 890 102 2 1 881 XOR2X1 $T=833520 717040 0 180 $X=826930 $Y=712485
X2949 789 886 2 1 897 XOR2X1 $T=830160 748400 1 0 $X=829730 $Y=743845
X2950 118 898 2 1 362 XOR2X1 $T=838000 622960 1 180 $X=831410 $Y=622570
X2951 927 882 2 1 902 XOR2X1 $T=849200 787600 0 180 $X=842610 $Y=783045
X2952 941 926 2 1 933 XOR2X1 $T=857040 771920 1 180 $X=850450 $Y=771530
X2953 133 947 2 1 696 XOR2X1 $T=863760 630800 1 180 $X=857170 $Y=630410
X2954 136 953 2 1 22 XOR2X1 $T=865440 630800 0 180 $X=858850 $Y=626245
X2955 134 826 2 1 963 XOR2X1 $T=860960 709200 1 0 $X=860530 $Y=704645
X2956 137 595 2 1 978 XOR2X1 $T=864320 701360 0 0 $X=863890 $Y=700970
X2957 140 838 2 1 143 XOR2X1 $T=867680 622960 0 0 $X=867250 $Y=622570
X2958 980 963 2 1 998 XOR2X1 $T=869360 740560 1 0 $X=868930 $Y=736005
X2959 141 947 2 1 1016 XOR2X1 $T=871040 630800 0 0 $X=870610 $Y=630410
X2960 153 1049 2 1 758 XOR2X1 $T=882240 677840 0 180 $X=875650 $Y=673285
X2961 143 1016 2 1 1031 XOR2X1 $T=877200 638640 1 0 $X=876770 $Y=634085
X2962 147 149 2 1 1052 XOR2X1 $T=878320 701360 0 0 $X=877890 $Y=700970
X2963 158 521 2 1 980 XOR2X1 $T=880560 701360 1 0 $X=880130 $Y=696805
X2964 171 521 2 1 156 XOR2X1 $T=888960 701360 1 0 $X=888530 $Y=696805
X2965 1016 163 2 1 181 XOR2X1 $T=896800 622960 0 0 $X=896370 $Y=622570
X2966 179 1203 2 1 1020 XOR2X1 $T=901840 701360 0 0 $X=901410 $Y=700970
X2967 177 156 2 1 1221 XOR2X1 $T=904640 779760 0 0 $X=904210 $Y=779370
X2968 1111 1012 2 1 177 XOR2X1 $T=911360 803280 1 180 $X=904770 $Y=802890
X2969 189 149 2 1 1058 XOR2X1 $T=914160 771920 1 180 $X=907570 $Y=771530
X2970 193 829 2 1 180 XOR2X1 $T=918080 756240 1 180 $X=911490 $Y=755850
X2971 199 125 2 1 170 XOR2X1 $T=930400 779760 0 180 $X=923810 $Y=775205
X2972 1215 1275 2 1 1293 XOR2X1 $T=924800 764080 0 0 $X=924370 $Y=763690
X2973 198 125 2 1 1296 XOR2X1 $T=928720 740560 1 0 $X=928290 $Y=736005
X2974 202 519 2 1 1304 XOR2X1 $T=932640 724880 1 0 $X=932210 $Y=720325
X2975 207 205 2 1 1059 XOR2X1 $T=943840 779760 0 180 $X=937250 $Y=775205
X2976 208 529 2 1 209 XOR2X1 $T=941040 622960 1 0 $X=940610 $Y=618405
X2977 1270 1306 2 1 1315 XOR2X1 $T=943280 779760 0 0 $X=942850 $Y=779370
X2978 211 64 2 1 1366 XOR2X1 $T=953360 622960 1 0 $X=952930 $Y=618405
X2979 216 1336 2 1 1438 XOR2X1 $T=967360 764080 1 0 $X=966930 $Y=759525
X2980 1225 1406 2 1 1422 XOR2X1 $T=977440 771920 0 180 $X=970850 $Y=767365
X2981 222 1464 2 1 1111 XOR2X1 $T=981360 764080 0 180 $X=974770 $Y=759525
X2982 1246 1409 2 1 1472 XOR2X1 $T=975760 740560 0 0 $X=975330 $Y=740170
X2983 1452 1466 2 1 1424 XOR2X1 $T=983040 670000 1 180 $X=976450 $Y=669610
X2984 224 1298 2 1 1431 XOR2X1 $T=984720 622960 0 180 $X=978130 $Y=618405
X2985 1507 1463 2 1 1488 XOR2X1 $T=991440 795440 0 180 $X=984850 $Y=790885
X2986 228 1516 2 1 1338 XOR2X1 $T=996480 630800 0 180 $X=989890 $Y=626245
X2987 229 785 2 1 1364 XOR2X1 $T=996480 638640 0 180 $X=989890 $Y=634085
X2988 226 829 2 1 1530 XOR2X1 $T=993120 740560 0 0 $X=992690 $Y=740170
X2989 230 1516 2 1 1552 XOR2X1 $T=998160 630800 1 0 $X=997730 $Y=626245
X2990 231 953 2 1 1553 XOR2X1 $T=998160 638640 1 0 $X=997730 $Y=634085
X2991 232 1560 2 1 1407 XOR2X1 $T=1006560 646480 0 180 $X=999970 $Y=641925
X2992 1555 1304 2 1 1569 XOR2X1 $T=1003760 732720 0 0 $X=1003330 $Y=732330
X2993 235 785 2 1 1589 XOR2X1 $T=1006560 630800 1 0 $X=1006130 $Y=626245
X2994 237 1596 2 1 1361 XOR2X1 $T=1014400 638640 1 180 $X=1007810 $Y=638250
X2995 1304 1296 2 1 1611 XOR2X1 $T=1013280 740560 1 0 $X=1012850 $Y=736005
X2996 240 1596 2 1 1572 XOR2X1 $T=1017200 670000 0 0 $X=1016770 $Y=669610
X2997 1193 1646 2 1 1632 XOR2X1 $T=1026720 717040 1 180 $X=1020130 $Y=716650
X2998 1702 1727 2 1 1731 XOR2X1 $T=1054720 740560 1 0 $X=1054290 $Y=736005
X2999 1523 1748 2 1 1764 XOR2X1 $T=1067600 654320 1 0 $X=1067170 $Y=649765
X3000 1283 1765 2 1 1741 XOR2X1 $T=1074880 670000 1 180 $X=1068290 $Y=669610
X3001 1775 1759 2 1 1742 XOR2X1 $T=1081600 693520 1 180 $X=1075010 $Y=693130
X3002 1465 1787 2 1 1799 XOR2X1 $T=1083280 693520 0 0 $X=1082850 $Y=693130
X3003 1278 1812 2 1 1804 XOR2X1 $T=1100640 622960 1 180 $X=1094050 $Y=622570
X3004 271 1770 2 1 272 XOR2X1 $T=1094480 654320 0 0 $X=1094050 $Y=653930
X3005 1277 1820 2 1 1833 XOR2X1 $T=1099520 646480 0 0 $X=1099090 $Y=646090
X3006 1955 1944 2 1 1933 XOR2X1 $T=1158880 622960 1 180 $X=1152290 $Y=622570
X3007 1958 1904 2 1 1830 XOR2X1 $T=1160560 638640 1 180 $X=1153970 $Y=638250
X3008 1959 1937 2 1 1929 XOR2X1 $T=1160560 646480 1 180 $X=1153970 $Y=646090
X3044 1 2 36 420 425 ICV_59 $T=662720 771920 1 0 $X=662290 $Y=767365
X3045 1 2 36 387 438 ICV_59 $T=667200 795440 1 0 $X=666770 $Y=790885
X3046 1 2 43 445 462 ICV_59 $T=676160 701360 0 0 $X=675730 $Y=700970
X3047 1 2 40 464 498 ICV_59 $T=688480 756240 0 0 $X=688050 $Y=755850
X3048 1 2 40 491 537 ICV_59 $T=703040 787600 1 0 $X=702610 $Y=783045
X3049 1 2 43 644 604 ICV_59 $T=744480 787600 1 0 $X=744050 $Y=783045
X3050 1 2 684 653 676 ICV_59 $T=750640 693520 0 0 $X=750210 $Y=693130
X3051 1 2 693 696 658 ICV_59 $T=755120 701360 0 0 $X=754690 $Y=700970
X3052 1 2 46 759 768 ICV_59 $T=769680 677840 1 0 $X=769250 $Y=673285
X3053 1 2 773 767 776 ICV_59 $T=771360 732720 0 0 $X=770930 $Y=732330
X3054 1 2 823 810 822 ICV_59 $T=797120 756240 1 0 $X=796690 $Y=751685
X3055 1 2 461 831 853 ICV_59 $T=813920 756240 1 0 $X=813490 $Y=751685
X3056 1 2 461 882 848 ICV_59 $T=826800 771920 1 0 $X=826370 $Y=767365
X3057 1 2 979 963 976 ICV_59 $T=867680 756240 1 0 $X=867250 $Y=751685
X3058 1 2 1038 143 1039 ICV_59 $T=878880 630800 1 0 $X=878450 $Y=626245
X3059 1 2 1080 1071 1067 ICV_59 $T=883920 630800 0 0 $X=883490 $Y=630410
X3060 1 2 1069 165 166 ICV_59 $T=888400 622960 1 0 $X=887970 $Y=618405
X3061 1 2 1099 1045 1112 ICV_59 $T=889520 740560 0 0 $X=889090 $Y=740170
X3062 1 2 1145 1004 1142 ICV_59 $T=892880 740560 0 0 $X=892450 $Y=740170
X3063 1 2 1180 1150 1184 ICV_59 $T=899040 630800 0 0 $X=898610 $Y=630410
X3064 1 2 1219 1190 1211 ICV_59 $T=904640 748400 1 0 $X=904210 $Y=743845
X3065 1 2 1175 1016 1245 ICV_59 $T=911360 638640 0 0 $X=910930 $Y=638250
X3066 1 2 461 1306 1314 ICV_59 $T=944960 779760 1 0 $X=944530 $Y=775205
X3067 1 2 1359 1452 1506 ICV_59 $T=988640 654320 0 0 $X=988210 $Y=653930
X3068 1 2 1508 1402 1509 ICV_59 $T=989760 662160 0 0 $X=989330 $Y=661770
X3069 1 2 126 227 891 ICV_59 $T=993680 622960 1 0 $X=993250 $Y=618405
X3070 1 2 126 114 1517 ICV_59 $T=993680 630800 0 0 $X=993250 $Y=630410
X3071 1 2 1587 1552 1603 ICV_59 $T=1012160 764080 1 0 $X=1011730 $Y=759525
X3072 1 2 126 1524 1684 ICV_59 $T=1037360 654320 1 0 $X=1036930 $Y=649765
X3073 1 2 126 244 1717 ICV_59 $T=1048000 638640 0 0 $X=1047570 $Y=638250
X3074 1 2 461 1560 1728 ICV_59 $T=1062560 724880 1 0 $X=1062130 $Y=720325
X3075 1 2 461 254 1779 ICV_59 $T=1087200 654320 1 0 $X=1086770 $Y=649765
X3076 1 2 1819 1786 1817 ICV_59 $T=1098400 787600 0 0 $X=1097970 $Y=787210
X3077 1 2 1861 1854 1860 ICV_59 $T=1116320 764080 1 0 $X=1115890 $Y=759525
X3078 1 2 1869 1813 1868 ICV_59 $T=1119120 764080 0 0 $X=1118690 $Y=763690
X3079 1 2 1898 1887 1896 ICV_59 $T=1134800 724880 1 0 $X=1134370 $Y=720325
X3080 1 2 43 1874 1905 ICV_59 $T=1137600 701360 0 0 $X=1137170 $Y=700970
X3081 1 2 461 1516 1915 ICV_59 $T=1140960 630800 1 0 $X=1140530 $Y=626245
X3082 1 2 50 1516 1919 ICV_59 $T=1141520 638640 0 0 $X=1141090 $Y=638250
X3083 1 2 40 1885 1932 ICV_59 $T=1148240 764080 1 0 $X=1147810 $Y=759525
X3084 1 2 36 1928 1954 ICV_59 $T=1156080 764080 1 0 $X=1155650 $Y=759525
X3085 1 2 2025 2040 2045 ICV_59 $T=1190800 630800 0 0 $X=1190370 $Y=630410
X3086 1 2 2057 2049 2046 ICV_59 $T=1194160 654320 1 0 $X=1193730 $Y=649765
X3087 1 2 2085 272 2050 ICV_59 $T=1207600 662160 1 0 $X=1207170 $Y=657605
X3088 1 2 50 519 489 ICV_68 $T=695200 677840 1 0 $X=694770 $Y=673285
X3089 1 2 461 52 516 ICV_68 $T=697440 630800 1 0 $X=697010 $Y=626245
X3090 1 2 43 531 548 ICV_68 $T=706960 748400 0 0 $X=706530 $Y=748010
X3091 1 2 43 589 590 ICV_68 $T=720960 748400 1 0 $X=720530 $Y=743845
X3092 1 2 46 593 581 ICV_68 $T=722080 654320 1 0 $X=721650 $Y=649765
X3093 1 2 50 64 574 ICV_68 $T=722080 662160 0 0 $X=721650 $Y=661770
X3094 1 2 461 643 649 ICV_68 $T=747840 654320 0 0 $X=747410 $Y=653930
X3095 1 2 734 764 757 ICV_68 $T=766320 811120 1 0 $X=765890 $Y=806565
X3096 1 2 693 780 808 ICV_68 $T=783120 701360 1 0 $X=782690 $Y=696805
X3097 1 2 113 114 879 ICV_68 $T=825680 622960 0 0 $X=825250 $Y=622570
X3098 1 2 126 930 127 ICV_68 $T=845840 638640 1 0 $X=845410 $Y=634085
X3099 1 2 933 50 915 ICV_68 $T=847520 764080 0 0 $X=847090 $Y=763690
X3100 1 2 126 940 910 ICV_68 $T=849760 662160 0 0 $X=849330 $Y=661770
X3101 1 2 956 963 968 ICV_68 $T=863200 740560 1 0 $X=862770 $Y=736005
X3102 1 2 885 1052 1032 ICV_68 $T=876640 732720 1 0 $X=876210 $Y=728165
X3103 1 2 1048 1006 1056 ICV_68 $T=877760 795440 0 0 $X=877330 $Y=795050
X3104 1 2 1064 1073 1030 ICV_68 $T=881120 732720 0 0 $X=880690 $Y=732330
X3105 1 2 999 1089 1078 ICV_68 $T=882800 779760 0 0 $X=882370 $Y=779370
X3106 1 2 173 170 172 ICV_68 $T=891760 811120 1 0 $X=891330 $Y=806565
X3107 1 2 461 1298 1289 ICV_68 $T=930960 756240 1 0 $X=930530 $Y=751685
X3108 1 2 50 1336 1330 ICV_68 $T=947760 771920 0 0 $X=947330 $Y=771530
X3109 1 2 1374 1390 1360 ICV_68 $T=958400 677840 1 0 $X=957970 $Y=673285
X3110 1 2 1380 1392 1362 ICV_68 $T=958960 622960 0 0 $X=958530 $Y=622570
X3111 1 2 1548 1546 1521 ICV_68 $T=999840 764080 0 0 $X=999410 $Y=763690
X3112 1 2 1629 1546 1667 ICV_68 $T=1029520 771920 1 0 $X=1029090 $Y=767365
X3113 1 2 1643 1700 1705 ICV_68 $T=1040720 654320 1 0 $X=1040290 $Y=649765
X3114 1 2 461 1727 1737 ICV_68 $T=1060880 740560 1 0 $X=1060450 $Y=736005
X3115 1 2 461 1759 1761 ICV_68 $T=1073760 701360 0 0 $X=1073330 $Y=700970
X3116 1 2 46 268 1797 ICV_68 $T=1084400 646480 0 0 $X=1083970 $Y=646090
X3117 1 2 50 1049 1802 ICV_68 $T=1089440 693520 0 0 $X=1089010 $Y=693130
X3118 1 2 40 1857 1867 ICV_68 $T=1117440 756240 0 0 $X=1117010 $Y=755850
X3119 1 2 40 1827 1861 ICV_68 $T=1119680 764080 1 0 $X=1119250 $Y=759525
X3120 1 2 40 1910 1898 ICV_68 $T=1138160 724880 1 0 $X=1137730 $Y=720325
X3121 1 2 40 1918 1900 ICV_68 $T=1138720 709200 1 0 $X=1138290 $Y=704645
X3122 1 2 480 476 316 603 ICV_60 $T=678400 685680 1 0 $X=677970 $Y=681125
X3123 1 2 55 465 316 527 ICV_60 $T=678400 811120 0 0 $X=677970 $Y=810730
X3124 1 2 500 524 316 603 ICV_60 $T=684000 693520 0 0 $X=683570 $Y=693130
X3125 1 2 589 585 316 832 ICV_60 $T=712000 740560 1 0 $X=711570 $Y=736005
X3126 1 2 100 321 316 320 ICV_60 $T=797680 630800 1 0 $X=797250 $Y=626245
X3127 1 2 1241 1248 316 1037 ICV_60 $T=911360 693520 0 0 $X=910930 $Y=693130
X3128 1 2 1291 1294 316 1037 ICV_60 $T=914160 717040 1 0 $X=913730 $Y=712485
X3129 1 2 1298 1286 316 1037 ICV_60 $T=921440 748400 1 0 $X=921010 $Y=743845
X3130 1 2 1343 1310 316 1302 ICV_60 $T=944960 685680 1 0 $X=944530 $Y=681125
X3131 1 2 234 1570 316 217 ICV_60 $T=980800 811120 1 0 $X=980370 $Y=806565
X3132 1 2 1691 1681 316 1594 ICV_60 $T=1028960 701360 0 0 $X=1028530 $Y=700970
X3133 1 2 1701 1708 316 1594 ICV_60 $T=1028960 717040 1 0 $X=1028530 $Y=712485
X3134 1 2 1706 1705 316 323 ICV_60 $T=1031760 646480 1 0 $X=1031330 $Y=641925
X3135 1 2 1746 1743 316 253 ICV_60 $T=1057520 787600 1 0 $X=1057090 $Y=783045
X3136 1 2 1753 1755 316 1723 ICV_60 $T=1066480 646480 1 0 $X=1066050 $Y=641925
X3137 1 2 1878 1877 316 328 ICV_60 $T=1123040 677840 0 0 $X=1122610 $Y=677450
X3138 1 2 1904 1883 316 328 ICV_60 $T=1124160 654320 1 0 $X=1123730 $Y=649765
X3139 1 2 1937 1920 316 328 ICV_60 $T=1136480 662160 0 0 $X=1136050 $Y=661770
X3140 1 2 1945 1942 316 1926 ICV_60 $T=1143760 670000 0 0 $X=1143330 $Y=669610
X3164 1 2 36 413 436 ICV_92 $T=668880 771920 1 0 $X=668450 $Y=767365
X3165 1 2 658 672 659 ICV_92 $T=747840 701360 0 0 $X=747410 $Y=700970
X3166 1 2 881 50 884 ICV_92 $T=829040 724880 1 0 $X=828610 $Y=720325
X3167 1 2 976 1005 1018 ICV_92 $T=875520 756240 1 0 $X=875090 $Y=751685
X3168 1 2 176 183 999 ICV_92 $T=902960 803280 1 0 $X=902530 $Y=798725
X3169 1 2 1134 1237 1248 ICV_92 $T=912480 685680 1 0 $X=912050 $Y=681125
X3170 1 2 461 1336 1344 ICV_92 $T=952800 771920 0 0 $X=952370 $Y=771530
X3171 1 2 1341 1356 1337 ICV_92 $T=955600 654320 0 0 $X=955170 $Y=653930
X3172 1 2 46 1421 1416 ICV_92 $T=966800 740560 0 0 $X=966370 $Y=740170
X3173 1 2 1413 1372 1394 ICV_92 $T=967920 654320 1 0 $X=967490 $Y=649765
X3174 1 2 1363 1392 1485 ICV_92 $T=983040 670000 1 0 $X=982610 $Y=665445
X3175 1 2 50 953 1495 ICV_92 $T=985840 740560 0 0 $X=985410 $Y=740170
X3176 1 2 1540 1567 1548 ICV_92 $T=1003760 771920 0 0 $X=1003330 $Y=771530
X3177 1 2 43 1837 1840 ICV_92 $T=1105680 740560 0 0 $X=1105250 $Y=740170
X3178 1 2 461 1812 1853 ICV_92 $T=1114080 638640 1 0 $X=1113650 $Y=634085
X3179 1 2 43 1886 1914 ICV_92 $T=1144320 701360 1 0 $X=1143890 $Y=696805
X3180 1 2 36 1882 1925 ICV_92 $T=1144320 803280 1 0 $X=1143890 $Y=798725
X3181 1 2 40 1939 1922 ICV_92 $T=1149360 740560 1 0 $X=1148930 $Y=736005
X3182 1 2 36 1940 1899 ICV_92 $T=1150480 795440 1 0 $X=1150050 $Y=790885
X3183 1 2 2003 272 297 ICV_92 $T=1177920 622960 1 0 $X=1177490 $Y=618405
X3184 1 2 2016 302 2010 ICV_92 $T=1180720 638640 0 0 $X=1180290 $Y=638250
X3226 1 337 339 338 2 ICV_90 $T=617920 638640 1 0 $X=617490 $Y=634085
X3227 1 393 6 405 2 ICV_90 $T=654320 654320 0 0 $X=653890 $Y=653930
X3228 1 498 504 499 2 ICV_90 $T=686240 748400 1 0 $X=685810 $Y=743845
X3229 1 461 64 568 2 ICV_90 $T=713680 622960 0 0 $X=713250 $Y=622570
X3230 1 461 75 614 2 ICV_90 $T=741680 638640 1 0 $X=741250 $Y=634085
X3231 1 694 716 632 2 ICV_90 $T=754560 709200 1 0 $X=754130 $Y=704645
X3232 1 751 50 792 2 ICV_90 $T=773600 740560 0 0 $X=773170 $Y=740170
X3233 1 461 826 850 2 ICV_90 $T=810560 748400 1 0 $X=810130 $Y=743845
X3234 1 46 905 878 2 ICV_90 $T=836320 724880 1 0 $X=835890 $Y=720325
X3235 1 46 925 924 2 ICV_90 $T=842480 724880 1 0 $X=842050 $Y=720325
X3236 1 1032 1051 1010 2 ICV_90 $T=875520 724880 1 0 $X=875090 $Y=720325
X3237 1 1039 1055 1044 2 ICV_90 $T=876080 646480 0 0 $X=875650 $Y=646090
X3238 1 1084 169 1119 2 ICV_90 $T=887280 622960 0 0 $X=886850 $Y=622570
X3239 1 1132 980 1166 2 ICV_90 $T=894000 764080 0 0 $X=893570 $Y=763690
X3240 1 46 1291 1284 2 ICV_90 $T=923680 732720 0 0 $X=923250 $Y=732330
X3241 1 50 1298 1297 2 ICV_90 $T=929840 764080 1 0 $X=929410 $Y=759525
X3242 1 1490 1388 1469 2 ICV_90 $T=982480 685680 1 0 $X=982050 $Y=681125
X3243 1 1579 1582 1534 2 ICV_90 $T=1004880 787600 0 0 $X=1004450 $Y=787210
X3244 1 1598 1572 1626 2 ICV_90 $T=1013840 732720 0 0 $X=1013410 $Y=732330
X3245 1 1625 1693 1688 2 ICV_90 $T=1035680 779760 1 0 $X=1035250 $Y=775205
X3246 1 43 1793 1809 2 ICV_90 $T=1091120 764080 1 0 $X=1090690 $Y=759525
X3247 1 43 1949 1967 2 ICV_90 $T=1160000 732720 1 0 $X=1159570 $Y=728165
X3248 1 40 1979 1969 2 ICV_90 $T=1166160 717040 0 0 $X=1165730 $Y=716650
X3249 1 2051 2005 2055 2 ICV_90 $T=1191360 662160 0 0 $X=1190930 $Y=661770
X3269 1 2 369 359 368 ICV_70 $T=639760 662160 0 180 $X=636530 $Y=657605
X3270 1 2 40 385 446 ICV_70 $T=674480 732720 0 180 $X=671250 $Y=728165
X3271 1 2 40 384 451 ICV_70 $T=676160 717040 1 180 $X=672930 $Y=716650
X3272 1 2 461 541 560 ICV_70 $T=715920 662160 1 180 $X=712690 $Y=661770
X3273 1 2 824 50 823 ICV_70 $T=800480 756240 1 180 $X=797250 $Y=755850
X3274 1 2 50 829 833 ICV_70 $T=804400 724880 0 180 $X=801170 $Y=720325
X3275 1 2 50 831 851 ICV_70 $T=816720 764080 1 180 $X=813490 $Y=763690
X3276 1 2 50 826 844 ICV_70 $T=819520 764080 0 180 $X=816290 $Y=759525
X3277 1 2 113 112 883 ICV_70 $T=829040 622960 0 180 $X=825810 $Y=618405
X3278 1 2 461 862 903 ICV_70 $T=841920 748400 0 180 $X=838690 $Y=743845
X3279 1 2 1085 1031 1079 ICV_70 $T=887840 638640 1 180 $X=884610 $Y=638250
X3280 1 2 1127 997 1125 ICV_70 $T=894560 748400 0 180 $X=891330 $Y=743845
X3281 1 2 1152 1118 1153 ICV_70 $T=897920 771920 1 180 $X=894690 $Y=771530
X3282 1 2 1257 1271 1269 ICV_70 $T=922560 670000 0 180 $X=919330 $Y=665445
X3283 1 2 113 1115 1280 ICV_70 $T=932080 677840 1 180 $X=928850 $Y=677450
X3284 1 2 1591 1572 1527 ICV_70 $T=1013280 764080 1 180 $X=1010050 $Y=763690
X3285 1 2 1615 1562 1583 ICV_70 $T=1017200 756240 0 180 $X=1013970 $Y=751685
X3286 1 2 1630 1588 1551 ICV_70 $T=1028960 779760 0 180 $X=1025730 $Y=775205
X3287 1 2 113 1638 1697 ICV_70 $T=1043520 685680 1 180 $X=1040290 $Y=685290
X3288 1 2 40 269 1818 ICV_70 $T=1104000 779760 0 180 $X=1100770 $Y=775205
X3289 1 2 1892 1880 1891 ICV_70 $T=1136480 740560 0 180 $X=1133250 $Y=736005
X3290 1 2 1934 1905 1931 ICV_70 $T=1151040 709200 0 180 $X=1147810 $Y=704645
X3291 1 2 36 1964 1976 ICV_70 $T=1168960 740560 0 180 $X=1165730 $Y=736005
X3292 1 2 36 394 427 ICV_89 $T=662720 756240 0 0 $X=662290 $Y=755850
X3293 1 2 36 388 453 ICV_89 $T=673360 787600 0 0 $X=672930 $Y=787210
X3294 1 2 461 486 518 ICV_89 $T=694080 646480 1 0 $X=693650 $Y=641925
X3295 1 2 662 657 661 ICV_89 $T=746160 795440 0 0 $X=745730 $Y=795050
X3296 1 2 613 37 78 ICV_89 $T=746160 811120 0 0 $X=745730 $Y=810730
X3297 1 2 769 767 655 ICV_89 $T=769120 717040 0 0 $X=768690 $Y=716650
X3298 1 2 805 683 809 ICV_89 $T=784800 685680 1 0 $X=784370 $Y=681125
X3299 1 2 46 855 859 ICV_89 $T=817280 709200 0 0 $X=816850 $Y=708810
X3300 1 2 113 930 988 ICV_89 $T=869360 662160 0 0 $X=868930 $Y=661770
X3301 1 2 1022 988 1019 ICV_89 $T=874400 670000 1 0 $X=873970 $Y=665445
X3302 1 2 1092 1054 1089 ICV_89 $T=884480 787600 0 0 $X=884050 $Y=787210
X3303 1 2 991 1131 1001 ICV_89 $T=894560 732720 1 0 $X=894130 $Y=728165
X3304 1 2 1183 176 1148 ICV_89 $T=897920 795440 1 0 $X=897490 $Y=790885
X3305 1 2 183 178 1013 ICV_89 $T=900720 811120 1 0 $X=900290 $Y=806565
X3306 1 2 1208 1201 1183 ICV_89 $T=901840 795440 1 0 $X=901410 $Y=790885
X3307 1 2 1221 1207 1191 ICV_89 $T=904080 771920 0 0 $X=903650 $Y=771530
X3308 1 2 186 999 1222 ICV_89 $T=904640 811120 1 0 $X=904210 $Y=806565
X3309 1 2 1488 50 1449 ICV_89 $T=982480 764080 1 0 $X=982050 $Y=759525
X3310 1 2 1451 1356 1498 ICV_89 $T=984720 654320 0 0 $X=984290 $Y=653930
X3311 1 2 1496 1475 1499 ICV_89 $T=984720 677840 0 0 $X=984290 $Y=677450
X3312 1 2 1503 1496 1505 ICV_89 $T=988080 638640 0 0 $X=987650 $Y=638250
X3313 1 2 1510 1511 1513 ICV_89 $T=993120 677840 0 0 $X=992690 $Y=677450
X3314 1 2 1686 1616 1693 ICV_89 $T=1041840 779760 1 0 $X=1041410 $Y=775205
X3315 1 2 1816 1809 1814 ICV_89 $T=1097280 779760 1 0 $X=1096850 $Y=775205
X3316 1 2 50 947 1881 ICV_89 $T=1126400 646480 1 0 $X=1125970 $Y=641925
X3317 1 2 43 1855 1889 ICV_89 $T=1131440 701360 1 0 $X=1131010 $Y=696805
X3318 1 2 43 1876 1921 ICV_89 $T=1140960 701360 0 0 $X=1140530 $Y=700970
X3319 1 2 309 2065 2030 ICV_89 $T=1199200 662160 1 0 $X=1198770 $Y=657605
X3320 1 104 ANTENNA $T=818960 693520 1 0 $X=818530 $Y=688965
X3321 1 104 ANTENNA $T=821760 693520 0 0 $X=821330 $Y=693130
X3322 1 104 ANTENNA $T=822880 693520 0 0 $X=822450 $Y=693130
X3323 1 115 ANTENNA $T=831840 709200 0 0 $X=831410 $Y=708810
X3324 1 115 ANTENNA $T=832960 709200 0 0 $X=832530 $Y=708810
X3325 1 179 ANTENNA $T=900720 701360 0 0 $X=900290 $Y=700970
X3326 1 193 ANTENNA $T=918080 756240 0 0 $X=917650 $Y=755850
X3327 1 199 ANTENNA $T=930400 779760 1 0 $X=929970 $Y=775205
X3328 1 207 ANTENNA $T=943840 779760 1 0 $X=943410 $Y=775205
X3329 1 216 ANTENNA $T=966240 764080 1 0 $X=965810 $Y=759525
X3330 1 222 ANTENNA $T=981360 764080 1 0 $X=980930 $Y=759525
X3331 1 240 ANTENNA $T=1020000 677840 1 0 $X=1019570 $Y=673285
X3332 1 240 ANTENNA $T=1023360 670000 0 0 $X=1022930 $Y=669610
X3384 1 2 336 343 346 347 ICV_85 $T=622400 646480 0 0 $X=621970 $Y=646090
X3385 1 2 404 399 409 405 ICV_85 $T=656000 654320 1 0 $X=655570 $Y=649765
X3386 1 2 441 453 457 459 ICV_85 $T=672240 779760 0 0 $X=671810 $Y=779370
X3387 1 2 588 70 599 598 ICV_85 $T=724880 803280 0 0 $X=724450 $Y=802890
X3388 1 2 746 704 703 765 ICV_85 $T=765760 677840 0 0 $X=765330 $Y=677450
X3389 1 2 866 851 875 878 ICV_85 $T=818960 764080 0 0 $X=818530 $Y=763690
X3390 1 2 932 937 938 935 ICV_85 $T=848080 748400 1 0 $X=847650 $Y=743845
X3391 1 2 1067 1079 1086 161 ICV_85 $T=882240 630800 1 0 $X=881810 $Y=626245
X3392 1 2 1095 1125 1132 1122 ICV_85 $T=888400 764080 0 0 $X=887970 $Y=763690
X3393 1 2 1240 194 1274 1265 ICV_85 $T=916960 811120 1 0 $X=916530 $Y=806565
X3394 1 2 1318 1323 890 1334 ICV_85 $T=946640 677840 1 0 $X=946210 $Y=673285
X3395 1 2 1379 1405 1408 1413 ICV_85 $T=962320 646480 1 0 $X=961890 $Y=641925
X3396 1 2 1474 1495 1500 1502 ICV_85 $T=983040 748400 0 0 $X=982610 $Y=748010
X3397 1 2 1648 1530 1652 1588 ICV_85 $T=1023920 787600 0 0 $X=1023490 $Y=787210
X3398 1 2 1587 1616 1695 1304 ICV_85 $T=1037360 756240 0 0 $X=1036930 $Y=755850
X3399 1 2 1676 1690 1702 1685 ICV_85 $T=1039040 740560 0 0 $X=1038610 $Y=740170
X3400 1 2 1771 1779 1781 264 ICV_85 $T=1078800 646480 0 0 $X=1078370 $Y=646090
X3401 1 2 1849 1846 1863 280 ICV_85 $T=1114640 646480 0 0 $X=1114210 $Y=646090
X3402 1 2 1884 1899 1901 1893 ICV_85 $T=1133680 787600 0 0 $X=1133250 $Y=787210
X3403 1 2 1960 1968 1970 1966 ICV_85 $T=1161120 779760 1 0 $X=1160690 $Y=775205
X3404 1 2 2084 315 2092 313 ICV_85 $T=1212080 622960 1 0 $X=1211650 $Y=618405
X3405 1 2 374 23 373 ICV_73 $T=644240 654320 1 0 $X=643810 $Y=649765
X3406 1 2 443 448 447 ICV_73 $T=671680 709200 1 0 $X=671250 $Y=704645
X3407 1 2 451 462 460 ICV_73 $T=676160 717040 1 0 $X=675730 $Y=712485
X3408 1 2 43 503 496 ICV_73 $T=689600 717040 1 0 $X=689170 $Y=712485
X3409 1 2 40 534 528 ICV_73 $T=701920 764080 1 0 $X=701490 $Y=759525
X3410 1 2 537 548 547 ICV_73 $T=708080 787600 1 0 $X=707650 $Y=783045
X3411 1 2 587 590 591 ICV_73 $T=723200 764080 1 0 $X=722770 $Y=759525
X3412 1 2 46 869 873 ICV_73 $T=822320 717040 0 0 $X=821890 $Y=716650
X3413 1 2 46 931 935 ICV_73 $T=849760 717040 0 0 $X=849330 $Y=716650
X3414 1 2 943 945 944 ICV_73 $T=857600 662160 0 0 $X=857170 $Y=661770
X3415 1 2 1006 1013 144 ICV_73 $T=873840 811120 1 0 $X=873410 $Y=806565
X3416 1 2 50 205 1479 ICV_73 $T=982480 771920 0 0 $X=982050 $Y=771530
X3417 1 2 1472 50 1481 ICV_73 $T=983600 740560 1 0 $X=983170 $Y=736005
X3418 1 2 247 1722 1726 ICV_73 $T=1054720 811120 1 0 $X=1054290 $Y=806565
X3419 1 2 46 274 1810 ICV_73 $T=1100640 622960 0 0 $X=1100210 $Y=622570
X3420 1 2 40 1841 1835 ICV_73 $T=1104560 764080 1 0 $X=1104130 $Y=759525
X3421 1 2 445 442 316 452 ICV_95 $T=648160 701360 1 0 $X=647730 $Y=696805
X3422 1 2 420 419 316 452 ICV_95 $T=648160 740560 0 0 $X=647730 $Y=740170
X3423 1 2 569 565 316 832 ICV_95 $T=706960 732720 1 0 $X=706530 $Y=728165
X3424 1 2 674 668 316 72 ICV_95 $T=738880 630800 0 0 $X=738450 $Y=630410
X3425 1 2 926 913 316 899 ICV_95 $T=835200 779760 1 0 $X=834770 $Y=775205
X3426 1 2 119 900 316 120 ICV_95 $T=835760 803280 0 0 $X=835330 $Y=802890
X3427 1 2 931 929 316 899 ICV_95 $T=838000 717040 1 0 $X=837570 $Y=712485
X3428 1 2 1463 1433 316 217 ICV_95 $T=966240 779760 0 0 $X=965810 $Y=779370
X3429 1 2 220 1453 316 217 ICV_95 $T=966800 803280 1 0 $X=966370 $Y=798725
X3430 1 2 1528 1590 316 1594 ICV_95 $T=1012160 693520 1 0 $X=1011730 $Y=688965
X3431 1 2 1707 1689 316 323 ICV_95 $T=1036800 638640 1 0 $X=1036370 $Y=634085
X3432 1 2 1049 1735 316 1723 ICV_95 $T=1053040 693520 1 0 $X=1052610 $Y=688965
X3433 1 2 1795 1792 316 253 ICV_95 $T=1076560 740560 1 0 $X=1076130 $Y=736005
X3434 1 2 1825 1826 316 1768 ICV_95 $T=1091680 724880 1 0 $X=1091250 $Y=720325
X3435 1 2 947 1842 316 1723 ICV_95 $T=1092240 646480 1 0 $X=1091810 $Y=641925
X3436 1 2 1837 1831 316 1768 ICV_95 $T=1092240 717040 0 0 $X=1091810 $Y=716650
X3437 1 2 1848 1851 316 1768 ICV_95 $T=1092240 732720 0 0 $X=1091810 $Y=732330
X3438 1 2 1910 1896 316 1926 ICV_95 $T=1125840 732720 1 0 $X=1125410 $Y=728165
X3439 1 2 1918 1895 316 328 ICV_95 $T=1126400 717040 0 0 $X=1125970 $Y=716650
X3440 1 2 400 390 402 33 ICV_88 $T=654320 622960 0 0 $X=653890 $Y=622570
X3441 1 2 412 418 419 424 ICV_88 $T=660480 732720 0 0 $X=660050 $Y=732330
X3442 1 2 415 427 430 434 ICV_88 $T=663840 748400 0 0 $X=663410 $Y=748010
X3443 1 2 411 38 435 432 ICV_88 $T=664960 622960 1 0 $X=664530 $Y=618405
X3444 1 2 513 536 538 57 ICV_88 $T=701920 670000 0 0 $X=701490 $Y=669610
X3445 1 2 535 540 550 553 ICV_88 $T=706960 803280 1 0 $X=706530 $Y=798725
X3446 1 2 691 707 721 684 ICV_88 $T=759600 701360 1 0 $X=759170 $Y=696805
X3447 1 2 663 750 755 762 ICV_88 $T=766320 732720 1 0 $X=765890 $Y=728165
X3448 1 2 800 490 810 812 ICV_88 $T=784240 670000 1 0 $X=783810 $Y=665445
X3449 1 2 792 807 811 813 ICV_88 $T=784240 740560 1 0 $X=783810 $Y=736005
X3450 1 2 1065 1036 1070 1012 ICV_88 $T=882800 795440 0 0 $X=882370 $Y=795050
X3451 1 2 1102 1119 1080 1129 ICV_88 $T=888960 630800 0 0 $X=888530 $Y=630410
X3452 1 2 1178 1144 1193 1177 ICV_88 $T=899040 670000 0 0 $X=898610 $Y=669610
X3453 1 2 1204 169 1249 1162 ICV_88 $T=911360 646480 1 0 $X=910930 $Y=641925
X3454 1 2 1247 1253 1254 1231 ICV_88 $T=912480 654320 0 0 $X=912050 $Y=653930
X3455 1 2 1295 1297 1299 1300 ICV_88 $T=932640 756240 0 0 $X=932210 $Y=755850
X3456 1 2 1407 1392 1400 1364 ICV_88 $T=972400 638640 0 0 $X=971970 $Y=638250
X3457 1 2 1514 1483 1523 1518 ICV_88 $T=993680 646480 0 0 $X=993250 $Y=646090
X3458 1 2 2074 2078 2067 313 ICV_88 $T=1201440 630800 0 0 $X=1201010 $Y=630410
X3459 1 2 416 422 426 410 ICV_97 $T=659920 646480 1 0 $X=659490 $Y=641925
X3460 1 2 469 473 475 44 ICV_97 $T=677280 662160 1 0 $X=676850 $Y=657605
X3461 1 2 637 645 615 651 ICV_97 $T=741680 701360 0 0 $X=741250 $Y=700970
X3462 1 2 987 1021 1028 1011 ICV_97 $T=872720 764080 0 0 $X=872290 $Y=763690
X3463 1 2 1047 1127 1146 1131 ICV_97 $T=890080 748400 0 0 $X=889650 $Y=748010
X3464 1 2 1130 175 1171 1162 ICV_97 $T=895120 654320 1 0 $X=894690 $Y=649765
X3465 1 2 1216 1175 187 165 ICV_97 $T=906880 622960 0 0 $X=906450 $Y=622570
X3466 1 2 1234 1243 1251 1250 ICV_97 $T=909680 787600 0 0 $X=909250 $Y=787210
X3467 1 2 1140 1252 1253 1228 ICV_97 $T=910800 654320 1 0 $X=910370 $Y=649765
X3468 1 2 1259 1249 1264 1262 ICV_97 $T=915840 646480 1 0 $X=915410 $Y=641925
X3469 1 2 182 170 1272 1059 ICV_97 $T=915840 787600 0 0 $X=915410 $Y=787210
X3470 1 2 1314 1330 1342 1319 ICV_97 $T=948320 779760 1 0 $X=947890 $Y=775205
X3471 1 2 1373 1387 1391 1355 ICV_97 $T=957840 662160 0 0 $X=957410 $Y=661770
X3472 1 2 1351 1346 1396 1364 ICV_97 $T=958960 630800 0 0 $X=958530 $Y=630410
X3473 1 2 1545 1573 1568 1565 ICV_97 $T=1003200 756240 0 0 $X=1002770 $Y=755850
X3474 1 2 1578 1629 1571 1637 ICV_97 $T=1018320 764080 0 0 $X=1017890 $Y=763690
X3475 1 2 1635 1641 1644 1628 ICV_97 $T=1019440 740560 1 0 $X=1019010 $Y=736005
X3476 1 2 1578 1629 1654 1653 ICV_97 $T=1023360 771920 1 0 $X=1022930 $Y=767365
X3477 1 383 37 424 2 ICV_86 $T=662720 732720 1 0 $X=662290 $Y=728165
X3478 1 43 480 483 2 ICV_86 $T=681200 717040 0 0 $X=680770 $Y=716650
X3479 1 43 606 657 2 ICV_86 $T=743920 771920 0 0 $X=743490 $Y=771530
X3480 1 659 648 625 2 ICV_86 $T=745040 709200 1 0 $X=744610 $Y=704645
X3481 1 50 838 843 2 ICV_86 $T=807200 709200 0 0 $X=806770 $Y=708810
X3482 1 461 102 837 2 ICV_86 $T=810560 724880 1 0 $X=810130 $Y=720325
X3483 1 972 978 973 2 ICV_86 $T=864880 717040 0 0 $X=864450 $Y=716650
X3484 1 154 157 1006 2 ICV_86 $T=878320 803280 1 0 $X=877890 $Y=798725
X3485 1 1069 1084 1050 2 ICV_86 $T=881680 622960 0 0 $X=881250 $Y=622570
X3486 1 1076 1088 1085 2 ICV_86 $T=882240 646480 0 0 $X=881810 $Y=646090
X3487 1 1073 885 1122 2 ICV_86 $T=887840 756240 0 0 $X=887410 $Y=755850
X3488 1 46 1308 1319 2 ICV_86 $T=945520 732720 0 0 $X=945090 $Y=732330
X3489 1 46 1386 1385 2 ICV_86 $T=957280 740560 1 0 $X=956850 $Y=736005
X3490 1 1412 1372 1411 2 ICV_86 $T=964000 630800 1 0 $X=963570 $Y=626245
X3491 1 1497 1504 1503 2 ICV_86 $T=985280 646480 0 0 $X=984850 $Y=646090
X3492 1 46 1480 1494 2 ICV_86 $T=986960 732720 0 0 $X=986530 $Y=732330
X3493 1 1616 1296 1615 2 ICV_86 $T=1012720 756240 0 0 $X=1012290 $Y=755850
X3494 1 113 1604 1593 2 ICV_86 $T=1013280 685680 1 0 $X=1012850 $Y=681125
X3495 1 126 1638 1529 2 ICV_86 $T=1018320 685680 0 0 $X=1017890 $Y=685290
X3496 1 43 1746 1763 2 ICV_86 $T=1068720 811120 0 0 $X=1068290 $Y=810730
X3497 1 1818 1823 1824 2 ICV_86 $T=1097280 764080 1 0 $X=1096850 $Y=759525
X3498 1 461 1820 1821 2 ICV_86 $T=1104560 662160 1 0 $X=1104130 $Y=657605
X3499 1 43 1878 1887 2 ICV_86 $T=1129200 724880 1 0 $X=1128770 $Y=720325
X3500 1 1827 37 1893 2 ICV_86 $T=1131440 771920 0 0 $X=1131010 $Y=771530
X3501 1 43 1948 1956 2 ICV_86 $T=1154400 701360 1 0 $X=1153970 $Y=696805
X3502 1 40 1963 1962 2 ICV_86 $T=1157760 701360 0 0 $X=1157330 $Y=700970
X3503 1 305 2086 2021 2 ICV_86 $T=1210400 646480 1 0 $X=1209970 $Y=641925
X3504 1 2090 2092 2058 2 ICV_86 $T=1211520 622960 0 0 $X=1211090 $Y=622570
X3505 1 2 464 37 459 ICV_63 $T=678960 771920 0 180 $X=675730 $Y=767365
X3506 1 2 40 578 600 ICV_63 $T=735520 787600 0 180 $X=732290 $Y=783045
X3507 1 2 40 611 662 ICV_63 $T=750080 803280 0 180 $X=746850 $Y=798725
X3508 1 2 46 711 787 ICV_63 $T=779760 654320 0 180 $X=776530 $Y=649765
X3509 1 2 809 808 806 ICV_63 $T=788720 685680 1 180 $X=785490 $Y=685290
X3510 1 2 874 50 872 ICV_63 $T=824560 764080 0 180 $X=821330 $Y=759525
X3511 1 2 113 940 945 ICV_63 $T=865440 670000 0 180 $X=862210 $Y=665445
X3512 1 2 1069 1130 1150 ICV_63 $T=897920 638640 0 180 $X=894690 $Y=634085
X3513 1 2 1223 957 1242 ICV_63 $T=913040 740560 0 180 $X=909810 $Y=736005
X3514 1 2 1267 1111 1265 ICV_63 $T=920880 803280 1 180 $X=917650 $Y=802890
X3515 1 2 1328 1427 1444 ICV_63 $T=976320 646480 1 180 $X=973090 $Y=646090
X3516 1 2 1572 1637 1650 ICV_63 $T=1028400 764080 0 180 $X=1025170 $Y=759525
X3517 1 2 50 1464 1679 ICV_63 $T=1038480 732720 1 180 $X=1035250 $Y=732330
X3518 1 2 1731 50 1730 ICV_63 $T=1059760 732720 1 180 $X=1056530 $Y=732330
X3519 1 2 46 1721 1733 ICV_63 $T=1065360 670000 0 180 $X=1062130 $Y=665445
X3520 1 2 40 250 1776 ICV_63 $T=1083280 811120 1 180 $X=1080050 $Y=810730
X3521 1 2 1867 1862 1865 ICV_63 $T=1121920 748400 0 180 $X=1118690 $Y=743845
X3522 1 2 2063 2040 2054 ICV_63 $T=1199200 630800 0 180 $X=1195970 $Y=626245
X3523 1 2 466 484 316 452 ICV_94 $T=677280 748400 0 0 $X=676850 $Y=748010
X3524 1 2 564 563 316 603 ICV_94 $T=704160 685680 1 0 $X=703730 $Y=681125
X3525 1 2 75 610 316 72 ICV_94 $T=727120 654320 1 0 $X=726690 $Y=649765
X3526 1 2 643 636 316 72 ICV_94 $T=731600 662160 0 0 $X=731170 $Y=661770
X3527 1 2 595 697 316 95 ICV_94 $T=743920 662160 1 0 $X=743490 $Y=657605
X3528 1 2 92 825 316 97 ICV_94 $T=788160 779760 1 0 $X=787730 $Y=775205
X3529 1 2 101 319 316 320 ICV_94 $T=795440 622960 0 0 $X=795010 $Y=622570
X3530 1 2 838 852 316 834 ICV_94 $T=802720 701360 1 0 $X=802290 $Y=696805
X3531 1 2 107 870 316 97 ICV_94 $T=810000 787600 0 0 $X=809570 $Y=787210
X3532 1 2 919 918 316 834 ICV_94 $T=829040 670000 1 0 $X=828610 $Y=665445
X3533 1 2 958 970 316 132 ICV_94 $T=858160 685680 1 0 $X=857730 $Y=681125
X3534 1 2 1072 1287 316 1037 ICV_94 $T=899600 677840 0 0 $X=899170 $Y=677450
X3535 1 2 233 1619 316 323 ICV_94 $T=1010480 622960 1 0 $X=1010050 $Y=618405
X3536 1 2 1608 1623 316 323 ICV_94 $T=1010480 630800 0 0 $X=1010050 $Y=630410
X3537 1 2 238 1621 316 323 ICV_94 $T=1010480 654320 1 0 $X=1010050 $Y=649765
X3538 1 2 1604 1586 316 1594 ICV_94 $T=1010480 677840 0 0 $X=1010050 $Y=677450
X3539 1 2 1464 1659 316 1594 ICV_94 $T=1015520 732720 1 0 $X=1015090 $Y=728165
X3540 1 2 1709 1714 316 1594 ICV_94 $T=1030080 685680 1 0 $X=1029650 $Y=681125
X3541 1 2 1721 1719 316 1723 ICV_94 $T=1036240 662160 0 0 $X=1035810 $Y=661770
X3542 1 2 1751 1745 316 253 ICV_94 $T=1056960 771920 1 0 $X=1056530 $Y=767365
X3543 1 2 1766 1762 316 253 ICV_94 $T=1056960 779760 1 0 $X=1056530 $Y=775205
X3544 1 2 1787 1782 316 1768 ICV_94 $T=1070400 717040 1 0 $X=1069970 $Y=712485
X3545 1 2 1793 1790 316 253 ICV_94 $T=1073760 748400 0 0 $X=1073330 $Y=748010
X3546 1 2 1909 1908 316 283 ICV_94 $T=1124720 779760 0 0 $X=1124290 $Y=779370
X3547 1 2 1939 1916 316 1926 ICV_94 $T=1130880 748400 1 0 $X=1130450 $Y=743845
X3548 1 2 1961 1943 316 283 ICV_94 $T=1146560 787600 0 0 $X=1146130 $Y=787210
X3549 1 2 295 1980 316 283 ICV_94 $T=1157760 795440 1 0 $X=1157330 $Y=790885
X3550 1 2 615 621 619 ICV_84 $T=737200 701360 0 0 $X=736770 $Y=700970
X3551 1 2 652 660 633 ICV_84 $T=745040 724880 0 0 $X=744610 $Y=724490
X3552 1 2 718 729 586 ICV_84 $T=761280 677840 0 0 $X=760850 $Y=677450
X3553 1 2 758 696 623 ICV_84 $T=778640 677840 0 0 $X=778210 $Y=677450
X3554 1 2 1025 1029 1000 ICV_84 $T=874960 787600 0 0 $X=874530 $Y=787210
X3555 1 2 1012 1060 155 ICV_84 $T=878880 803280 0 0 $X=878450 $Y=802890
X3556 1 2 157 1012 1054 ICV_84 $T=882800 795440 1 0 $X=882370 $Y=790885
X3557 1 2 162 155 1098 ICV_84 $T=885600 811120 0 0 $X=885170 $Y=810730
X3558 1 2 1108 1123 1025 ICV_84 $T=888400 787600 0 0 $X=887970 $Y=787210
X3559 1 2 1322 1329 1318 ICV_84 $T=947760 670000 1 0 $X=947330 $Y=665445
X3560 1 2 1522 1526 941 ICV_84 $T=994240 771920 0 0 $X=993810 $Y=771530
X3561 1 2 1535 1541 1538 ICV_84 $T=997600 748400 0 0 $X=997170 $Y=748010
X3562 1 2 1572 1655 1641 ICV_84 $T=1025600 740560 1 0 $X=1025170 $Y=736005
X3563 1 2 1296 1653 1546 ICV_84 $T=1027840 748400 1 0 $X=1027410 $Y=743845
X3564 1 2 272 1999 1995 ICV_84 $T=1171200 630800 1 0 $X=1170770 $Y=626245
X3565 1 2 1996 2002 1999 ICV_84 $T=1171760 630800 0 0 $X=1171330 $Y=630410
X3566 1 2 1553 2007 2003 ICV_84 $T=1173440 662160 0 0 $X=1173010 $Y=661770
X3567 1 2 209 1589 2018 ICV_84 $T=1182400 662160 1 0 $X=1181970 $Y=657605
X3568 1 2 2086 305 2065 ICV_84 $T=1212640 638640 1 0 $X=1212210 $Y=634085
.ENDS
***************************************
.SUBCKT ICV_64
** N=4 EP=0 IP=8 FDC=0
.ENDS
***************************************
.SUBCKT ICV_57
** N=4 EP=0 IP=8 FDC=0
.ENDS
***************************************
.SUBCKT ICV_74
** N=4 EP=0 IP=16 FDC=0
.ENDS
***************************************
.SUBCKT ICV_75
** N=5 EP=0 IP=8 FDC=0
.ENDS
***************************************
.SUBCKT ICV_76
** N=7 EP=0 IP=10 FDC=0
.ENDS
***************************************
.SUBCKT ICV_67 1 2 3 4 5 6
** N=8 EP=6 IP=13 FDC=40
X1 4 6 2 5 1 2 3 DFFQSRX1 $T=25760 0 1 180 $X=130 $Y=-390
.ENDS
***************************************
.SUBCKT ICV_77 1 2 3 4 5 6 7 8 9 10 11 12 13 14 15 16 17 18 19 20
+ 21 22 23 24 25 26 27 28 29 30 31 32 33 34 35 36 37 38 39 40
+ 41 42 43 44 45 46 47 48 49 50 51 52 53 54 55 56 57 58 59 60
+ 61 62 63 64 65 66 67 68 69 70 71 72 73 74 75 76 77 78 79 80
+ 81 82 83 84 85 86 87 88 89 90 91 92 93 94 95 96 97 98 99 100
+ 101 102 103 104 105 106 107 108 109
** N=497 EP=109 IP=4754 FDC=4352
X227 50 283 1 2 282 OR2X1 $T=888960 818960 0 0 $X=888530 $Y=818570
X228 51 44 1 2 277 OR2X1 $T=895680 818960 1 180 $X=891890 $Y=818570
X229 288 59 1 2 284 OR2X1 $T=901840 826800 1 180 $X=898050 $Y=826410
X230 113 116 6 1 2 115 NAND3X1 $T=702480 826800 1 180 $X=698130 $Y=826410
X231 119 117 7 1 2 8 NAND3X1 $T=705280 818960 0 180 $X=700930 $Y=814405
X232 123 120 9 1 2 118 NAND3X1 $T=706960 834640 1 180 $X=702610 $Y=834250
X233 127 125 12 1 2 124 NAND3X1 $T=715360 842480 0 180 $X=711010 $Y=837925
X234 132 126 14 1 2 131 NAND3X1 $T=723760 818960 0 180 $X=719410 $Y=814405
X235 129 133 15 1 2 134 NAND3X1 $T=723760 834640 1 0 $X=723330 $Y=830085
X236 138 142 146 1 2 144 NAND3X1 $T=736640 850320 0 0 $X=736210 $Y=849930
X237 143 136 16 1 2 147 NAND3X1 $T=744480 834640 1 180 $X=740130 $Y=834250
X238 151 137 17 1 2 150 NAND3X1 $T=750640 826800 0 180 $X=746290 $Y=822245
X239 153 148 156 1 2 154 NAND3X1 $T=748960 850320 1 0 $X=748530 $Y=845765
X240 149 155 158 1 2 157 NAND3X1 $T=750080 858160 0 0 $X=749650 $Y=857770
X241 174 178 177 1 2 181 NAND3X1 $T=782560 858160 0 0 $X=782130 $Y=857770
X242 187 175 176 1 2 185 NAND3X1 $T=792080 850320 0 180 $X=787730 $Y=845765
X243 192 160 190 1 2 191 NAND3X1 $T=799360 850320 1 180 $X=795010 $Y=849930
X244 188 199 202 1 2 203 NAND3X1 $T=808320 858160 0 0 $X=807890 $Y=857770
X245 220 218 214 1 2 215 NAND3X1 $T=832960 858160 0 180 $X=828610 $Y=853605
X246 221 219 210 1 2 216 NAND3X1 $T=832960 866000 1 180 $X=828610 $Y=865610
X247 231 224 226 1 2 229 NAND3X1 $T=846960 866000 1 180 $X=842610 $Y=865610
X248 233 241 240 1 2 243 NAND3X1 $T=851440 866000 0 0 $X=851010 $Y=865610
X249 260 259 256 1 2 38 NAND3X1 $T=876080 818960 1 180 $X=871730 $Y=818570
X250 262 247 257 1 2 258 NAND3X1 $T=876080 858160 0 180 $X=871730 $Y=853605
X251 39 40 265 1 2 256 NAND3X1 $T=872720 818960 1 0 $X=872290 $Y=814405
X252 255 269 271 1 2 272 NAND3X1 $T=875520 866000 0 0 $X=875090 $Y=865610
X253 42 44 43 1 2 260 NAND3X1 $T=878880 818960 1 0 $X=878450 $Y=814405
X254 278 246 274 1 2 276 NAND3X1 $T=887280 866000 1 180 $X=882930 $Y=865610
X255 279 277 275 1 2 266 NAND3X1 $T=887840 826800 0 180 $X=883490 $Y=822245
X256 284 282 280 1 2 264 NAND3X1 $T=891760 826800 1 180 $X=887410 $Y=826410
X257 285 58 60 1 2 286 NAND3X1 $T=896800 818960 1 0 $X=896370 $Y=814405
X258 59 289 293 1 2 61 NAND3X1 $T=905200 818960 0 0 $X=904770 $Y=818570
X259 290 295 298 1 2 297 NAND3X1 $T=908000 866000 0 0 $X=907570 $Y=865610
X260 63 294 300 1 2 301 NAND3X1 $T=913040 818960 1 0 $X=912610 $Y=814405
X261 306 309 312 1 2 313 NAND3X1 $T=923120 866000 1 0 $X=922690 $Y=861445
X262 322 249 318 1 2 319 NAND3X1 $T=937680 866000 0 180 $X=933330 $Y=861445
X263 326 332 336 1 2 334 NAND3X1 $T=953360 873840 1 0 $X=952930 $Y=869285
X264 345 303 342 1 2 343 NAND3X1 $T=969040 873840 1 180 $X=964690 $Y=873450
X265 346 347 350 1 2 348 NAND3X1 $T=970720 858160 0 0 $X=970290 $Y=857770
X266 360 325 354 1 2 355 NAND3X1 $T=981920 858160 1 180 $X=977570 $Y=857770
X267 362 368 369 1 2 370 NAND3X1 $T=986960 873840 1 0 $X=986530 $Y=869285
X268 380 386 381 1 2 388 NAND3X1 $T=1012160 858160 1 0 $X=1011730 $Y=853605
X269 391 327 387 1 2 389 NAND3X1 $T=1018320 858160 1 180 $X=1013970 $Y=857770
X270 396 373 390 1 2 393 NAND3X1 $T=1024480 850320 1 180 $X=1020130 $Y=849930
X271 400 406 403 1 2 407 NAND3X1 $T=1037920 842480 0 0 $X=1037490 $Y=842090
X272 414 399 411 1 2 412 NAND3X1 $T=1059760 850320 1 180 $X=1055410 $Y=849930
X273 409 413 416 1 2 415 NAND3X1 $T=1056400 850320 1 0 $X=1055970 $Y=845765
X274 422 405 419 1 2 420 NAND3X1 $T=1070400 834640 1 180 $X=1066050 $Y=834250
X275 430 423 427 1 2 428 NAND3X1 $T=1082720 834640 1 180 $X=1078370 $Y=834250
X276 432 435 431 1 2 434 NAND3X1 $T=1091120 834640 0 180 $X=1086770 $Y=830085
X277 437 438 440 1 2 439 NAND3X1 $T=1093920 834640 1 0 $X=1093490 $Y=830085
X278 443 436 90 1 2 442 NAND3X1 $T=1104000 818960 1 180 $X=1099650 $Y=818570
X279 448 447 94 1 2 446 NAND3X1 $T=1124720 818960 1 180 $X=1120370 $Y=818570
X280 449 97 98 1 2 450 NAND3X1 $T=1139280 818960 1 0 $X=1138850 $Y=814405
X281 275 57 1 2 283 NOR2X1 $T=895680 818960 0 0 $X=895250 $Y=818570
X282 51 56 1 2 265 NOR2X1 $T=898480 818960 0 0 $X=898050 $Y=818570
X283 60 43 1 2 275 NOR2X1 $T=901840 818960 1 0 $X=901410 $Y=814405
X284 52 51 1 2 55 NOR2X1 $T=911360 826800 1 0 $X=910930 $Y=822245
X285 3 5 1 2 4 NAND2X1 $T=676160 818960 1 0 $X=675730 $Y=814405
X286 3 11 1 2 119 NAND2X1 $T=709760 818960 0 180 $X=706530 $Y=814405
X287 10 13 1 2 126 NAND2X1 $T=715360 818960 0 180 $X=712130 $Y=814405
X288 3 130 1 2 127 NAND2X1 $T=718160 842480 0 0 $X=717730 $Y=842090
X289 3 135 1 2 132 NAND2X1 $T=725440 818960 0 0 $X=725010 $Y=818570
X290 10 128 1 2 133 NAND2X1 $T=729360 842480 1 180 $X=726130 $Y=842090
X291 10 135 1 2 136 NAND2X1 $T=733280 834640 0 180 $X=730050 $Y=830085
X292 3 128 1 2 138 NAND2X1 $T=735520 850320 1 180 $X=732290 $Y=849930
X293 10 145 1 2 148 NAND2X1 $T=743360 850320 1 0 $X=742930 $Y=845765
X294 3 140 1 2 149 NAND2X1 $T=748400 858160 1 180 $X=745170 $Y=857770
X295 19 18 1 2 146 NAND2X1 $T=750080 818960 0 180 $X=746850 $Y=814405
X296 3 141 1 2 153 NAND2X1 $T=749520 850320 0 0 $X=749090 $Y=849930
X297 10 141 1 2 155 NAND2X1 $T=757920 858160 0 180 $X=754690 $Y=853605
X298 10 130 1 2 160 NAND2X1 $T=758480 850320 1 180 $X=755250 $Y=849930
X299 159 18 1 2 156 NAND2X1 $T=763520 842480 1 0 $X=763090 $Y=837925
X300 22 159 1 2 164 NAND2X1 $T=766320 818960 0 0 $X=765890 $Y=818570
X301 3 139 1 2 174 NAND2X1 $T=779760 858160 1 180 $X=776530 $Y=857770
X302 10 152 1 2 175 NAND2X1 $T=780880 850320 0 180 $X=777650 $Y=845765
X303 173 18 1 2 176 NAND2X1 $T=778640 842480 1 0 $X=778210 $Y=837925
X304 179 182 1 2 180 NAND2X1 $T=784240 826800 1 0 $X=783810 $Y=822245
X305 22 161 1 2 179 NAND2X1 $T=789840 826800 0 180 $X=786610 $Y=822245
X306 22 189 1 2 183 NAND2X1 $T=791520 842480 0 0 $X=791090 $Y=842090
X307 189 18 1 2 190 NAND2X1 $T=793200 850320 1 0 $X=792770 $Y=845765
X308 24 195 1 2 172 NAND2X1 $T=797680 826800 1 0 $X=797250 $Y=822245
X309 22 194 1 2 198 NAND2X1 $T=810000 850320 1 180 $X=806770 $Y=849930
X310 10 209 1 2 199 NAND2X1 $T=818400 866000 0 0 $X=817970 $Y=865610
X311 24 32 1 2 211 NAND2X1 $T=824560 818960 1 0 $X=824130 $Y=814405
X312 213 211 1 2 212 NAND2X1 $T=829040 826800 1 180 $X=825810 $Y=826410
X313 217 18 1 2 214 NAND2X1 $T=831280 850320 1 180 $X=828050 $Y=849930
X314 22 217 1 2 213 NAND2X1 $T=829040 834640 1 0 $X=828610 $Y=830085
X315 10 222 1 2 218 NAND2X1 $T=832960 866000 0 0 $X=832530 $Y=865610
X316 3 222 1 2 221 NAND2X1 $T=838560 866000 1 180 $X=835330 $Y=865610
X317 10 223 1 2 224 NAND2X1 $T=838560 866000 0 0 $X=838130 $Y=865610
X318 228 225 1 2 227 NAND2X1 $T=844720 834640 0 180 $X=841490 $Y=830085
X319 230 18 1 2 226 NAND2X1 $T=846400 858160 1 180 $X=843170 $Y=857770
X320 24 34 1 2 232 NAND2X1 $T=844720 834640 1 0 $X=844290 $Y=830085
X321 236 234 1 2 235 NAND2X1 $T=850320 842480 1 180 $X=847090 $Y=842090
X322 239 232 1 2 238 NAND2X1 $T=852560 834640 1 180 $X=849330 $Y=834250
X323 242 18 1 2 240 NAND2X1 $T=854800 858160 1 180 $X=851570 $Y=857770
X324 22 242 1 2 236 NAND2X1 $T=859280 850320 0 180 $X=856050 $Y=845765
X325 24 36 1 2 245 NAND2X1 $T=860400 834640 1 0 $X=859970 $Y=830085
X326 10 237 1 2 246 NAND2X1 $T=864880 866000 1 180 $X=861650 $Y=865610
X327 251 245 1 2 250 NAND2X1 $T=869360 834640 0 180 $X=866130 $Y=830085
X328 10 197 1 2 249 NAND2X1 $T=869360 866000 0 180 $X=866130 $Y=861445
X329 244 18 1 2 257 NAND2X1 $T=871040 850320 0 0 $X=870610 $Y=849930
X330 24 37 1 2 268 NAND2X1 $T=880000 834640 0 180 $X=876770 $Y=830085
X331 22 270 1 2 251 NAND2X1 $T=880000 834640 1 180 $X=876770 $Y=834250
X332 22 253 1 2 263 NAND2X1 $T=880000 850320 0 0 $X=879570 $Y=849930
X333 45 46 1 2 273 NAND2X1 $T=882800 818960 1 0 $X=882370 $Y=814405
X334 48 275 1 2 47 NAND2X1 $T=888400 818960 0 180 $X=885170 $Y=814405
X335 3 281 1 2 278 NAND2X1 $T=887280 866000 0 0 $X=886850 $Y=865610
X336 51 52 1 2 285 NAND2X1 $T=890080 818960 1 0 $X=889650 $Y=814405
X337 53 286 1 2 54 NAND2X1 $T=892880 818960 1 0 $X=892450 $Y=814405
X338 275 52 1 2 291 NAND2X1 $T=902400 818960 0 0 $X=901970 $Y=818570
X339 44 62 1 2 294 NAND2X1 $T=911360 818960 0 180 $X=908130 $Y=814405
X340 51 43 1 2 293 NAND2X1 $T=911920 818960 1 180 $X=908690 $Y=818570
X341 10 281 1 2 303 NAND2X1 $T=917520 873840 0 180 $X=914290 $Y=869285
X342 301 55 1 2 64 NAND2X1 $T=922000 818960 0 180 $X=918770 $Y=814405
X343 24 65 1 2 307 NAND2X1 $T=920880 834640 0 0 $X=920450 $Y=834250
X344 10 308 1 2 295 NAND2X1 $T=920880 873840 1 0 $X=920450 $Y=869285
X345 22 304 1 2 311 NAND2X1 $T=927600 834640 1 180 $X=924370 $Y=834250
X346 311 316 1 2 317 NAND2X1 $T=932080 834640 0 0 $X=931650 $Y=834250
X347 320 323 1 2 321 NAND2X1 $T=934880 834640 0 0 $X=934450 $Y=834250
X348 22 310 1 2 320 NAND2X1 $T=940480 834640 1 180 $X=937250 $Y=834250
X349 10 324 1 2 325 NAND2X1 $T=944960 866000 1 0 $X=944530 $Y=861445
X350 3 308 1 2 326 NAND2X1 $T=950560 873840 0 180 $X=947330 $Y=869285
X351 10 254 1 2 327 NAND2X1 $T=952800 858160 1 180 $X=949570 $Y=857770
X352 22 335 1 2 333 NAND2X1 $T=954480 842480 0 0 $X=954050 $Y=842090
X353 22 339 1 2 337 NAND2X1 $T=956160 850320 1 0 $X=955730 $Y=845765
X354 24 330 1 2 338 NAND2X1 $T=956720 834640 1 0 $X=956290 $Y=830085
X355 337 338 1 2 340 NAND2X1 $T=961760 850320 0 180 $X=958530 $Y=845765
X356 339 18 1 2 342 NAND2X1 $T=964560 866000 1 0 $X=964130 $Y=861445
X357 3 302 1 2 346 NAND2X1 $T=971280 866000 0 180 $X=968050 $Y=861445
X358 344 18 1 2 350 NAND2X1 $T=972960 850320 0 0 $X=972530 $Y=849930
X359 24 71 1 2 358 NAND2X1 $T=978560 826800 1 0 $X=978130 $Y=822245
X360 356 358 1 2 357 NAND2X1 $T=978560 826800 0 0 $X=978130 $Y=826410
X361 359 18 1 2 354 NAND2X1 $T=981920 858160 0 180 $X=978690 $Y=853605
X362 22 359 1 2 353 NAND2X1 $T=979680 842480 1 0 $X=979250 $Y=837925
X363 22 344 1 2 356 NAND2X1 $T=984160 826800 1 180 $X=980930 $Y=826410
X364 24 72 1 2 365 NAND2X1 $T=984160 826800 0 0 $X=983730 $Y=826410
X365 10 371 1 2 368 NAND2X1 $T=993680 873840 0 0 $X=993250 $Y=873450
X366 10 349 1 2 373 NAND2X1 $T=1001520 873840 0 180 $X=998290 $Y=869285
X367 24 74 1 2 379 NAND2X1 $T=1008800 818960 0 0 $X=1008370 $Y=818570
X368 383 379 1 2 382 NAND2X1 $T=1013280 826800 0 180 $X=1010050 $Y=822245
X369 22 384 1 2 378 NAND2X1 $T=1011040 842480 1 0 $X=1010610 $Y=837925
X370 3 392 1 2 391 NAND2X1 $T=1019440 858160 0 0 $X=1019010 $Y=857770
X371 24 77 1 2 397 NAND2X1 $T=1030080 818960 0 180 $X=1026850 $Y=814405
X372 395 18 1 2 387 NAND2X1 $T=1027280 842480 1 0 $X=1026850 $Y=837925
X373 3 376 1 2 400 NAND2X1 $T=1034560 850320 1 180 $X=1031330 $Y=849930
X374 10 392 1 2 399 NAND2X1 $T=1034560 858160 0 180 $X=1031330 $Y=853605
X375 404 397 1 2 401 NAND2X1 $T=1036240 818960 0 180 $X=1033010 $Y=814405
X376 394 18 1 2 403 NAND2X1 $T=1033440 842480 1 0 $X=1033010 $Y=837925
X377 22 394 1 2 404 NAND2X1 $T=1040160 826800 1 180 $X=1036930 $Y=826410
X378 402 80 1 2 408 NAND2X1 $T=1040160 826800 0 0 $X=1039730 $Y=826410
X379 22 83 1 2 81 NAND2X1 $T=1054720 818960 0 0 $X=1054290 $Y=818570
X380 410 18 1 2 416 NAND2X1 $T=1060880 834640 0 0 $X=1060450 $Y=834250
X381 10 418 1 2 423 NAND2X1 $T=1072080 850320 0 180 $X=1068850 $Y=845765
X382 10 424 1 2 386 NAND2X1 $T=1071520 858160 1 0 $X=1071090 $Y=853605
X383 10 398 1 2 87 NAND2X1 $T=1080480 834640 0 180 $X=1077250 $Y=830085
X384 429 18 1 2 427 NAND2X1 $T=1081040 826800 1 180 $X=1077810 $Y=826410
X385 88 18 1 2 431 NAND2X1 $T=1083840 826800 1 0 $X=1083410 $Y=822245
X386 10 433 1 2 406 NAND2X1 $T=1083840 834640 1 0 $X=1083410 $Y=830085
X387 3 426 1 2 432 NAND2X1 $T=1087200 842480 0 180 $X=1083970 $Y=837925
X388 10 425 1 2 436 NAND2X1 $T=1091680 826800 1 180 $X=1088450 $Y=826410
X389 3 424 1 2 437 NAND2X1 $T=1096160 834640 1 180 $X=1092930 $Y=834250
X390 10 444 1 2 435 NAND2X1 $T=1101200 834640 1 0 $X=1100770 $Y=830085
X391 3 444 1 2 448 NAND2X1 $T=1124720 826800 0 180 $X=1121490 $Y=822245
X392 10 95 1 2 447 NAND2X1 $T=1125840 818960 1 0 $X=1125410 $Y=814405
X393 3 95 1 2 96 NAND2X1 $T=1131440 818960 0 180 $X=1128210 $Y=814405
X394 31 30 195 1 2 208 MUX2X1 $T=815040 818960 1 0 $X=814610 $Y=814405
X395 66 30 315 1 2 314 MUX2X1 $T=934320 826800 0 180 $X=928290 $Y=822245
X396 69 30 330 1 2 329 MUX2X1 $T=959520 818960 1 180 $X=953490 $Y=818570
X397 73 30 361 1 2 375 MUX2X1 $T=998160 818960 1 0 $X=997730 $Y=814405
X441 291 292 1 2 288 AND2X1 $T=905760 826800 1 180 $X=901970 $Y=826410
X453 264 1 2 259 INVX2 $T=876640 826800 1 180 $X=874530 $Y=826410
X454 49 1 2 279 INVX2 $T=888400 818960 1 0 $X=887970 $Y=814405
X455 265 1 2 289 INVX2 $T=900720 826800 1 0 $X=900290 $Y=822245
X456 43 1 2 62 INVX2 $T=911360 818960 1 0 $X=910930 $Y=814405
X457 78 1 2 79 INVX2 $T=1034560 881680 0 0 $X=1034130 $Y=881290
X477 115 163 2 79 1 2 114 DFFQSRX1 $T=689040 826800 1 0 $X=688610 $Y=822245
X478 118 163 2 79 1 2 121 DFFQSRX1 $T=692960 842480 0 0 $X=692530 $Y=842090
X479 124 163 2 79 1 2 130 DFFQSRX1 $T=707520 850320 0 0 $X=707090 $Y=849930
X480 131 163 2 79 1 2 135 DFFQSRX1 $T=714240 826800 1 0 $X=713810 $Y=822245
X481 147 163 2 79 1 2 145 DFFQSRX1 $T=730480 842480 1 0 $X=730050 $Y=837925
X482 150 163 2 79 1 2 152 DFFQSRX1 $T=736080 826800 0 0 $X=735650 $Y=826410
X483 157 163 2 79 1 2 140 DFFQSRX1 $T=762400 866000 1 180 $X=736770 $Y=865610
X484 154 163 2 79 1 2 141 DFFQSRX1 $T=763520 873840 1 180 $X=737890 $Y=873450
X485 165 99 2 79 1 2 159 DFFQSRX1 $T=780320 826800 0 180 $X=754690 $Y=822245
X486 169 163 2 79 1 2 173 DFFQSRX1 $T=755680 834640 0 0 $X=755250 $Y=834250
X487 180 99 2 79 1 2 161 DFFQSRX1 $T=784240 834640 0 180 $X=758610 $Y=830085
X488 181 100 2 79 1 2 139 DFFQSRX1 $T=789840 873840 1 180 $X=764210 $Y=873450
X489 184 99 2 79 1 2 189 DFFQSRX1 $T=789840 834640 0 0 $X=789410 $Y=834250
X490 191 100 2 79 1 2 193 DFFQSRX1 $T=789840 873840 1 0 $X=789410 $Y=869285
X491 185 100 2 79 1 2 197 DFFQSRX1 $T=789840 873840 0 0 $X=789410 $Y=873450
X492 201 99 2 79 1 2 207 DFFQSRX1 $T=799360 834640 1 0 $X=798930 $Y=830085
X493 204 100 2 79 1 2 194 DFFQSRX1 $T=824560 850320 0 180 $X=798930 $Y=845765
X494 208 100 2 79 1 2 195 DFFQSRX1 $T=830160 826800 0 180 $X=804530 $Y=822245
X495 212 100 2 79 1 2 217 DFFQSRX1 $T=815040 842480 1 0 $X=814610 $Y=837925
X496 216 100 2 79 1 2 222 DFFQSRX1 $T=821200 873840 1 0 $X=820770 $Y=869285
X497 227 100 2 79 1 2 230 DFFQSRX1 $T=831280 850320 1 0 $X=830850 $Y=845765
X498 101 100 2 79 1 2 35 DFFQSRX1 $T=835760 818960 1 0 $X=835330 $Y=814405
X499 243 248 2 79 1 2 206 DFFQSRX1 $T=860960 881680 0 180 $X=835330 $Y=877125
X500 229 248 2 79 1 2 237 DFFQSRX1 $T=836880 889520 1 0 $X=836450 $Y=884965
X501 235 100 2 79 1 2 242 DFFQSRX1 $T=838000 858160 1 0 $X=837570 $Y=853605
X502 102 100 2 79 1 2 37 DFFQSRX1 $T=840240 826800 0 0 $X=839810 $Y=826410
X503 238 100 2 79 1 2 244 DFFQSRX1 $T=840240 842480 1 0 $X=839810 $Y=837925
X504 272 248 2 79 1 2 209 DFFQSRX1 $T=888400 881680 1 180 $X=862770 $Y=881290
X505 250 248 2 79 1 2 270 DFFQSRX1 $T=867120 842480 0 0 $X=866690 $Y=842090
X506 267 248 2 79 1 2 253 DFFQSRX1 $T=895680 850320 0 180 $X=870050 $Y=845765
X507 258 248 2 79 1 2 254 DFFQSRX1 $T=895680 858160 1 180 $X=870050 $Y=857770
X508 297 248 2 79 1 2 252 DFFQSRX1 $T=895680 873840 0 180 $X=870050 $Y=869285
X509 305 248 2 79 1 2 296 DFFQSRX1 $T=904640 842480 0 0 $X=904210 $Y=842090
X510 317 104 2 79 1 2 304 DFFQSRX1 $T=942720 850320 1 180 $X=917090 $Y=849930
X511 314 248 2 79 1 2 315 DFFQSRX1 $T=918640 834640 1 0 $X=918210 $Y=830085
X512 321 104 2 79 1 2 310 DFFQSRX1 $T=950560 842480 0 180 $X=924930 $Y=837925
X513 334 104 2 79 1 2 308 DFFQSRX1 $T=962320 881680 0 180 $X=936690 $Y=877125
X514 331 104 2 79 1 2 335 DFFQSRX1 $T=943280 834640 0 0 $X=942850 $Y=834250
X515 340 104 2 79 1 2 339 DFFQSRX1 $T=943840 850320 0 0 $X=943410 $Y=849930
X516 348 104 2 79 1 2 302 DFFQSRX1 $T=984160 873840 0 180 $X=958530 $Y=869285
X517 105 106 2 79 1 2 72 DFFQSRX1 $T=966800 818960 1 0 $X=966370 $Y=814405
X518 370 76 2 79 1 2 341 DFFQSRX1 $T=995920 881680 0 180 $X=970290 $Y=877125
X519 367 104 2 79 1 2 364 DFFQSRX1 $T=975760 850320 0 0 $X=975330 $Y=849930
X520 375 76 2 79 1 2 361 DFFQSRX1 $T=1006560 826800 0 180 $X=980930 $Y=822245
X521 388 76 2 79 1 2 371 DFFQSRX1 $T=1022800 873840 1 180 $X=997170 $Y=873450
X522 389 76 2 79 1 2 392 DFFQSRX1 $T=1008240 866000 0 0 $X=1007810 $Y=865610
X523 382 76 2 79 1 2 385 DFFQSRX1 $T=1012160 826800 0 0 $X=1011730 $Y=826410
X524 377 76 2 79 1 2 384 DFFQSRX1 $T=1012160 842480 0 0 $X=1011730 $Y=842090
X525 401 76 2 79 1 2 394 DFFQSRX1 $T=1048000 818960 1 180 $X=1022370 $Y=818570
X526 407 82 2 79 1 2 376 DFFQSRX1 $T=1051920 858160 1 180 $X=1026290 $Y=857770
X527 415 82 2 79 1 2 372 DFFQSRX1 $T=1069840 866000 1 180 $X=1044210 $Y=865610
X528 107 108 2 79 1 2 429 DFFQSRX1 $T=1066480 818960 1 0 $X=1066050 $Y=814405
X529 434 82 2 79 1 2 426 DFFQSRX1 $T=1105120 850320 0 180 $X=1079490 $Y=845765
X530 428 82 2 79 1 2 441 DFFQSRX1 $T=1087200 842480 1 0 $X=1086770 $Y=837925
X531 442 82 2 79 1 2 445 DFFQSRX1 $T=1092240 826800 1 0 $X=1091810 $Y=822245
X558 21 1 2 163 BUFX1 $T=765760 818960 0 180 $X=762530 $Y=814405
X559 21 1 2 248 BUFX1 $T=864320 842480 0 0 $X=863890 $Y=842090
X560 75 1 2 76 BUFX1 $T=1012160 818960 0 0 $X=1011730 $Y=818570
X561 75 1 2 82 BUFX1 $T=1054160 826800 0 0 $X=1053730 $Y=826410
X586 1 2 3 114 113 ICV_61 $T=694080 826800 0 0 $X=693650 $Y=826410
X587 1 2 10 121 117 ICV_61 $T=703040 818960 0 0 $X=702610 $Y=818570
X588 1 2 10 122 116 ICV_61 $T=703040 834640 1 0 $X=702610 $Y=830085
X589 1 2 3 122 129 ICV_61 $T=717600 834640 1 0 $X=717170 $Y=830085
X590 1 2 10 5 137 ICV_61 $T=730480 818960 1 0 $X=730050 $Y=814405
X591 1 2 10 139 120 ICV_61 $T=732160 850320 1 0 $X=731730 $Y=845765
X592 1 2 3 145 143 ICV_61 $T=737200 834640 0 0 $X=736770 $Y=834250
X593 1 2 3 152 151 ICV_61 $T=746720 834640 0 0 $X=746290 $Y=834250
X594 1 2 22 173 171 ICV_61 $T=766320 842480 1 0 $X=765890 $Y=837925
X595 1 2 161 18 177 ICV_61 $T=782560 842480 0 0 $X=782130 $Y=842090
X596 1 2 24 27 186 ICV_61 $T=792080 818960 0 0 $X=791650 $Y=818570
X597 1 2 3 197 187 ICV_61 $T=801040 858160 1 0 $X=800610 $Y=853605
X598 1 2 10 206 178 ICV_61 $T=811680 866000 0 0 $X=811250 $Y=865610
X599 1 2 24 33 225 ICV_61 $T=838560 834640 1 0 $X=838130 $Y=830085
X600 1 2 253 18 274 ICV_61 $T=881680 858160 1 0 $X=881250 $Y=853605
X601 1 2 3 254 262 ICV_61 $T=885040 858160 1 0 $X=884610 $Y=853605
X602 1 2 56 58 292 ICV_61 $T=908000 826800 0 0 $X=907570 $Y=826410
X603 1 2 296 18 298 ICV_61 $T=909680 850320 0 0 $X=909250 $Y=849930
X604 1 2 3 349 345 ICV_61 $T=971280 873840 0 0 $X=970850 $Y=873450
X605 1 2 22 364 363 ICV_61 $T=982480 842480 1 0 $X=982050 $Y=837925
X606 1 2 3 398 396 ICV_61 $T=1026720 850320 0 0 $X=1026290 $Y=849930
X607 1 2 85 18 419 ICV_61 $T=1072640 826800 1 0 $X=1072210 $Y=822245
X608 1 2 3 441 430 ICV_61 $T=1097840 834640 1 0 $X=1097410 $Y=830085
X609 1 2 10 441 91 ICV_61 $T=1104000 834640 1 0 $X=1103570 $Y=830085
X610 1 2 10 92 438 ICV_61 $T=1110160 818960 1 0 $X=1109730 $Y=814405
X611 1 2 10 445 93 ICV_61 $T=1115200 818960 0 0 $X=1114770 $Y=818570
X612 1 2 3 121 123 ICV_62 $T=706400 834640 1 0 $X=705970 $Y=830085
X613 1 2 164 166 165 ICV_62 $T=761840 818960 0 0 $X=761410 $Y=818570
X614 1 2 24 25 166 ICV_62 $T=776960 818960 1 0 $X=776530 $Y=814405
X615 1 2 183 186 184 ICV_62 $T=785360 834640 0 0 $X=784930 $Y=834250
X616 1 2 24 28 196 ICV_62 $T=799920 818960 0 0 $X=799490 $Y=818570
X617 1 2 22 230 228 ICV_62 $T=841920 834640 0 0 $X=841490 $Y=834250
X618 1 2 3 237 231 ICV_62 $T=846960 866000 0 0 $X=846530 $Y=865610
X619 1 2 22 244 239 ICV_62 $T=852560 834640 0 0 $X=852130 $Y=834250
X620 1 2 10 252 219 ICV_62 $T=864880 873840 1 0 $X=864450 $Y=869285
X621 1 2 261 266 41 ICV_62 $T=872720 826800 1 0 $X=872290 $Y=822245
X622 1 2 24 315 316 ICV_62 $T=927600 834640 0 0 $X=927170 $Y=834250
X623 1 2 310 18 318 ICV_62 $T=934320 858160 1 0 $X=933890 $Y=853605
X624 1 2 24 68 328 ICV_62 $T=948880 834640 1 0 $X=948450 $Y=830085
X625 1 2 3 366 360 ICV_62 $T=981920 858160 0 0 $X=981490 $Y=857770
X626 1 2 364 18 369 ICV_62 $T=986400 858160 0 0 $X=985970 $Y=857770
X627 1 2 10 426 413 ICV_62 $T=1073760 850320 0 0 $X=1073330 $Y=849930
X628 1 2 22 429 86 ICV_62 $T=1076000 826800 1 0 $X=1075570 $Y=822245
X629 1 2 3 445 443 ICV_62 $T=1104000 818960 0 0 $X=1103570 $Y=818570
X668 1 2 3 193 192 ICV_69 $T=796000 858160 1 0 $X=795570 $Y=853605
X669 1 2 24 29 200 ICV_69 $T=810000 818960 1 0 $X=809570 $Y=814405
X670 1 2 207 18 210 ICV_69 $T=822320 858160 1 0 $X=821890 $Y=853605
X671 1 2 263 268 267 ICV_69 $T=874960 850320 0 0 $X=874530 $Y=849930
X672 1 2 273 43 261 ICV_69 $T=878880 826800 1 0 $X=878450 $Y=822245
X673 1 2 3 324 322 ICV_69 $T=939920 866000 1 0 $X=939490 $Y=861445
X674 1 2 24 67 323 ICV_69 $T=943840 834640 1 0 $X=943410 $Y=830085
X675 1 2 10 341 332 ICV_69 $T=960080 873840 0 0 $X=959650 $Y=873450
X676 1 2 24 70 351 ICV_69 $T=973520 826800 1 0 $X=973090 $Y=822245
X677 1 2 10 376 347 ICV_69 $T=1004320 858160 0 0 $X=1003890 $Y=857770
X678 1 2 385 18 390 ICV_69 $T=1015520 850320 0 0 $X=1015090 $Y=849930
X679 1 2 417 84 421 ICV_69 $T=1067600 826800 1 0 $X=1067170 $Y=822245
X705 1 2 171 23 169 ICV_59 $T=765760 826800 0 0 $X=765330 $Y=826410
X706 1 2 205 196 201 ICV_59 $T=809440 826800 0 0 $X=809010 $Y=826410
X707 1 2 10 193 247 ICV_59 $T=861520 858160 0 0 $X=861090 $Y=857770
X708 1 2 270 18 271 ICV_59 $T=876080 858160 1 0 $X=875650 $Y=853605
X709 1 2 22 296 299 ICV_59 $T=911360 834640 0 0 $X=910930 $Y=834250
X710 1 2 275 58 300 ICV_59 $T=911920 818960 0 0 $X=911490 $Y=818570
X711 1 2 3 287 306 ICV_59 $T=916400 866000 1 0 $X=915970 $Y=861445
X712 1 2 333 328 331 ICV_59 $T=953360 834640 1 0 $X=952930 $Y=830085
X713 1 2 335 18 336 ICV_59 $T=954480 866000 1 0 $X=954050 $Y=861445
X714 1 2 3 341 362 ICV_59 $T=981360 873840 0 0 $X=980930 $Y=873450
X715 1 2 10 372 309 ICV_59 $T=997600 858160 0 0 $X=997170 $Y=857770
X716 1 2 384 18 381 ICV_59 $T=1009920 850320 0 0 $X=1009490 $Y=849930
X717 1 2 3 433 449 ICV_59 $T=1135920 818960 1 0 $X=1135490 $Y=814405
X718 1 2 24 26 182 ICV_68 $T=787040 818960 0 0 $X=786610 $Y=818570
X719 1 2 3 223 220 ICV_68 $T=832960 858160 1 0 $X=832530 $Y=853605
X720 1 2 55 56 280 ICV_68 $T=891760 826800 0 0 $X=891330 $Y=826410
X721 1 2 10 302 269 ICV_68 $T=911920 866000 0 0 $X=911490 $Y=865610
X722 1 2 299 307 305 ICV_68 $T=914720 834640 0 0 $X=914290 $Y=834250
X723 1 2 304 18 312 ICV_68 $T=922560 858160 0 0 $X=922130 $Y=857770
X724 1 2 3 418 414 ICV_68 $T=1059760 850320 0 0 $X=1059330 $Y=849930
X725 1 2 3 425 422 ICV_68 $T=1070400 834640 0 0 $X=1069970 $Y=834250
X726 1 2 167 170 79 163 ICV_60 $T=758480 850320 0 0 $X=758050 $Y=849930
X727 1 2 223 215 79 100 ICV_60 $T=820640 866000 1 0 $X=820210 $Y=861445
X728 1 2 281 276 79 248 ICV_60 $T=874400 881680 1 0 $X=873970 $Y=877125
X729 1 2 287 313 79 248 ICV_60 $T=904080 858160 1 0 $X=903650 $Y=853605
X730 1 2 324 319 79 248 ICV_60 $T=925920 866000 0 0 $X=925490 $Y=865610
X731 1 2 330 329 79 104 ICV_60 $T=943280 826800 1 0 $X=942850 $Y=822245
X732 1 2 349 343 79 104 ICV_60 $T=958400 889520 1 0 $X=957970 $Y=884965
X733 1 2 359 352 79 104 ICV_60 $T=966240 850320 1 0 $X=965810 $Y=845765
X734 1 2 366 355 79 104 ICV_60 $T=974080 866000 0 0 $X=973650 $Y=865610
X735 1 2 398 393 79 76 ICV_60 $T=1025600 850320 1 0 $X=1025170 $Y=845765
X736 1 2 418 412 79 82 ICV_60 $T=1045760 858160 1 0 $X=1045330 $Y=853605
X737 1 2 425 420 79 82 ICV_60 $T=1055280 842480 0 0 $X=1054850 $Y=842090
X738 1 2 444 446 79 109 ICV_60 $T=1123040 834640 1 0 $X=1122610 $Y=830085
X739 1 2 433 450 79 109 ICV_60 $T=1124720 826800 1 0 $X=1124290 $Y=822245
X750 1 2 10 114 125 ICV_70 $T=715360 834640 0 180 $X=712130 $Y=830085
X751 1 2 3 162 188 ICV_70 $T=793760 858160 0 180 $X=790530 $Y=853605
X752 1 2 198 200 204 ICV_70 $T=812800 842480 0 180 $X=809570 $Y=837925
X753 1 2 3 209 255 ICV_70 $T=873280 866000 1 180 $X=870050 $Y=865610
X754 1 2 353 351 352 ICV_70 $T=977440 842480 0 180 $X=974210 $Y=837925
X755 1 2 378 374 377 ICV_70 $T=1008800 842480 0 180 $X=1005570 $Y=837925
X756 1 2 3 371 380 ICV_70 $T=1012160 858160 1 180 $X=1008930 $Y=857770
X757 1 2 3 372 409 ICV_70 $T=1053600 850320 1 180 $X=1050370 $Y=849930
X758 1 2 83 18 411 ICV_70 $T=1058640 834640 1 180 $X=1055410 $Y=834250
X759 1 2 22 410 417 ICV_70 $T=1065360 826800 0 180 $X=1062130 $Y=822245
X764 1 2 10 140 142 ICV_73 $T=743360 858160 1 0 $X=742930 $Y=853605
X765 1 2 10 162 20 ICV_73 $T=757920 842480 0 0 $X=757490 $Y=842090
X766 1 2 168 172 170 ICV_73 $T=766320 850320 1 0 $X=765890 $Y=845765
X767 1 2 22 167 168 ICV_73 $T=770800 842480 0 0 $X=770370 $Y=842090
X768 1 2 194 18 202 ICV_73 $T=810000 850320 0 0 $X=809570 $Y=849930
X769 1 2 22 207 205 ICV_73 $T=812800 826800 0 0 $X=812370 $Y=826410
X770 1 2 24 35 234 ICV_73 $T=847520 834640 1 0 $X=847090 $Y=830085
X771 1 2 10 287 241 ICV_73 $T=895680 866000 0 0 $X=895250 $Y=865610
X772 1 2 22 385 383 ICV_73 $T=1010480 834640 0 0 $X=1010050 $Y=834250
X773 1 2 167 18 158 ICV_63 $T=766880 858160 1 180 $X=763650 $Y=857770
X774 1 2 3 206 233 ICV_63 $T=849200 873840 0 180 $X=845970 $Y=869285
X775 1 2 3 252 290 ICV_63 $T=904640 873840 0 180 $X=901410 $Y=869285
X776 1 2 363 365 367 ICV_63 $T=988640 842480 0 180 $X=985410 $Y=837925
X777 1 2 24 361 374 ICV_63 $T=1003200 826800 1 180 $X=999970 $Y=826410
X778 1 2 22 395 402 ICV_63 $T=1036240 834640 0 180 $X=1033010 $Y=830085
X779 1 2 10 366 405 ICV_63 $T=1040720 850320 1 180 $X=1037490 $Y=849930
X780 1 2 89 18 440 ICV_63 $T=1101200 818960 0 180 $X=1097970 $Y=814405
X803 1 2 122 134 79 163 ICV_67 $T=706960 834640 0 0 $X=706530 $Y=834250
X804 1 2 128 144 79 163 ICV_67 $T=714240 858160 0 0 $X=713810 $Y=857770
X805 1 2 162 203 79 100 ICV_67 $T=788160 866000 1 0 $X=787730 $Y=861445
X806 1 2 65 103 79 104 ICV_67 $T=919760 818960 0 0 $X=919330 $Y=818570
X807 1 2 344 357 79 76 ICV_67 $T=966240 834640 1 0 $X=965810 $Y=830085
X808 1 2 395 408 79 82 ICV_67 $T=1022240 834640 0 0 $X=1021810 $Y=834250
X809 1 2 410 421 79 82 ICV_67 $T=1051920 834640 1 0 $X=1051490 $Y=830085
X810 1 2 424 439 79 82 ICV_67 $T=1078240 850320 0 0 $X=1077810 $Y=849930
.ENDS
***************************************
.SUBCKT ICV_49
** N=35 EP=0 IP=38 FDC=0
.ENDS
***************************************
.SUBCKT ICV_43
** N=5 EP=0 IP=13 FDC=0
.ENDS
***************************************
.SUBCKT ICV_44
** N=7 EP=0 IP=10 FDC=0
.ENDS
***************************************
.SUBCKT ICV_38
** N=5 EP=0 IP=8 FDC=0
.ENDS
***************************************
.SUBCKT ICV_39
** N=7 EP=0 IP=10 FDC=0
.ENDS
***************************************
.SUBCKT ICV_50
** N=60 EP=0 IP=1106 FDC=0
.ENDS
***************************************
.SUBCKT ICV_3 VSS VDD
** N=46 EP=2 IP=1 FDC=1
D0 VSS VDD ndio_m AREA=9e-10 PJ=0.00012 $X=10780 $Y=193610 $D=30
.ENDS
***************************************
.SUBCKT ICV_33
** N=4 EP=0 IP=12 FDC=0
.ENDS
***************************************
.SUBCKT ICV_32
** N=4 EP=0 IP=24 FDC=0
.ENDS
***************************************
.SUBCKT ICV_31 1 2 3 4
** N=6 EP=4 IP=62 FDC=96
X0 1 4 2 3 pad_in $T=1696720 529920 0 90 $X=1462620 $Y=529020
.ENDS
***************************************
.SUBCKT ICV_30
** N=4 EP=0 IP=24 FDC=0
.ENDS
***************************************
.SUBCKT ICV_29
** N=5 EP=0 IP=60 FDC=0
.ENDS
***************************************
.SUBCKT ICV_28
** N=4 EP=0 IP=24 FDC=0
.ENDS
***************************************
.SUBCKT ICV_27
** N=4 EP=0 IP=68 FDC=0
.ENDS
***************************************
.SUBCKT ICV_25
** N=4 EP=0 IP=4 FDC=0
.ENDS
***************************************
.SUBCKT ICV_2 VDD DataOut pad VSS
** N=25 EP=4 IP=1 FDC=96
M0 VSS VDD 7 VSS N L=3.5e-07 W=9e-06 $X=5700 $Y=147100 $D=0
M1 8 7 VSS VSS N L=3.5e-07 W=9e-06 $X=8100 $Y=147100 $D=0
M2 VSS DataOut 10 VSS N L=3.5e-07 W=9e-06 $X=13200 $Y=147100 $D=0
M3 10 DataOut VSS VSS N L=3.5e-07 W=9e-06 $X=15600 $Y=147100 $D=0
M4 pad 10 VSS VSS N L=3.5e-07 W=2e-05 $X=15770 $Y=191300 $D=0
M5 VSS 10 pad VSS N L=3.5e-07 W=2e-05 $X=15770 $Y=196210 $D=0
M6 pad 10 VSS VSS N L=3.5e-07 W=2e-05 $X=15770 $Y=197780 $D=0
M7 VSS 10 pad VSS N L=3.5e-07 W=2e-05 $X=15770 $Y=202690 $D=0
M8 pad 10 VSS VSS N L=3.5e-07 W=2e-05 $X=15770 $Y=204260 $D=0
M9 VSS 10 pad VSS N L=3.5e-07 W=2e-05 $X=15770 $Y=209170 $D=0
M10 pad 10 VSS VSS N L=3.5e-07 W=2e-05 $X=15770 $Y=210740 $D=0
M11 VSS 10 pad VSS N L=3.5e-07 W=2e-05 $X=15770 $Y=215650 $D=0
M12 pad 10 VSS VSS N L=3.5e-07 W=2e-05 $X=15770 $Y=217220 $D=0
M13 VSS 10 pad VSS N L=3.5e-07 W=2e-05 $X=15770 $Y=222130 $D=0
M14 VSS DataOut 10 VSS N L=3.5e-07 W=9e-06 $X=18000 $Y=147100 $D=0
M15 10 DataOut VSS VSS N L=3.5e-07 W=9e-06 $X=20400 $Y=147100 $D=0
M16 VSS DataOut 10 VSS N L=3.5e-07 W=9e-06 $X=22800 $Y=147100 $D=0
M17 10 7 VSS VSS N L=3.5e-07 W=9e-06 $X=25200 $Y=147100 $D=0
M18 VSS 7 10 VSS N L=3.5e-07 W=9e-06 $X=27600 $Y=147100 $D=0
M19 10 7 VSS VSS N L=3.5e-07 W=9e-06 $X=30000 $Y=147100 $D=0
M20 VSS 7 10 VSS N L=3.5e-07 W=9e-06 $X=32400 $Y=147100 $D=0
M21 10 7 VSS VSS N L=3.5e-07 W=9e-06 $X=34800 $Y=147100 $D=0
M22 9 8 10 VSS N L=3.5e-07 W=9e-06 $X=37200 $Y=147100 $D=0
M23 10 8 9 VSS N L=3.5e-07 W=9e-06 $X=39600 $Y=147100 $D=0
M24 9 8 10 VSS N L=3.5e-07 W=9e-06 $X=42000 $Y=147100 $D=0
M25 10 8 9 VSS N L=3.5e-07 W=9e-06 $X=44400 $Y=147100 $D=0
M26 pad 10 VSS VSS N L=3.5e-07 W=2e-05 $X=54230 $Y=191300 $D=0
M27 VSS 10 pad VSS N L=3.5e-07 W=2e-05 $X=54230 $Y=196210 $D=0
M28 pad 10 VSS VSS N L=3.5e-07 W=2e-05 $X=54230 $Y=197780 $D=0
M29 VSS 10 pad VSS N L=3.5e-07 W=2e-05 $X=54230 $Y=202690 $D=0
M30 pad 10 VSS VSS N L=3.5e-07 W=2e-05 $X=54230 $Y=204260 $D=0
M31 VSS 10 pad VSS N L=3.5e-07 W=2e-05 $X=54230 $Y=209170 $D=0
M32 pad 10 VSS VSS N L=3.5e-07 W=2e-05 $X=54230 $Y=210740 $D=0
M33 VSS 10 pad VSS N L=3.5e-07 W=2e-05 $X=54230 $Y=215650 $D=0
M34 pad 10 VSS VSS N L=3.5e-07 W=2e-05 $X=54230 $Y=217220 $D=0
M35 VSS 10 pad VSS N L=3.5e-07 W=2e-05 $X=54230 $Y=222130 $D=0
M36 11 pad VSS VSS N L=3.5e-07 W=9e-06 $X=59400 $Y=146950 $D=0
M37 VSS pad 11 VSS N L=3.5e-07 W=9e-06 $X=61800 $Y=146950 $D=0
M38 11 pad VSS VSS N L=3.5e-07 W=9e-06 $X=64200 $Y=146950 $D=0
M39 VSS pad 11 VSS N L=3.5e-07 W=9e-06 $X=66600 $Y=146950 $D=0
M40 11 pad VSS VSS N L=3.5e-07 W=9e-06 $X=69000 $Y=146950 $D=0
M41 VSS pad 11 VSS N L=3.5e-07 W=9e-06 $X=71400 $Y=146950 $D=0
M42 12 11 VSS VSS N L=3.5e-07 W=9e-06 $X=73800 $Y=146950 $D=0
M43 VSS 11 12 VSS N L=3.5e-07 W=9e-06 $X=76200 $Y=146950 $D=0
M44 12 11 VSS VSS N L=3.5e-07 W=9e-06 $X=78600 $Y=146950 $D=0
M45 VSS 11 12 VSS N L=3.5e-07 W=9e-06 $X=81000 $Y=146950 $D=0
M46 12 11 VSS VSS N L=3.5e-07 W=9e-06 $X=83400 $Y=146950 $D=0
M47 VSS 11 12 VSS N L=3.5e-07 W=9e-06 $X=85800 $Y=146950 $D=0
M48 VDD VDD 7 VDD P L=3.5e-07 W=1.56e-05 $X=5700 $Y=165550 $D=16
M49 8 7 VDD VDD P L=3.5e-07 W=1.56e-05 $X=8100 $Y=165550 $D=16
M50 VDD DataOut 9 VDD P L=3.5e-07 W=1.56e-05 $X=13200 $Y=165550 $D=16
M51 9 DataOut VDD VDD P L=3.5e-07 W=1.56e-05 $X=15600 $Y=165550 $D=16
M52 pad 9 VDD VDD P L=3.5e-07 W=2e-05 $X=15795 $Y=97085 $D=16
M53 VDD 9 pad VDD P L=3.5e-07 W=2e-05 $X=15795 $Y=101995 $D=16
M54 pad 9 VDD VDD P L=3.5e-07 W=2e-05 $X=15795 $Y=103565 $D=16
M55 VDD 9 pad VDD P L=3.5e-07 W=2e-05 $X=15795 $Y=108475 $D=16
M56 pad 9 VDD VDD P L=3.5e-07 W=2e-05 $X=15795 $Y=110045 $D=16
M57 VDD 9 pad VDD P L=3.5e-07 W=2e-05 $X=15795 $Y=114955 $D=16
M58 pad 9 VDD VDD P L=3.5e-07 W=2e-05 $X=15795 $Y=116525 $D=16
M59 VDD 9 pad VDD P L=3.5e-07 W=2e-05 $X=15795 $Y=121435 $D=16
M60 pad 9 VDD VDD P L=3.5e-07 W=2e-05 $X=15795 $Y=123005 $D=16
M61 VDD 9 pad VDD P L=3.5e-07 W=2e-05 $X=15795 $Y=127915 $D=16
M62 VDD DataOut 9 VDD P L=3.5e-07 W=1.56e-05 $X=18000 $Y=165550 $D=16
M63 9 DataOut VDD VDD P L=3.5e-07 W=1.56e-05 $X=20400 $Y=165550 $D=16
M64 VDD DataOut 9 VDD P L=3.5e-07 W=1.56e-05 $X=22800 $Y=165550 $D=16
M65 9 8 VDD VDD P L=3.5e-07 W=1.56e-05 $X=25200 $Y=165550 $D=16
M66 VDD 8 9 VDD P L=3.5e-07 W=1.56e-05 $X=27600 $Y=165550 $D=16
M67 9 8 VDD VDD P L=3.5e-07 W=1.56e-05 $X=30000 $Y=165550 $D=16
M68 VDD 8 9 VDD P L=3.5e-07 W=1.56e-05 $X=32400 $Y=165550 $D=16
M69 9 8 VDD VDD P L=3.5e-07 W=1.56e-05 $X=34800 $Y=165550 $D=16
M70 10 7 9 VDD P L=3.5e-07 W=1.56e-05 $X=37200 $Y=165550 $D=16
M71 9 7 10 VDD P L=3.5e-07 W=1.56e-05 $X=39600 $Y=165550 $D=16
M72 10 7 9 VDD P L=3.5e-07 W=1.56e-05 $X=42000 $Y=165550 $D=16
M73 9 7 10 VDD P L=3.5e-07 W=1.56e-05 $X=44400 $Y=165550 $D=16
M74 pad 9 VDD VDD P L=3.5e-07 W=2e-05 $X=53330 $Y=97085 $D=16
M75 VDD 9 pad VDD P L=3.5e-07 W=2e-05 $X=53330 $Y=101995 $D=16
M76 pad 9 VDD VDD P L=3.5e-07 W=2e-05 $X=53330 $Y=103565 $D=16
M77 VDD 9 pad VDD P L=3.5e-07 W=2e-05 $X=53330 $Y=108475 $D=16
M78 pad 9 VDD VDD P L=3.5e-07 W=2e-05 $X=53330 $Y=110045 $D=16
M79 VDD 9 pad VDD P L=3.5e-07 W=2e-05 $X=53330 $Y=114955 $D=16
M80 pad 9 VDD VDD P L=3.5e-07 W=2e-05 $X=53330 $Y=116525 $D=16
M81 VDD 9 pad VDD P L=3.5e-07 W=2e-05 $X=53330 $Y=121435 $D=16
M82 pad 9 VDD VDD P L=3.5e-07 W=2e-05 $X=53330 $Y=123005 $D=16
M83 VDD 9 pad VDD P L=3.5e-07 W=2e-05 $X=53330 $Y=127915 $D=16
M84 11 pad VDD VDD P L=3.5e-07 W=1.56e-05 $X=59400 $Y=165550 $D=16
M85 VDD pad 11 VDD P L=3.5e-07 W=1.56e-05 $X=61800 $Y=165550 $D=16
M86 11 pad VDD VDD P L=3.5e-07 W=1.56e-05 $X=64200 $Y=165550 $D=16
M87 VDD pad 11 VDD P L=3.5e-07 W=1.56e-05 $X=66600 $Y=165550 $D=16
M88 11 pad VDD VDD P L=3.5e-07 W=1.56e-05 $X=69000 $Y=165550 $D=16
M89 VDD pad 11 VDD P L=3.5e-07 W=1.56e-05 $X=71400 $Y=165550 $D=16
M90 12 11 VDD VDD P L=3.5e-07 W=1.56e-05 $X=73800 $Y=165550 $D=16
M91 VDD 11 12 VDD P L=3.5e-07 W=1.56e-05 $X=76200 $Y=165550 $D=16
M92 12 11 VDD VDD P L=3.5e-07 W=1.56e-05 $X=78600 $Y=165550 $D=16
M93 VDD 11 12 VDD P L=3.5e-07 W=1.56e-05 $X=81000 $Y=165550 $D=16
M94 12 11 VDD VDD P L=3.5e-07 W=1.56e-05 $X=83400 $Y=165550 $D=16
M95 VDD 11 12 VDD P L=3.5e-07 W=1.56e-05 $X=85800 $Y=165550 $D=16
.ENDS
***************************************
.SUBCKT ICV_23
** N=4 EP=0 IP=4 FDC=0
.ENDS
***************************************
.SUBCKT top_pad 1
** N=498 EP=1 IP=1108 FDC=42683
X0 1 2 264 cs_n ICV_126 $T=0 0 0 0 $X=0 $Y=456600
X3 1 2 ICV_1 $T=0 1006640 0 270 $X=0 $Y=915740
X12 1 2 6 7 clk sclk ICV_121 $T=0 0 0 0 $X=232600 $Y=0
X13 1 2 8 rst ICV_35 $T=0 0 0 0 $X=232600 $Y=1223400
X14 1 2 9 13 14 11 287 279 15 16 17 32 24 22 18 47 286 23 82 281
+ 283 285 21 20 25 284 19 289 29 26 290 36 27 28 30 31 292 288 299 33
+ 34 291 282 35 63 294 37 295 296 51 38 298 39 300 40 10 41 42 301 43
+ 44 303 45 46 304 48 56 61 49 54 50 306 52 53 84 314 326 57 58 59
+ 318 60 308 307 320 62 309 64 65 66 67 55 68 69 311 70 71 72 323 73
+ 312 74 310 76 317 77 330 316 319 78 79 322 80 81 83 313 75 85 328 86
+ 87 92 88 89 315 90 91 324 325 93 327 94 95 97 98 99 101 100 103 104
+ 105 106 107 109 334 329 7 96 102 331 332 108 333 110
+ ICV_119 $T=0 0 0 0 $X=234100 $Y=234100
X15 1 2 111 112 130 121 113 342 114 115 116 117 118 119 124 120 336 335 122 338
+ 337 133 340 123 343 131 125 339 126 127 341 128 344 129 345 132 152 153 4 134
+ 347 271 135 144 136 137 346 348 138 349 140 350 141 142 352 353 355 143 265 354
+ 362 357 180 360 361 358 278 367 365 145 363 146 139 147 148 9 370 149 150 10
+ 11 51 12 14 13 368 366 151 364 279 280 16 22 18 19 281 17 36 76 283
+ 23 47 282 371 369 82 20 158 21 285 32 372 24 35 41 286 25 155 288 284
+ 26 27 291 287 28 374 375 293 29 80 156 377 289 31 292 290 30 34 33 305
+ 294 6 157 162 37 297 43 63 42 378 38 159 302 314 39 296 295 381 300 298
+ 299 379 387 84 380 382 301 46 44 383 303 45 190 52 160 161 385 304 163 48
+ 164 3 167 165 53 388 49 50 166 56 390 389 306 61 384 168 170 169 386 417
+ 391 173 392 171 172 57 58 54 59 396 395 319 60 397 62 307 174 394 176 177
+ 308 398 309 64 178 310 65 66 175 393 312 67 68 69 75 89 73 311 70 71
+ 83 313 72 399 315 216 215 400 316 79 402 77 74 318 317 78 183 321 320 81
+ 90 181 322 324 85 401 404 86 182 403 406 405 91 88 87 92 323 407 325 408
+ 410 359 93 210 94 411 425 184 95 326 96 97 98 413 414 270 416 412 99 100
+ 101 419 409 415 230 185 102 421 105 422 186 103 107 104 424 106 423 188 187 225
+ 189 426 420 267 331 191 212 108 109 192 427 332 193 428 194 333 429 195 110 196
+ 222 430 431 334 197 204 198 199 200 213 432 201 203 202 268 205 434 206 435 207
+ 208 209 211 433 5 214 264 329 351 356 154 376 179 330 418 266
+ ICV_112 $T=0 0 0 0 $X=234100 $Y=430200
X16 1 2 112 335 114 130 111 115 123 337 118 117 116 119 336 121 338 122 120 133
+ 128 131 125 339 124 126 343 341 340 127 342 129 344 436 345 430 222 132 113 447
+ 217 230 225 134 347 271 136 135 220 326 137 139 346 437 218 440 138 348 219 441
+ 140 438 350 359 442 349 144 141 142 444 443 351 265 352 354 221 353 223 224 355
+ 358 445 446 361 357 362 374 360 146 450 226 449 273 364 356 274 448 366 367 370
+ 150 227 369 368 4 151 228 375 377 371 453 145 153 373 381 372 154 155 452 451
+ 384 229 231 386 464 152 365 454 157 232 455 376 378 379 6 40 380 158 233 382
+ 159 458 3 234 456 238 383 161 468 235 388 239 160 236 241 237 249 385 457 387
+ 163 240 167 164 148 165 242 243 166 245 394 244 459 389 390 460 461 246 162 462
+ 168 463 247 169 170 248 391 171 398 250 172 392 175 251 470 173 396 395 55 253
+ 252 397 466 174 473 465 393 176 206 467 177 471 180 178 399 216 469 179 402 472
+ 254 215 255 181 400 403 182 328 401 183 404 407 406 256 405 269 410 408 411 327
+ 184 412 257 415 414 413 275 185 418 477 416 259 475 417 476 270 190 266 419 267
+ 258 260 420 186 479 421 423 422 481 188 425 5 482 189 478 426 191 483 272 192
+ 263 484 486 193 485 194 276 277 195 429 196 261 431 197 262 199 198 200 212 201
+ 432 204 434 202 203 205 208 207 435 209 433 210 211 213 214 329 439 143 147 363
+ 149 156 409 474 187 480 424 428 427
+ ICV_98 $T=0 0 0 0 $X=234100 $Y=618400
X17 1 2 436 217 218 437 438 439 440 430 219 441 220 442 443 221 223 222 224 444
+ 445 447 446 225 226 449 450 273 274 230 227 228 452 453 231 455 232 233 234 239
+ 456 235 237 236 238 243 240 457 241 458 462 249 244 242 459 463 460 245 461 246
+ 248 247 250 251 252 464 466 467 468 471 472 255 473 256 470 474 269 8 329 257
+ 275 480 259 476 477 260 478 479 481 482 483 485 263 484 261 272 276 277 448 451
+ 229 454 253 465 254 469 258 475 486
+ ICV_77 $T=0 0 0 0 $X=234100 $Y=814400
X19 1 2 ICV_3 $T=673310 1536560 0 180 $X=582410 $Y=1302460
X22 1 2 268 mosi ICV_31 $T=0 0 0 0 $X=1462600 $Y=430200
X28 2 262 miso 1 ICV_2 $T=1696720 916640 0 90 $X=1462620 $Y=915740
.ENDS
***************************************
.SUBCKT top_pad_merged_2
** N=3 EP=0 IP=91 FDC=42683
X30 3 top_pad $T=205375 99395 0 0 $X=205375 $Y=99395
*.CALIBRE WARNING SCONNECT SCONNECT conflict(s) detected by extraction in this cell. See extraction report for details.
.ENDS
***************************************
