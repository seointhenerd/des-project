$ Spice netlist generated by v2lvs
$ v2021.2_37.20    Tue Jun 1 14:42:15 PDT 2021
*.BUSDELIMITER [

.SUBCKT TopModule clk rst sclk cs_n mosi miso VDD VSS
XDIODE_17 ANTENNA $PINS A=n_6532 VSS=VSS VDD=VDD
XDIODE_16 ANTENNA $PINS A=n_119 VSS=VSS VDD=VDD
XDIODE_15 ANTENNA $PINS A=n_119 VSS=VSS VDD=VDD
XDIODE_14 ANTENNA $PINS A=clk VSS=VSS VDD=VDD
XDIODE_13 ANTENNA $PINS A=clk VSS=VSS VDD=VDD
XDIODE_12 ANTENNA $PINS A=n_6538 VSS=VSS VDD=VDD
XDIODE_11 ANTENNA $PINS A=n_6536 VSS=VSS VDD=VDD
XDIODE_10 ANTENNA $PINS A=n_6537 VSS=VSS VDD=VDD
XDIODE_9 ANTENNA $PINS A=n_8063 VSS=VSS VDD=VDD
XDIODE_8 ANTENNA $PINS A=n_6562 VSS=VSS VDD=VDD
XDIODE_7 ANTENNA $PINS A=n_6773 VSS=VSS VDD=VDD
XDIODE_6 ANTENNA $PINS A=n_6535 VSS=VSS VDD=VDD
XDIODE_5 ANTENNA $PINS A=n_6535 VSS=VSS VDD=VDD
XDIODE_4 ANTENNA $PINS A=n_6532 VSS=VSS VDD=VDD
XDIODE_3 ANTENNA $PINS A=n_6532 VSS=VSS VDD=VDD
XDIODE_2 ANTENNA $PINS A=n_6561 VSS=VSS VDD=VDD
XDIODE_1 ANTENNA $PINS A=n_6561 VSS=VSS VDD=VDD
XCTS_ccl_a_buf_00288 BUFX1 $PINS Z=CTS_51 A=CTS_52 VSS=VSS VDD=VDD
XCTS_ccl_a_buf_00256 BUFX1 $PINS Z=CTS_50 A=CTS_52 VSS=VSS VDD=VDD
XCTS_ccl_a_buf_00251 BUFX1 $PINS Z=CTS_54 A=CTS_52 VSS=VSS VDD=VDD
XCTS_ccl_a_buf_00250 BUFX1 $PINS Z=CTS_53 A=CTS_52 VSS=VSS VDD=VDD
XCTS_ccl_a_buf_00297 BUFX1 $PINS Z=CTS_52 A=CTS_55 VSS=VSS VDD=VDD
XCTS_ccl_a_buf_00299 BUFX1 $PINS Z=CTS_55 A=CTS_56 VSS=VSS VDD=VDD
XCTS_ccl_a_buf_00287 BUFX1 $PINS Z=CTS_46 A=CTS_47 VSS=VSS VDD=VDD
XCTS_ccl_a_buf_00268 BUFX1 $PINS Z=CTS_45 A=CTS_47 VSS=VSS VDD=VDD
XCTS_ccl_a_buf_00263 BUFX1 $PINS Z=CTS_44 A=CTS_47 VSS=VSS VDD=VDD
XCTS_ccl_a_buf_00255 BUFX1 $PINS Z=CTS_43 A=CTS_47 VSS=VSS VDD=VDD
XCTS_ccl_a_buf_00249 BUFX1 $PINS Z=CTS_49 A=CTS_47 VSS=VSS VDD=VDD
XCTS_ccl_a_buf_00247 BUFX1 $PINS Z=CTS_48 A=CTS_47 VSS=VSS VDD=VDD
XCTS_ccl_a_buf_00296 BUFX1 $PINS Z=CTS_47 A=CTS_56 VSS=VSS VDD=VDD
XCTS_ccl_a_buf_00285 BUFX1 $PINS Z=CTS_39 A=CTS_40 VSS=VSS VDD=VDD
XCTS_ccl_a_buf_00284 BUFX1 $PINS Z=CTS_38 A=CTS_40 VSS=VSS VDD=VDD
XCTS_ccl_a_buf_00266 BUFX1 $PINS Z=CTS_37 A=CTS_40 VSS=VSS VDD=VDD
XCTS_ccl_a_buf_00265 BUFX1 $PINS Z=CTS_42 A=CTS_40 VSS=VSS VDD=VDD
XCTS_ccl_a_buf_00264 BUFX1 $PINS Z=CTS_41 A=CTS_40 VSS=VSS VDD=VDD
XCTS_ccl_a_buf_00294 BUFX1 $PINS Z=CTS_40 A=CTS_56 VSS=VSS VDD=VDD
XCTS_ccl_a_buf_00283 BUFX1 $PINS Z=CTS_33 A=CTS_34 VSS=VSS VDD=VDD
XCTS_ccl_a_buf_00259 BUFX1 $PINS Z=CTS_32 A=CTS_34 VSS=VSS VDD=VDD
XCTS_ccl_a_buf_00258 BUFX1 $PINS Z=CTS_31 A=CTS_34 VSS=VSS VDD=VDD
XCTS_ccl_a_buf_00254 BUFX1 $PINS Z=CTS_30 A=CTS_34 VSS=VSS VDD=VDD
XCTS_ccl_a_buf_00253 BUFX1 $PINS Z=CTS_36 A=CTS_34 VSS=VSS VDD=VDD
XCTS_ccl_a_buf_00252 BUFX1 $PINS Z=CTS_35 A=CTS_34 VSS=VSS VDD=VDD
XCTS_ccl_a_buf_00293 BUFX1 $PINS Z=CTS_34 A=CTS_56 VSS=VSS VDD=VDD
XCTS_ccl_a_buf_00274 BUFX1 $PINS Z=CTS_26 A=CTS_27 VSS=VSS VDD=VDD
XCTS_ccl_a_buf_00267 BUFX1 $PINS Z=CTS_25 A=CTS_27 VSS=VSS VDD=VDD
XCTS_ccl_a_buf_00261 BUFX1 $PINS Z=CTS_24 A=CTS_27 VSS=VSS VDD=VDD
XCTS_ccl_a_buf_00260 BUFX1 $PINS Z=CTS_29 A=CTS_27 VSS=VSS VDD=VDD
XCTS_ccl_a_buf_00257 BUFX1 $PINS Z=CTS_28 A=CTS_27 VSS=VSS VDD=VDD
XCTS_ccl_a_buf_00289 BUFX1 $PINS Z=CTS_27 A=CTS_56 VSS=VSS VDD=VDD
XCTS_ccd_buf_00300 BUFX1 $PINS Z=CTS_56 A=clk VSS=VSS VDD=VDD
XCTS_ccl_a_buf_00286 BUFX1 $PINS Z=CTS_22 A=CTS_20 VSS=VSS VDD=VDD
XCTS_ccl_a_buf_00282 BUFX1 $PINS Z=CTS_21 A=CTS_20 VSS=VSS VDD=VDD
XCTS_ccl_a_buf_00295 BUFX1 $PINS Z=CTS_20 A=CTS_23 VSS=VSS VDD=VDD
XCTS_ccl_a_buf_00281 BUFX1 $PINS Z=CTS_16 A=CTS_17 VSS=VSS VDD=VDD
XCTS_ccl_a_buf_00278 BUFX1 $PINS Z=CTS_15 A=CTS_17 VSS=VSS VDD=VDD
XCTS_ccl_a_buf_00262 BUFX1 $PINS Z=CTS_19 A=CTS_17 VSS=VSS VDD=VDD
XCTS_ccl_a_buf_00248 BUFX1 $PINS Z=CTS_18 A=CTS_17 VSS=VSS VDD=VDD
XCTS_ccl_a_buf_00292 BUFX1 $PINS Z=CTS_17 A=CTS_23 VSS=VSS VDD=VDD
XCTS_ccl_a_buf_00280 BUFX1 $PINS Z=CTS_11 A=CTS_12 VSS=VSS VDD=VDD
XCTS_ccl_a_buf_00277 BUFX1 $PINS Z=CTS_10 A=CTS_12 VSS=VSS VDD=VDD
XCTS_ccl_a_buf_00276 BUFX1 $PINS Z=CTS_9 A=CTS_12 VSS=VSS VDD=VDD
XCTS_ccl_a_buf_00273 BUFX1 $PINS Z=CTS_8 A=CTS_12 VSS=VSS VDD=VDD
XCTS_ccl_a_buf_00272 BUFX1 $PINS Z=CTS_14 A=CTS_12 VSS=VSS VDD=VDD
XCTS_ccl_a_buf_00271 BUFX1 $PINS Z=CTS_13 A=CTS_12 VSS=VSS VDD=VDD
XCTS_ccl_a_buf_00291 BUFX1 $PINS Z=CTS_12 A=CTS_23 VSS=VSS VDD=VDD
XCTS_ccl_a_buf_00279 BUFX1 $PINS Z=CTS_4 A=CTS_5 VSS=VSS VDD=VDD
XCTS_ccl_a_buf_00275 BUFX1 $PINS Z=CTS_3 A=CTS_5 VSS=VSS VDD=VDD
XCTS_ccl_a_buf_00270 BUFX1 $PINS Z=CTS_2 A=CTS_5 VSS=VSS VDD=VDD
XCTS_ccl_a_buf_00269 BUFX1 $PINS Z=CTS_1 A=CTS_5 VSS=VSS VDD=VDD
XCTS_ccl_a_buf_00246 BUFX1 $PINS Z=CTS_7 A=CTS_5 VSS=VSS VDD=VDD
XCTS_ccl_a_buf_00245 BUFX1 $PINS Z=CTS_6 A=CTS_5 VSS=VSS VDD=VDD
XCTS_ccl_a_buf_00290 BUFX1 $PINS Z=CTS_5 A=CTS_23 VSS=VSS VDD=VDD
XCTS_ccl_a_buf_00298 BUFX1 $PINS Z=CTS_23 A=clk VSS=VSS VDD=VDD
XFE_DBTC2_csm_inst_round_counter_0 INVX2 $PINS
+ Z=FE_DBTN2_csm_inst_round_counter_0 A=csm_inst_round_counter[0] VSS=VSS VDD=VDD
XFE_DBTC1_csm_inst_mode INVX2 $PINS Z=FE_DBTN1_csm_inst_mode A=csm_inst_mode
+ VSS=VSS VDD=VDD
XFE_DBTC0_n_6155 INVX2 $PINS Z=FE_DBTN0_n_6155 A=n_6155 VSS=VSS VDD=VDD
Xactive_reg DFFQSRX1 $PINS Q=active CLK=CTS_7 D=n_4729 RESETB=n_152 SETB=VDD
+ VSS=VSS VDD=VDD
Xcrypt_reg DFFQSRX1 $PINS Q=crypt CLK=CTS_6 D=n_0 RESETB=n_152 SETB=VDD VSS=VSS
+ VDD=VDD
Xcs_meta_reg DFFQSRX1 $PINS Q=cs_meta CLK=CTS_10 D=cs_n RESETB=VDD SETB=n_152
+ VSS=VSS VDD=VDD
Xcs_prev_reg DFFQSRX1 $PINS Q=spi_inst_cs_prev CLK=CTS_15 D=spi_inst_cs_sync2
+ RESETB=VDD SETB=n_152 VSS=VSS VDD=VDD
Xcs_rise_delayed_reg DFFQSRX1 $PINS Q=cs_rise_delayed CLK=CTS_15 D=n_5405
+ RESETB=n_152 SETB=VDD VSS=VSS VDD=VDD
Xcs_sync_reg DFFQSRX1 $PINS Q=spi_inst_cs_sync2 CLK=CTS_10 D=cs_meta RESETB=VDD
+ SETB=n_152 VSS=VSS VDD=VDD
Xcsm_inst_done_decrypt_reg DFFQSRX1 $PINS Q=done_decrypt CLK=CTS_4 D=n_5318
+ RESETB=n_152 SETB=VDD VSS=VSS VDD=VDD
Xcsm_inst_done_encrypt_reg DFFQSRX1 $PINS Q=done_encrypt CLK=CTS_4 D=n_5275
+ RESETB=n_152 SETB=VDD VSS=VSS VDD=VDD
Xcsm_inst_left_reg_reg[0] DFFQSRX1 $PINS Q=csm_inst_left_reg[0] CLK=CTS_51
+ D=n_5455 RESETB=n_152 SETB=VDD VSS=VSS VDD=VDD
Xcsm_inst_left_reg_reg[1] DFFQSRX1 $PINS Q=csm_inst_left_reg[1] CLK=CTS_51
+ D=n_5470 RESETB=n_152 SETB=VDD VSS=VSS VDD=VDD
Xcsm_inst_left_reg_reg[2] DFFQSRX1 $PINS Q=csm_inst_left_reg[2] CLK=CTS_44
+ D=n_5484 RESETB=n_152 SETB=VDD VSS=VSS VDD=VDD
Xcsm_inst_left_reg_reg[3] DFFQSRX1 $PINS Q=csm_inst_left_reg[3] CLK=CTS_29
+ D=n_5465 RESETB=n_152 SETB=VDD VSS=VSS VDD=VDD
Xcsm_inst_left_reg_reg[4] DFFQSRX1 $PINS Q=csm_inst_left_reg[4] CLK=CTS_33
+ D=n_5461 RESETB=n_152 SETB=VDD VSS=VSS VDD=VDD
Xcsm_inst_left_reg_reg[5] DFFQSRX1 $PINS Q=csm_inst_left_reg[5] CLK=CTS_51
+ D=n_5450 RESETB=n_152 SETB=VDD VSS=VSS VDD=VDD
Xcsm_inst_left_reg_reg[6] DFFQSRX1 $PINS Q=csm_inst_left_reg[6] CLK=CTS_38
+ D=n_5442 RESETB=n_152 SETB=VDD VSS=VSS VDD=VDD
Xcsm_inst_left_reg_reg[7] DFFQSRX1 $PINS Q=csm_inst_left_reg[7] CLK=CTS_18
+ D=n_5426 RESETB=n_152 SETB=VDD VSS=VSS VDD=VDD
Xcsm_inst_left_reg_reg[8] DFFQSRX1 $PINS Q=csm_inst_left_reg[8] CLK=CTS_18
+ D=n_5427 RESETB=n_152 SETB=VDD VSS=VSS VDD=VDD
Xcsm_inst_left_reg_reg[9] DFFQSRX1 $PINS Q=csm_inst_left_reg[9] CLK=CTS_51
+ D=n_5457 RESETB=n_152 SETB=VDD VSS=VSS VDD=VDD
Xcsm_inst_left_reg_reg[10] DFFQSRX1 $PINS Q=csm_inst_left_reg[10] CLK=CTS_49
+ D=n_5472 RESETB=n_152 SETB=VDD VSS=VSS VDD=VDD
Xcsm_inst_left_reg_reg[11] DFFQSRX1 $PINS Q=csm_inst_left_reg[11] CLK=CTS_29
+ D=n_5446 RESETB=n_152 SETB=VDD VSS=VSS VDD=VDD
Xcsm_inst_left_reg_reg[12] DFFQSRX1 $PINS Q=csm_inst_left_reg[12] CLK=CTS_38
+ D=n_5481 RESETB=n_152 SETB=VDD VSS=VSS VDD=VDD
Xcsm_inst_left_reg_reg[13] DFFQSRX1 $PINS Q=csm_inst_left_reg[13] CLK=CTS_46
+ D=n_5480 RESETB=n_152 SETB=VDD VSS=VSS VDD=VDD
Xcsm_inst_left_reg_reg[14] DFFQSRX1 $PINS Q=csm_inst_left_reg[14] CLK=CTS_38
+ D=n_5460 RESETB=n_152 SETB=VDD VSS=VSS VDD=VDD
Xcsm_inst_left_reg_reg[15] DFFQSRX1 $PINS Q=csm_inst_left_reg[15] CLK=CTS_51
+ D=n_5444 RESETB=n_152 SETB=VDD VSS=VSS VDD=VDD
Xcsm_inst_left_reg_reg[16] DFFQSRX1 $PINS Q=csm_inst_left_reg[16] CLK=CTS_45
+ D=n_5448 RESETB=n_152 SETB=VDD VSS=VSS VDD=VDD
Xcsm_inst_left_reg_reg[17] DFFQSRX1 $PINS Q=csm_inst_left_reg[17] CLK=CTS_30
+ D=n_5445 RESETB=n_152 SETB=VDD VSS=VSS VDD=VDD
Xcsm_inst_left_reg_reg[18] DFFQSRX1 $PINS Q=csm_inst_left_reg[18] CLK=CTS_18
+ D=n_5441 RESETB=n_152 SETB=VDD VSS=VSS VDD=VDD
Xcsm_inst_left_reg_reg[19] DFFQSRX1 $PINS Q=csm_inst_left_reg[19] CLK=CTS_39
+ D=n_5434 RESETB=n_152 SETB=VDD VSS=VSS VDD=VDD
Xcsm_inst_left_reg_reg[20] DFFQSRX1 $PINS Q=csm_inst_left_reg[20] CLK=CTS_38
+ D=n_5428 RESETB=n_152 SETB=VDD VSS=VSS VDD=VDD
Xcsm_inst_left_reg_reg[21] DFFQSRX1 $PINS Q=csm_inst_left_reg[21] CLK=CTS_46
+ D=n_5421 RESETB=n_152 SETB=VDD VSS=VSS VDD=VDD
Xcsm_inst_left_reg_reg[22] DFFQSRX1 $PINS Q=csm_inst_left_reg[22] CLK=CTS_39
+ D=n_5479 RESETB=n_152 SETB=VDD VSS=VSS VDD=VDD
Xcsm_inst_left_reg_reg[23] DFFQSRX1 $PINS Q=csm_inst_left_reg[23] CLK=CTS_29
+ D=n_5483 RESETB=n_152 SETB=VDD VSS=VSS VDD=VDD
Xcsm_inst_left_reg_reg[24] DFFQSRX1 $PINS Q=csm_inst_left_reg[24] CLK=CTS_18
+ D=n_5478 RESETB=n_152 SETB=VDD VSS=VSS VDD=VDD
Xcsm_inst_left_reg_reg[25] DFFQSRX1 $PINS Q=csm_inst_left_reg[25] CLK=CTS_33
+ D=n_5474 RESETB=n_152 SETB=VDD VSS=VSS VDD=VDD
Xcsm_inst_left_reg_reg[26] DFFQSRX1 $PINS Q=csm_inst_left_reg[26] CLK=CTS_46
+ D=n_5471 RESETB=n_152 SETB=VDD VSS=VSS VDD=VDD
Xcsm_inst_left_reg_reg[27] DFFQSRX1 $PINS Q=csm_inst_left_reg[27] CLK=CTS_30
+ D=n_5440 RESETB=n_152 SETB=VDD VSS=VSS VDD=VDD
Xcsm_inst_left_reg_reg[28] DFFQSRX1 $PINS Q=csm_inst_left_reg[28] CLK=CTS_39
+ D=n_5468 RESETB=n_152 SETB=VDD VSS=VSS VDD=VDD
Xcsm_inst_left_reg_reg[29] DFFQSRX1 $PINS Q=csm_inst_left_reg[29] CLK=CTS_46
+ D=n_5424 RESETB=n_152 SETB=VDD VSS=VSS VDD=VDD
Xcsm_inst_left_reg_reg[30] DFFQSRX1 $PINS Q=csm_inst_left_reg[30] CLK=CTS_29
+ D=n_5447 RESETB=n_152 SETB=VDD VSS=VSS VDD=VDD
Xcsm_inst_left_reg_reg[31] DFFQSRX1 $PINS Q=csm_inst_left_reg[31] CLK=CTS_38
+ D=n_5464 RESETB=n_152 SETB=VDD VSS=VSS VDD=VDD
Xcsm_inst_mode_reg DFFQSRX1 $PINS Q=csm_inst_mode CLK=CTS_4 D=n_5900
+ RESETB=n_152 SETB=VDD VSS=VSS VDD=VDD
Xcsm_inst_output_text_reg[0] DFFQSRX1 $PINS Q=des_output[0] CLK=CTS_18 D=n_5171
+ RESETB=n_152 SETB=VDD VSS=VSS VDD=VDD
Xcsm_inst_output_text_reg[1] DFFQSRX1 $PINS Q=des_output[1] CLK=CTS_48 D=n_5142
+ RESETB=n_152 SETB=VDD VSS=VSS VDD=VDD
Xcsm_inst_output_text_reg[2] DFFQSRX1 $PINS Q=des_output[2] CLK=CTS_53 D=n_5148
+ RESETB=n_152 SETB=VDD VSS=VSS VDD=VDD
Xcsm_inst_output_text_reg[3] DFFQSRX1 $PINS Q=des_output[3] CLK=CTS_51 D=n_5160
+ RESETB=n_152 SETB=VDD VSS=VSS VDD=VDD
Xcsm_inst_output_text_reg[4] DFFQSRX1 $PINS Q=des_output[4] CLK=CTS_33 D=n_5154
+ RESETB=n_152 SETB=VDD VSS=VSS VDD=VDD
Xcsm_inst_output_text_reg[5] DFFQSRX1 $PINS Q=des_output[5] CLK=CTS_30 D=n_5169
+ RESETB=n_152 SETB=VDD VSS=VSS VDD=VDD
Xcsm_inst_output_text_reg[6] DFFQSRX1 $PINS Q=des_output[6] CLK=CTS_29 D=n_5158
+ RESETB=n_152 SETB=VDD VSS=VSS VDD=VDD
Xcsm_inst_output_text_reg[7] DFFQSRX1 $PINS Q=des_output[7] CLK=CTS_24 D=n_5168
+ RESETB=n_152 SETB=VDD VSS=VSS VDD=VDD
Xcsm_inst_output_text_reg[8] DFFQSRX1 $PINS Q=des_output[8] CLK=CTS_24 D=n_5134
+ RESETB=n_152 SETB=VDD VSS=VSS VDD=VDD
Xcsm_inst_output_text_reg[9] DFFQSRX1 $PINS Q=des_output[9] CLK=CTS_24 D=n_5163
+ RESETB=n_152 SETB=VDD VSS=VSS VDD=VDD
Xcsm_inst_output_text_reg[10] DFFQSRX1 $PINS Q=des_output[10] CLK=CTS_38
+ D=n_5197 RESETB=n_152 SETB=VDD VSS=VSS VDD=VDD
Xcsm_inst_output_text_reg[11] DFFQSRX1 $PINS Q=des_output[11] CLK=CTS_38
+ D=n_5161 RESETB=n_152 SETB=VDD VSS=VSS VDD=VDD
Xcsm_inst_output_text_reg[12] DFFQSRX1 $PINS Q=des_output[12] CLK=CTS_38
+ D=n_5159 RESETB=n_152 SETB=VDD VSS=VSS VDD=VDD
Xcsm_inst_output_text_reg[13] DFFQSRX1 $PINS Q=des_output[13] CLK=CTS_38
+ D=n_5157 RESETB=n_152 SETB=VDD VSS=VSS VDD=VDD
Xcsm_inst_output_text_reg[14] DFFQSRX1 $PINS Q=des_output[14] CLK=CTS_31
+ D=n_5153 RESETB=n_152 SETB=VDD VSS=VSS VDD=VDD
Xcsm_inst_output_text_reg[15] DFFQSRX1 $PINS Q=des_output[15] CLK=CTS_31
+ D=n_5152 RESETB=n_152 SETB=VDD VSS=VSS VDD=VDD
Xcsm_inst_output_text_reg[16] DFFQSRX1 $PINS Q=des_output[16] CLK=CTS_51
+ D=n_5151 RESETB=n_152 SETB=VDD VSS=VSS VDD=VDD
Xcsm_inst_output_text_reg[17] DFFQSRX1 $PINS Q=des_output[17] CLK=CTS_51
+ D=n_5150 RESETB=n_152 SETB=VDD VSS=VSS VDD=VDD
Xcsm_inst_output_text_reg[18] DFFQSRX1 $PINS Q=des_output[18] CLK=CTS_46
+ D=n_5149 RESETB=n_152 SETB=VDD VSS=VSS VDD=VDD
Xcsm_inst_output_text_reg[19] DFFQSRX1 $PINS Q=des_output[19] CLK=CTS_49
+ D=n_5187 RESETB=n_152 SETB=VDD VSS=VSS VDD=VDD
Xcsm_inst_output_text_reg[20] DFFQSRX1 $PINS Q=des_output[20] CLK=CTS_46
+ D=n_5147 RESETB=n_152 SETB=VDD VSS=VSS VDD=VDD
Xcsm_inst_output_text_reg[21] DFFQSRX1 $PINS Q=des_output[21] CLK=CTS_49
+ D=n_5146 RESETB=n_152 SETB=VDD VSS=VSS VDD=VDD
Xcsm_inst_output_text_reg[22] DFFQSRX1 $PINS Q=des_output[22] CLK=CTS_49
+ D=n_5144 RESETB=n_152 SETB=VDD VSS=VSS VDD=VDD
Xcsm_inst_output_text_reg[23] DFFQSRX1 $PINS Q=des_output[23] CLK=CTS_49
+ D=n_5190 RESETB=n_152 SETB=VDD VSS=VSS VDD=VDD
Xcsm_inst_output_text_reg[24] DFFQSRX1 $PINS Q=des_output[24] CLK=CTS_35
+ D=n_5143 RESETB=n_152 SETB=VDD VSS=VSS VDD=VDD
Xcsm_inst_output_text_reg[25] DFFQSRX1 $PINS Q=des_output[25] CLK=CTS_36
+ D=n_5141 RESETB=n_152 SETB=VDD VSS=VSS VDD=VDD
Xcsm_inst_output_text_reg[26] DFFQSRX1 $PINS Q=des_output[26] CLK=CTS_30
+ D=n_5138 RESETB=n_152 SETB=VDD VSS=VSS VDD=VDD
Xcsm_inst_output_text_reg[27] DFFQSRX1 $PINS Q=des_output[27] CLK=CTS_38
+ D=n_5172 RESETB=n_152 SETB=VDD VSS=VSS VDD=VDD
Xcsm_inst_output_text_reg[28] DFFQSRX1 $PINS Q=des_output[28] CLK=CTS_29
+ D=n_5136 RESETB=n_152 SETB=VDD VSS=VSS VDD=VDD
Xcsm_inst_output_text_reg[29] DFFQSRX1 $PINS Q=des_output[29] CLK=CTS_31
+ D=n_5135 RESETB=n_152 SETB=VDD VSS=VSS VDD=VDD
Xcsm_inst_output_text_reg[30] DFFQSRX1 $PINS Q=des_output[30] CLK=CTS_29
+ D=n_5184 RESETB=n_152 SETB=VDD VSS=VSS VDD=VDD
Xcsm_inst_output_text_reg[31] DFFQSRX1 $PINS Q=des_output[31] CLK=CTS_31
+ D=n_5132 RESETB=n_152 SETB=VDD VSS=VSS VDD=VDD
Xcsm_inst_output_text_reg[32] DFFQSRX1 $PINS Q=des_output[32] CLK=CTS_30
+ D=n_5131 RESETB=n_152 SETB=VDD VSS=VSS VDD=VDD
Xcsm_inst_output_text_reg[33] DFFQSRX1 $PINS Q=des_output[33] CLK=CTS_36
+ D=n_5194 RESETB=n_152 SETB=VDD VSS=VSS VDD=VDD
Xcsm_inst_output_text_reg[34] DFFQSRX1 $PINS Q=des_output[34] CLK=CTS_31
+ D=n_5193 RESETB=n_152 SETB=VDD VSS=VSS VDD=VDD
Xcsm_inst_output_text_reg[35] DFFQSRX1 $PINS Q=des_output[35] CLK=CTS_31
+ D=n_5174 RESETB=n_152 SETB=VDD VSS=VSS VDD=VDD
Xcsm_inst_output_text_reg[36] DFFQSRX1 $PINS Q=des_output[36] CLK=CTS_29
+ D=n_5164 RESETB=n_152 SETB=VDD VSS=VSS VDD=VDD
Xcsm_inst_output_text_reg[37] DFFQSRX1 $PINS Q=des_output[37] CLK=CTS_38
+ D=n_5137 RESETB=n_152 SETB=VDD VSS=VSS VDD=VDD
Xcsm_inst_output_text_reg[38] DFFQSRX1 $PINS Q=des_output[38] CLK=CTS_30
+ D=n_5191 RESETB=n_152 SETB=VDD VSS=VSS VDD=VDD
Xcsm_inst_output_text_reg[39] DFFQSRX1 $PINS Q=des_output[39] CLK=CTS_33
+ D=n_5175 RESETB=n_152 SETB=VDD VSS=VSS VDD=VDD
Xcsm_inst_output_text_reg[40] DFFQSRX1 $PINS Q=des_output[40] CLK=CTS_53
+ D=n_5189 RESETB=n_152 SETB=VDD VSS=VSS VDD=VDD
Xcsm_inst_output_text_reg[41] DFFQSRX1 $PINS Q=des_output[41] CLK=CTS_49
+ D=n_5188 RESETB=n_152 SETB=VDD VSS=VSS VDD=VDD
Xcsm_inst_output_text_reg[42] DFFQSRX1 $PINS Q=des_output[42] CLK=CTS_49
+ D=n_5155 RESETB=n_152 SETB=VDD VSS=VSS VDD=VDD
Xcsm_inst_output_text_reg[43] DFFQSRX1 $PINS Q=des_output[43] CLK=CTS_49
+ D=n_5167 RESETB=n_152 SETB=VDD VSS=VSS VDD=VDD
Xcsm_inst_output_text_reg[44] DFFQSRX1 $PINS Q=des_output[44] CLK=CTS_48
+ D=n_5186 RESETB=n_152 SETB=VDD VSS=VSS VDD=VDD
Xcsm_inst_output_text_reg[45] DFFQSRX1 $PINS Q=des_output[45] CLK=CTS_48
+ D=n_5176 RESETB=n_152 SETB=VDD VSS=VSS VDD=VDD
Xcsm_inst_output_text_reg[46] DFFQSRX1 $PINS Q=des_output[46] CLK=CTS_46
+ D=n_5170 RESETB=n_152 SETB=VDD VSS=VSS VDD=VDD
Xcsm_inst_output_text_reg[47] DFFQSRX1 $PINS Q=des_output[47] CLK=CTS_46
+ D=n_5173 RESETB=n_152 SETB=VDD VSS=VSS VDD=VDD
Xcsm_inst_output_text_reg[48] DFFQSRX1 $PINS Q=des_output[48] CLK=CTS_53
+ D=n_5182 RESETB=n_152 SETB=VDD VSS=VSS VDD=VDD
Xcsm_inst_output_text_reg[49] DFFQSRX1 $PINS Q=des_output[49] CLK=CTS_51
+ D=n_5165 RESETB=n_152 SETB=VDD VSS=VSS VDD=VDD
Xcsm_inst_output_text_reg[50] DFFQSRX1 $PINS Q=des_output[50] CLK=CTS_54
+ D=n_5133 RESETB=n_152 SETB=VDD VSS=VSS VDD=VDD
Xcsm_inst_output_text_reg[51] DFFQSRX1 $PINS Q=des_output[51] CLK=CTS_54
+ D=n_5181 RESETB=n_152 SETB=VDD VSS=VSS VDD=VDD
Xcsm_inst_output_text_reg[52] DFFQSRX1 $PINS Q=des_output[52] CLK=CTS_30
+ D=n_5180 RESETB=n_152 SETB=VDD VSS=VSS VDD=VDD
Xcsm_inst_output_text_reg[53] DFFQSRX1 $PINS Q=des_output[53] CLK=CTS_30
+ D=n_5139 RESETB=n_152 SETB=VDD VSS=VSS VDD=VDD
Xcsm_inst_output_text_reg[54] DFFQSRX1 $PINS Q=des_output[54] CLK=CTS_36
+ D=n_5179 RESETB=n_152 SETB=VDD VSS=VSS VDD=VDD
Xcsm_inst_output_text_reg[55] DFFQSRX1 $PINS Q=des_output[55] CLK=CTS_36
+ D=n_5178 RESETB=n_152 SETB=VDD VSS=VSS VDD=VDD
Xcsm_inst_output_text_reg[56] DFFQSRX1 $PINS Q=des_output[56] CLK=CTS_54
+ D=n_5166 RESETB=n_152 SETB=VDD VSS=VSS VDD=VDD
Xcsm_inst_output_text_reg[57] DFFQSRX1 $PINS Q=des_output[57] CLK=CTS_51
+ D=n_5177 RESETB=n_152 SETB=VDD VSS=VSS VDD=VDD
Xcsm_inst_output_text_reg[58] DFFQSRX1 $PINS Q=des_output[58] CLK=CTS_46
+ D=n_5145 RESETB=n_152 SETB=VDD VSS=VSS VDD=VDD
Xcsm_inst_output_text_reg[59] DFFQSRX1 $PINS Q=des_output[59] CLK=CTS_18
+ D=n_5192 RESETB=n_152 SETB=VDD VSS=VSS VDD=VDD
Xcsm_inst_output_text_reg[60] DFFQSRX1 $PINS Q=des_output[60] CLK=CTS_46
+ D=n_5183 RESETB=n_152 SETB=VDD VSS=VSS VDD=VDD
Xcsm_inst_output_text_reg[61] DFFQSRX1 $PINS Q=des_output[61] CLK=CTS_18
+ D=n_5140 RESETB=n_152 SETB=VDD VSS=VSS VDD=VDD
Xcsm_inst_output_text_reg[62] DFFQSRX1 $PINS Q=des_output[62] CLK=CTS_18
+ D=n_5185 RESETB=n_152 SETB=VDD VSS=VSS VDD=VDD
Xcsm_inst_output_text_reg[63] DFFQSRX1 $PINS Q=des_output[63] CLK=CTS_48
+ D=n_5156 RESETB=n_152 SETB=VDD VSS=VSS VDD=VDD
Xcsm_inst_right_reg_reg[0] DFFQSRX1 $PINS Q=csm_inst_right_reg[0] CLK=CTS_41
+ D=n_7995 RESETB=n_152 SETB=VDD VSS=VSS VDD=VDD
Xcsm_inst_right_reg_reg[1] DFFQSRX1 $PINS Q=csm_inst_right_reg[1] CLK=CTS_51
+ D=n_7997 RESETB=n_152 SETB=VDD VSS=VSS VDD=VDD
Xcsm_inst_right_reg_reg[2] DFFQSRX1 $PINS Q=csm_inst_right_reg[2] CLK=CTS_44
+ D=n_8030 RESETB=n_152 SETB=VDD VSS=VSS VDD=VDD
Xcsm_inst_right_reg_reg[3] DFFQSRX1 $PINS Q=csm_inst_right_reg[3] CLK=CTS_33
+ D=n_8042 RESETB=n_152 SETB=VDD VSS=VSS VDD=VDD
Xcsm_inst_right_reg_reg[4] DFFQSRX1 $PINS Q=csm_inst_right_reg[4] CLK=CTS_33
+ D=n_7996 RESETB=n_152 SETB=VDD VSS=VSS VDD=VDD
Xcsm_inst_right_reg_reg[5] DFFQSRX1 $PINS Q=csm_inst_right_reg[5] CLK=CTS_51
+ D=n_8039 RESETB=n_152 SETB=VDD VSS=VSS VDD=VDD
Xcsm_inst_right_reg_reg[6] DFFQSRX1 $PINS Q=csm_inst_right_reg[6] CLK=CTS_38
+ D=n_8038 RESETB=n_152 SETB=VDD VSS=VSS VDD=VDD
Xcsm_inst_right_reg_reg[7] DFFQSRX1 $PINS Q=csm_inst_right_reg[7] CLK=CTS_18
+ D=n_8024 RESETB=n_152 SETB=VDD VSS=VSS VDD=VDD
Xcsm_inst_right_reg_reg[8] DFFQSRX1 $PINS Q=csm_inst_right_reg[8] CLK=CTS_18
+ D=n_7994 RESETB=n_152 SETB=VDD VSS=VSS VDD=VDD
Xcsm_inst_right_reg_reg[9] DFFQSRX1 $PINS Q=csm_inst_right_reg[9] CLK=CTS_25
+ D=n_8029 RESETB=n_152 SETB=VDD VSS=VSS VDD=VDD
Xcsm_inst_right_reg_reg[10] DFFQSRX1 $PINS Q=csm_inst_right_reg[10] CLK=CTS_46
+ D=n_8028 RESETB=n_152 SETB=VDD VSS=VSS VDD=VDD
Xcsm_inst_right_reg_reg[11] DFFQSRX1 $PINS Q=csm_inst_right_reg[11] CLK=CTS_29
+ D=n_8034 RESETB=n_152 SETB=VDD VSS=VSS VDD=VDD
Xcsm_inst_right_reg_reg[12] DFFQSRX1 $PINS Q=csm_inst_right_reg[12] CLK=CTS_39
+ D=n_8027 RESETB=n_152 SETB=VDD VSS=VSS VDD=VDD
Xcsm_inst_right_reg_reg[13] DFFQSRX1 $PINS Q=csm_inst_right_reg[13] CLK=CTS_46
+ D=n_8026 RESETB=n_152 SETB=VDD VSS=VSS VDD=VDD
Xcsm_inst_right_reg_reg[14] DFFQSRX1 $PINS Q=csm_inst_right_reg[14] CLK=CTS_39
+ D=n_7977 RESETB=n_152 SETB=VDD VSS=VSS VDD=VDD
Xcsm_inst_right_reg_reg[15] DFFQSRX1 $PINS Q=csm_inst_right_reg[15] CLK=CTS_41
+ D=n_7993 RESETB=n_152 SETB=VDD VSS=VSS VDD=VDD
Xcsm_inst_right_reg_reg[16] DFFQSRX1 $PINS Q=csm_inst_right_reg[16] CLK=CTS_45
+ D=n_7992 RESETB=n_152 SETB=VDD VSS=VSS VDD=VDD
Xcsm_inst_right_reg_reg[17] DFFQSRX1 $PINS Q=csm_inst_right_reg[17] CLK=CTS_33
+ D=n_8025 RESETB=n_152 SETB=VDD VSS=VSS VDD=VDD
Xcsm_inst_right_reg_reg[18] DFFQSRX1 $PINS Q=csm_inst_right_reg[18] CLK=CTS_2
+ D=n_8031 RESETB=n_152 SETB=VDD VSS=VSS VDD=VDD
Xcsm_inst_right_reg_reg[19] DFFQSRX1 $PINS Q=csm_inst_right_reg[19] CLK=CTS_39
+ D=n_8023 RESETB=n_152 SETB=VDD VSS=VSS VDD=VDD
Xcsm_inst_right_reg_reg[20] DFFQSRX1 $PINS Q=csm_inst_right_reg[20] CLK=CTS_39
+ D=n_8022 RESETB=n_152 SETB=VDD VSS=VSS VDD=VDD
Xcsm_inst_right_reg_reg[21] DFFQSRX1 $PINS Q=csm_inst_right_reg[21] CLK=CTS_45
+ D=n_8041 RESETB=n_152 SETB=VDD VSS=VSS VDD=VDD
Xcsm_inst_right_reg_reg[22] DFFQSRX1 $PINS Q=csm_inst_right_reg[22] CLK=CTS_39
+ D=n_8021 RESETB=n_152 SETB=VDD VSS=VSS VDD=VDD
Xcsm_inst_right_reg_reg[23] DFFQSRX1 $PINS Q=csm_inst_right_reg[23] CLK=CTS_37
+ D=n_7991 RESETB=n_152 SETB=VDD VSS=VSS VDD=VDD
Xcsm_inst_right_reg_reg[24] DFFQSRX1 $PINS Q=csm_inst_right_reg[24] CLK=CTS_45
+ D=n_8020 RESETB=n_152 SETB=VDD VSS=VSS VDD=VDD
Xcsm_inst_right_reg_reg[25] DFFQSRX1 $PINS Q=csm_inst_right_reg[25] CLK=CTS_33
+ D=n_8019 RESETB=n_152 SETB=VDD VSS=VSS VDD=VDD
Xcsm_inst_right_reg_reg[26] DFFQSRX1 $PINS Q=csm_inst_right_reg[26] CLK=CTS_45
+ D=n_8040 RESETB=n_152 SETB=VDD VSS=VSS VDD=VDD
Xcsm_inst_right_reg_reg[27] DFFQSRX1 $PINS Q=csm_inst_right_reg[27] CLK=CTS_33
+ D=n_8018 RESETB=n_152 SETB=VDD VSS=VSS VDD=VDD
Xcsm_inst_right_reg_reg[28] DFFQSRX1 $PINS Q=csm_inst_right_reg[28] CLK=CTS_26
+ D=n_8017 RESETB=n_152 SETB=VDD VSS=VSS VDD=VDD
Xcsm_inst_right_reg_reg[29] DFFQSRX1 $PINS Q=csm_inst_right_reg[29] CLK=CTS_46
+ D=n_7998 RESETB=n_152 SETB=VDD VSS=VSS VDD=VDD
Xcsm_inst_right_reg_reg[30] DFFQSRX1 $PINS Q=csm_inst_right_reg[30] CLK=CTS_30
+ D=n_7978 RESETB=n_152 SETB=VDD VSS=VSS VDD=VDD
Xcsm_inst_right_reg_reg[31] DFFQSRX1 $PINS Q=csm_inst_right_reg[31] CLK=CTS_39
+ D=n_8037 RESETB=n_152 SETB=VDD VSS=VSS VDD=VDD
Xcsm_inst_round_counter_reg[0] DFFQSRX1 $PINS Q=csm_inst_round_counter[0]
+ CLK=CTS_22 D=n_5128 RESETB=n_152 SETB=VDD VSS=VSS VDD=VDD
Xcsm_inst_round_counter_reg[1] DFFQSRX1 $PINS Q=csm_inst_round_counter[1]
+ CLK=CTS_22 D=n_5608 RESETB=n_152 SETB=VDD VSS=VSS VDD=VDD
Xcsm_inst_round_counter_reg[2] DFFQSRX1 $PINS Q=csm_inst_round_counter[2]
+ CLK=CTS_22 D=n_5946 RESETB=n_152 SETB=VDD VSS=VSS VDD=VDD
Xcsm_inst_round_counter_reg[3] DFFQSRX1 $PINS Q=csm_inst_round_counter[3]
+ CLK=CTS_22 D=n_5606 RESETB=n_152 SETB=VDD VSS=VSS VDD=VDD
Xcsm_inst_state_reg[0] DFFQSRX1 $PINS Q=csm_inst_state[0] CLK=CTS_22 D=n_5689
+ RESETB=n_152 SETB=VDD VSS=VSS VDD=VDD
Xcsm_inst_state_reg[1] DFFQSRX1 $PINS Q=csm_inst_state[1] CLK=CTS_4 D=n_135
+ RESETB=n_152 SETB=VDD VSS=VSS VDD=VDD
Xcsm_inst_state_reg[2] DFFQSRX1 $PINS Q=csm_inst_state[2] CLK=CTS_4 D=n_5329
+ RESETB=n_152 SETB=VDD VSS=VSS VDD=VDD
Xdata_reg_reg[0] DFFQSRX1 $PINS Q=data_reg[0] CLK=CTS_2 D=n_6337 RESETB=n_152
+ SETB=VDD VSS=VSS VDD=VDD
Xdata_reg_reg[1] DFFQSRX1 $PINS Q=data_reg[1] CLK=CTS_18 D=n_6399 RESETB=n_152
+ SETB=VDD VSS=VSS VDD=VDD
Xdata_reg_reg[2] DFFQSRX1 $PINS Q=data_reg[2] CLK=CTS_44 D=n_6335 RESETB=n_152
+ SETB=VDD VSS=VSS VDD=VDD
Xdata_reg_reg[3] DFFQSRX1 $PINS Q=data_reg[3] CLK=CTS_41 D=n_6334 RESETB=n_152
+ SETB=VDD VSS=VSS VDD=VDD
Xdata_reg_reg[4] DFFQSRX1 $PINS Q=data_reg[4] CLK=CTS_37 D=n_6333 RESETB=n_152
+ SETB=VDD VSS=VSS VDD=VDD
Xdata_reg_reg[5] DFFQSRX1 $PINS Q=data_reg[5] CLK=CTS_37 D=n_6332 RESETB=n_152
+ SETB=VDD VSS=VSS VDD=VDD
Xdata_reg_reg[6] DFFQSRX1 $PINS Q=data_reg[6] CLK=CTS_10 D=n_6331 RESETB=n_152
+ SETB=VDD VSS=VSS VDD=VDD
Xdata_reg_reg[7] DFFQSRX1 $PINS Q=data_reg[7] CLK=CTS_10 D=n_6330 RESETB=n_152
+ SETB=VDD VSS=VSS VDD=VDD
Xdata_reg_reg[8] DFFQSRX1 $PINS Q=data_reg[8] CLK=CTS_10 D=n_6329 RESETB=n_152
+ SETB=VDD VSS=VSS VDD=VDD
Xdata_reg_reg[9] DFFQSRX1 $PINS Q=data_reg[9] CLK=CTS_10 D=n_6328 RESETB=n_152
+ SETB=VDD VSS=VSS VDD=VDD
Xdata_reg_reg[10] DFFQSRX1 $PINS Q=data_reg[10] CLK=CTS_10 D=n_6327
+ RESETB=n_152 SETB=VDD VSS=VSS VDD=VDD
Xdata_reg_reg[11] DFFQSRX1 $PINS Q=data_reg[11] CLK=CTS_8 D=n_6326 RESETB=n_152
+ SETB=VDD VSS=VSS VDD=VDD
Xdata_reg_reg[12] DFFQSRX1 $PINS Q=data_reg[12] CLK=CTS_14 D=n_6325
+ RESETB=n_152 SETB=VDD VSS=VSS VDD=VDD
Xdata_reg_reg[13] DFFQSRX1 $PINS Q=data_reg[13] CLK=CTS_14 D=n_6324
+ RESETB=n_152 SETB=VDD VSS=VSS VDD=VDD
Xdata_reg_reg[14] DFFQSRX1 $PINS Q=data_reg[14] CLK=CTS_26 D=n_6323
+ RESETB=n_152 SETB=VDD VSS=VSS VDD=VDD
Xdata_reg_reg[15] DFFQSRX1 $PINS Q=data_reg[15] CLK=CTS_37 D=n_6322
+ RESETB=n_152 SETB=VDD VSS=VSS VDD=VDD
Xdata_reg_reg[16] DFFQSRX1 $PINS Q=data_reg[16] CLK=CTS_25 D=n_6321
+ RESETB=n_152 SETB=VDD VSS=VSS VDD=VDD
Xdata_reg_reg[17] DFFQSRX1 $PINS Q=data_reg[17] CLK=CTS_41 D=n_6320
+ RESETB=n_152 SETB=VDD VSS=VSS VDD=VDD
Xdata_reg_reg[18] DFFQSRX1 $PINS Q=data_reg[18] CLK=CTS_45 D=n_6319
+ RESETB=n_152 SETB=VDD VSS=VSS VDD=VDD
Xdata_reg_reg[19] DFFQSRX1 $PINS Q=data_reg[19] CLK=CTS_16 D=n_6318
+ RESETB=n_152 SETB=VDD VSS=VSS VDD=VDD
Xdata_reg_reg[20] DFFQSRX1 $PINS Q=data_reg[20] CLK=CTS_3 D=n_6317 RESETB=n_152
+ SETB=VDD VSS=VSS VDD=VDD
Xdata_reg_reg[21] DFFQSRX1 $PINS Q=data_reg[21] CLK=CTS_1 D=n_6316 RESETB=n_152
+ SETB=VDD VSS=VSS VDD=VDD
Xdata_reg_reg[22] DFFQSRX1 $PINS Q=data_reg[22] CLK=CTS_45 D=n_6315
+ RESETB=n_152 SETB=VDD VSS=VSS VDD=VDD
Xdata_reg_reg[23] DFFQSRX1 $PINS Q=data_reg[23] CLK=CTS_44 D=n_6314
+ RESETB=n_152 SETB=VDD VSS=VSS VDD=VDD
Xdata_reg_reg[24] DFFQSRX1 $PINS Q=data_reg[24] CLK=CTS_33 D=n_6313
+ RESETB=n_152 SETB=VDD VSS=VSS VDD=VDD
Xdata_reg_reg[25] DFFQSRX1 $PINS Q=data_reg[25] CLK=CTS_42 D=n_6312
+ RESETB=n_152 SETB=VDD VSS=VSS VDD=VDD
Xdata_reg_reg[26] DFFQSRX1 $PINS Q=data_reg[26] CLK=CTS_26 D=n_6311
+ RESETB=n_152 SETB=VDD VSS=VSS VDD=VDD
Xdata_reg_reg[27] DFFQSRX1 $PINS Q=data_reg[27] CLK=CTS_8 D=n_6310 RESETB=n_152
+ SETB=VDD VSS=VSS VDD=VDD
Xdata_reg_reg[28] DFFQSRX1 $PINS Q=data_reg[28] CLK=CTS_39 D=n_6309
+ RESETB=n_152 SETB=VDD VSS=VSS VDD=VDD
Xdata_reg_reg[29] DFFQSRX1 $PINS Q=data_reg[29] CLK=CTS_8 D=n_6308 RESETB=n_152
+ SETB=VDD VSS=VSS VDD=VDD
Xdata_reg_reg[30] DFFQSRX1 $PINS Q=data_reg[30] CLK=CTS_39 D=n_6307
+ RESETB=n_152 SETB=VDD VSS=VSS VDD=VDD
Xdata_reg_reg[31] DFFQSRX1 $PINS Q=data_reg[31] CLK=CTS_39 D=n_6306
+ RESETB=n_152 SETB=VDD VSS=VSS VDD=VDD
Xdata_reg_reg[32] DFFQSRX1 $PINS Q=data_reg[32] CLK=CTS_38 D=n_6305
+ RESETB=n_152 SETB=VDD VSS=VSS VDD=VDD
Xdata_reg_reg[33] DFFQSRX1 $PINS Q=data_reg[33] CLK=CTS_37 D=n_6304
+ RESETB=n_152 SETB=VDD VSS=VSS VDD=VDD
Xdata_reg_reg[34] DFFQSRX1 $PINS Q=data_reg[34] CLK=CTS_37 D=n_6303
+ RESETB=n_152 SETB=VDD VSS=VSS VDD=VDD
Xdata_reg_reg[35] DFFQSRX1 $PINS Q=data_reg[35] CLK=CTS_26 D=n_6302
+ RESETB=n_152 SETB=VDD VSS=VSS VDD=VDD
Xdata_reg_reg[36] DFFQSRX1 $PINS Q=data_reg[36] CLK=CTS_10 D=n_6301
+ RESETB=n_152 SETB=VDD VSS=VSS VDD=VDD
Xdata_reg_reg[37] DFFQSRX1 $PINS Q=data_reg[37] CLK=CTS_13 D=n_6300
+ RESETB=n_152 SETB=VDD VSS=VSS VDD=VDD
Xdata_reg_reg[38] DFFQSRX1 $PINS Q=data_reg[38] CLK=CTS_37 D=n_6299
+ RESETB=n_152 SETB=VDD VSS=VSS VDD=VDD
Xdata_reg_reg[39] DFFQSRX1 $PINS Q=data_reg[39] CLK=CTS_37 D=n_6298
+ RESETB=n_152 SETB=VDD VSS=VSS VDD=VDD
Xdata_reg_reg[40] DFFQSRX1 $PINS Q=data_reg[40] CLK=CTS_44 D=n_6297
+ RESETB=n_152 SETB=VDD VSS=VSS VDD=VDD
Xdata_reg_reg[41] DFFQSRX1 $PINS Q=data_reg[41] CLK=CTS_45 D=n_6296
+ RESETB=n_152 SETB=VDD VSS=VSS VDD=VDD
Xdata_reg_reg[42] DFFQSRX1 $PINS Q=data_reg[42] CLK=CTS_45 D=n_6295
+ RESETB=n_152 SETB=VDD VSS=VSS VDD=VDD
Xdata_reg_reg[43] DFFQSRX1 $PINS Q=data_reg[43] CLK=CTS_45 D=n_6294
+ RESETB=n_152 SETB=VDD VSS=VSS VDD=VDD
Xdata_reg_reg[44] DFFQSRX1 $PINS Q=data_reg[44] CLK=CTS_3 D=n_6293 RESETB=n_152
+ SETB=VDD VSS=VSS VDD=VDD
Xdata_reg_reg[45] DFFQSRX1 $PINS Q=data_reg[45] CLK=CTS_2 D=n_6292 RESETB=n_152
+ SETB=VDD VSS=VSS VDD=VDD
Xdata_reg_reg[46] DFFQSRX1 $PINS Q=data_reg[46] CLK=CTS_16 D=n_6291
+ RESETB=n_152 SETB=VDD VSS=VSS VDD=VDD
Xdata_reg_reg[47] DFFQSRX1 $PINS Q=data_reg[47] CLK=CTS_45 D=n_6290
+ RESETB=n_152 SETB=VDD VSS=VSS VDD=VDD
Xdata_reg_reg[48] DFFQSRX1 $PINS Q=data_reg[48] CLK=CTS_44 D=n_6289
+ RESETB=n_152 SETB=VDD VSS=VSS VDD=VDD
Xdata_reg_reg[49] DFFQSRX1 $PINS Q=data_reg[49] CLK=CTS_41 D=n_6288
+ RESETB=n_152 SETB=VDD VSS=VSS VDD=VDD
Xdata_reg_reg[50] DFFQSRX1 $PINS Q=data_reg[50] CLK=CTS_41 D=n_6287
+ RESETB=n_152 SETB=VDD VSS=VSS VDD=VDD
Xdata_reg_reg[51] DFFQSRX1 $PINS Q=data_reg[51] CLK=CTS_25 D=n_6286
+ RESETB=n_152 SETB=VDD VSS=VSS VDD=VDD
Xdata_reg_reg[52] DFFQSRX1 $PINS Q=data_reg[52] CLK=CTS_33 D=n_6285
+ RESETB=n_152 SETB=VDD VSS=VSS VDD=VDD
Xdata_reg_reg[53] DFFQSRX1 $PINS Q=data_reg[53] CLK=CTS_37 D=n_6284
+ RESETB=n_152 SETB=VDD VSS=VSS VDD=VDD
Xdata_reg_reg[54] DFFQSRX1 $PINS Q=data_reg[54] CLK=CTS_33 D=n_6283
+ RESETB=n_152 SETB=VDD VSS=VSS VDD=VDD
Xdata_reg_reg[55] DFFQSRX1 $PINS Q=data_reg[55] CLK=CTS_33 D=n_6282
+ RESETB=n_152 SETB=VDD VSS=VSS VDD=VDD
Xdata_reg_reg[56] DFFQSRX1 $PINS Q=data_reg[56] CLK=CTS_41 D=n_6281
+ RESETB=n_152 SETB=VDD VSS=VSS VDD=VDD
Xdata_reg_reg[57] DFFQSRX1 $PINS Q=data_reg[57] CLK=CTS_41 D=n_6280
+ RESETB=n_152 SETB=VDD VSS=VSS VDD=VDD
Xdata_reg_reg[58] DFFQSRX1 $PINS Q=data_reg[58] CLK=CTS_1 D=n_6279 RESETB=n_152
+ SETB=VDD VSS=VSS VDD=VDD
Xdata_reg_reg[59] DFFQSRX1 $PINS Q=data_reg[59] CLK=CTS_2 D=n_6278 RESETB=n_152
+ SETB=VDD VSS=VSS VDD=VDD
Xdata_reg_reg[60] DFFQSRX1 $PINS Q=data_reg[60] CLK=CTS_3 D=n_6277 RESETB=n_152
+ SETB=VDD VSS=VSS VDD=VDD
Xdata_reg_reg[61] DFFQSRX1 $PINS Q=data_reg[61] CLK=CTS_3 D=n_6276 RESETB=n_152
+ SETB=VDD VSS=VSS VDD=VDD
Xdata_reg_reg[62] DFFQSRX1 $PINS Q=data_reg[62] CLK=CTS_3 D=n_6275 RESETB=n_152
+ SETB=VDD VSS=VSS VDD=VDD
Xdata_reg_reg[63] DFFQSRX1 $PINS Q=data_reg[63] CLK=CTS_3 D=n_6274 RESETB=n_152
+ SETB=VDD VSS=VSS VDD=VDD
Xkey_reg_reg[1] DFFQSRX1 $PINS Q=key_reg[1] CLK=CTS_16 D=n_6583 RESETB=n_152
+ SETB=VDD VSS=VSS VDD=VDD
Xkey_reg_reg[2] DFFQSRX1 $PINS Q=key_reg[2] CLK=CTS_21 D=n_6582 RESETB=n_152
+ SETB=VDD VSS=VSS VDD=VDD
Xkey_reg_reg[3] DFFQSRX1 $PINS Q=key_reg[3] CLK=CTS_21 D=n_6581 RESETB=n_152
+ SETB=VDD VSS=VSS VDD=VDD
Xkey_reg_reg[4] DFFQSRX1 $PINS Q=key_reg[4] CLK=CTS_9 D=n_6580 RESETB=n_152
+ SETB=VDD VSS=VSS VDD=VDD
Xkey_reg_reg[5] DFFQSRX1 $PINS Q=key_reg[5] CLK=CTS_9 D=n_6579 RESETB=n_152
+ SETB=VDD VSS=VSS VDD=VDD
Xkey_reg_reg[6] DFFQSRX1 $PINS Q=key_reg[6] CLK=CTS_11 D=n_6578 RESETB=n_152
+ SETB=VDD VSS=VSS VDD=VDD
Xkey_reg_reg[7] DFFQSRX1 $PINS Q=key_reg[7] CLK=CTS_11 D=n_6577 RESETB=n_152
+ SETB=VDD VSS=VSS VDD=VDD
Xkey_reg_reg[9] DFFQSRX1 $PINS Q=key_reg[9] CLK=CTS_13 D=n_6576 RESETB=n_152
+ SETB=VDD VSS=VSS VDD=VDD
Xkey_reg_reg[10] DFFQSRX1 $PINS Q=key_reg[10] CLK=CTS_9 D=n_6575 RESETB=n_152
+ SETB=VDD VSS=VSS VDD=VDD
Xkey_reg_reg[11] DFFQSRX1 $PINS Q=key_reg[11] CLK=CTS_13 D=n_6574 RESETB=n_152
+ SETB=VDD VSS=VSS VDD=VDD
Xkey_reg_reg[12] DFFQSRX1 $PINS Q=key_reg[12] CLK=CTS_11 D=n_6573 RESETB=n_152
+ SETB=VDD VSS=VSS VDD=VDD
Xkey_reg_reg[13] DFFQSRX1 $PINS Q=key_reg[13] CLK=CTS_11 D=n_6572 RESETB=n_152
+ SETB=VDD VSS=VSS VDD=VDD
Xkey_reg_reg[14] DFFQSRX1 $PINS Q=key_reg[14] CLK=CTS_9 D=n_6571 RESETB=n_152
+ SETB=VDD VSS=VSS VDD=VDD
Xkey_reg_reg[15] DFFQSRX1 $PINS Q=key_reg[15] CLK=CTS_9 D=n_6570 RESETB=n_152
+ SETB=VDD VSS=VSS VDD=VDD
Xkey_reg_reg[17] DFFQSRX1 $PINS Q=key_reg[17] CLK=CTS_21 D=n_6569 RESETB=n_152
+ SETB=VDD VSS=VSS VDD=VDD
Xkey_reg_reg[18] DFFQSRX1 $PINS Q=key_reg[18] CLK=CTS_16 D=n_6568 RESETB=n_152
+ SETB=VDD VSS=VSS VDD=VDD
Xkey_reg_reg[19] DFFQSRX1 $PINS Q=key_reg[19] CLK=CTS_16 D=n_6567 RESETB=n_152
+ SETB=VDD VSS=VSS VDD=VDD
Xkey_reg_reg[20] DFFQSRX1 $PINS Q=key_reg[20] CLK=CTS_16 D=n_6566 RESETB=n_152
+ SETB=VDD VSS=VSS VDD=VDD
Xkey_reg_reg[21] DFFQSRX1 $PINS Q=key_reg[21] CLK=CTS_16 D=n_6565 RESETB=n_152
+ SETB=VDD VSS=VSS VDD=VDD
Xkey_reg_reg[22] DFFQSRX1 $PINS Q=key_reg[22] CLK=CTS_1 D=n_6564 RESETB=n_152
+ SETB=VDD VSS=VSS VDD=VDD
Xkey_reg_reg[23] DFFQSRX1 $PINS Q=key_reg[23] CLK=CTS_19 D=n_6563 RESETB=n_152
+ SETB=VDD VSS=VSS VDD=VDD
Xkey_reg_reg[25] DFFQSRX1 $PINS Q=key_reg[25] CLK=CTS_21 D=n_6585 RESETB=n_152
+ SETB=VDD VSS=VSS VDD=VDD
Xkey_reg_reg[26] DFFQSRX1 $PINS Q=key_reg[26] CLK=CTS_9 D=n_6592 RESETB=n_152
+ SETB=VDD VSS=VSS VDD=VDD
Xkey_reg_reg[27] DFFQSRX1 $PINS Q=key_reg[27] CLK=CTS_8 D=n_6636 RESETB=n_152
+ SETB=VDD VSS=VSS VDD=VDD
Xkey_reg_reg[28] DFFQSRX1 $PINS Q=key_reg[28] CLK=CTS_11 D=n_6655 RESETB=n_152
+ SETB=VDD VSS=VSS VDD=VDD
Xkey_reg_reg[29] DFFQSRX1 $PINS Q=key_reg[29] CLK=CTS_11 D=n_6657 RESETB=n_152
+ SETB=VDD VSS=VSS VDD=VDD
Xkey_reg_reg[30] DFFQSRX1 $PINS Q=key_reg[30] CLK=CTS_11 D=n_6658 RESETB=n_152
+ SETB=VDD VSS=VSS VDD=VDD
Xkey_reg_reg[31] DFFQSRX1 $PINS Q=key_reg[31] CLK=CTS_9 D=n_6660 RESETB=n_152
+ SETB=VDD VSS=VSS VDD=VDD
Xkey_reg_reg[33] DFFQSRX1 $PINS Q=key_reg[33] CLK=CTS_42 D=n_6661 RESETB=n_152
+ SETB=VDD VSS=VSS VDD=VDD
Xkey_reg_reg[34] DFFQSRX1 $PINS Q=key_reg[34] CLK=CTS_11 D=n_6662 RESETB=n_152
+ SETB=VDD VSS=VSS VDD=VDD
Xkey_reg_reg[35] DFFQSRX1 $PINS Q=key_reg[35] CLK=CTS_9 D=n_6663 RESETB=n_152
+ SETB=VDD VSS=VSS VDD=VDD
Xkey_reg_reg[36] DFFQSRX1 $PINS Q=key_reg[36] CLK=CTS_11 D=n_6664 RESETB=n_152
+ SETB=VDD VSS=VSS VDD=VDD
Xkey_reg_reg[37] DFFQSRX1 $PINS Q=key_reg[37] CLK=CTS_11 D=n_6665 RESETB=n_152
+ SETB=VDD VSS=VSS VDD=VDD
Xkey_reg_reg[38] DFFQSRX1 $PINS Q=key_reg[38] CLK=CTS_9 D=n_6666 RESETB=n_152
+ SETB=VDD VSS=VSS VDD=VDD
Xkey_reg_reg[39] DFFQSRX1 $PINS Q=key_reg[39] CLK=CTS_42 D=n_6668 RESETB=n_152
+ SETB=VDD VSS=VSS VDD=VDD
Xkey_reg_reg[41] DFFQSRX1 $PINS Q=key_reg[41] CLK=CTS_19 D=n_6612 RESETB=n_152
+ SETB=VDD VSS=VSS VDD=VDD
Xkey_reg_reg[42] DFFQSRX1 $PINS Q=key_reg[42] CLK=CTS_16 D=n_6669 RESETB=n_152
+ SETB=VDD VSS=VSS VDD=VDD
Xkey_reg_reg[43] DFFQSRX1 $PINS Q=key_reg[43] CLK=CTS_1 D=n_6670 RESETB=n_152
+ SETB=VDD VSS=VSS VDD=VDD
Xkey_reg_reg[44] DFFQSRX1 $PINS Q=key_reg[44] CLK=CTS_4 D=n_6671 RESETB=n_152
+ SETB=VDD VSS=VSS VDD=VDD
Xkey_reg_reg[45] DFFQSRX1 $PINS Q=key_reg[45] CLK=CTS_16 D=n_6673 RESETB=n_152
+ SETB=VDD VSS=VSS VDD=VDD
Xkey_reg_reg[46] DFFQSRX1 $PINS Q=key_reg[46] CLK=CTS_16 D=n_6674 RESETB=n_152
+ SETB=VDD VSS=VSS VDD=VDD
Xkey_reg_reg[47] DFFQSRX1 $PINS Q=key_reg[47] CLK=CTS_1 D=n_6675 RESETB=n_152
+ SETB=VDD VSS=VSS VDD=VDD
Xkey_reg_reg[49] DFFQSRX1 $PINS Q=key_reg[49] CLK=CTS_21 D=n_6677 RESETB=n_152
+ SETB=VDD VSS=VSS VDD=VDD
Xkey_reg_reg[50] DFFQSRX1 $PINS Q=key_reg[50] CLK=CTS_21 D=n_6678 RESETB=n_152
+ SETB=VDD VSS=VSS VDD=VDD
Xkey_reg_reg[51] DFFQSRX1 $PINS Q=key_reg[51] CLK=CTS_21 D=n_6680 RESETB=n_152
+ SETB=VDD VSS=VSS VDD=VDD
Xkey_reg_reg[52] DFFQSRX1 $PINS Q=key_reg[52] CLK=CTS_21 D=n_6681 RESETB=n_152
+ SETB=VDD VSS=VSS VDD=VDD
Xkey_reg_reg[53] DFFQSRX1 $PINS Q=key_reg[53] CLK=CTS_42 D=n_6682 RESETB=n_152
+ SETB=VDD VSS=VSS VDD=VDD
Xkey_reg_reg[54] DFFQSRX1 $PINS Q=key_reg[54] CLK=CTS_9 D=n_6684 RESETB=n_152
+ SETB=VDD VSS=VSS VDD=VDD
Xkey_reg_reg[55] DFFQSRX1 $PINS Q=key_reg[55] CLK=CTS_42 D=n_6688 RESETB=n_152
+ SETB=VDD VSS=VSS VDD=VDD
Xkey_reg_reg[57] DFFQSRX1 $PINS Q=key_reg[57] CLK=CTS_21 D=n_6692 RESETB=n_152
+ SETB=VDD VSS=VSS VDD=VDD
Xkey_reg_reg[58] DFFQSRX1 $PINS Q=key_reg[58] CLK=CTS_1 D=n_6693 RESETB=n_152
+ SETB=VDD VSS=VSS VDD=VDD
Xkey_reg_reg[59] DFFQSRX1 $PINS Q=key_reg[59] CLK=CTS_16 D=n_6694 RESETB=n_152
+ SETB=VDD VSS=VSS VDD=VDD
Xkey_reg_reg[60] DFFQSRX1 $PINS Q=key_reg[60] CLK=CTS_4 D=n_6695 RESETB=n_152
+ SETB=VDD VSS=VSS VDD=VDD
Xkey_reg_reg[61] DFFQSRX1 $PINS Q=key_reg[61] CLK=CTS_16 D=n_6696 RESETB=n_152
+ SETB=VDD VSS=VSS VDD=VDD
Xkey_reg_reg[62] DFFQSRX1 $PINS Q=key_reg[62] CLK=CTS_16 D=n_6697 RESETB=n_152
+ SETB=VDD VSS=VSS VDD=VDD
Xkey_reg_reg[63] DFFQSRX1 $PINS Q=key_reg[63] CLK=CTS_16 D=n_6698 RESETB=n_152
+ SETB=VDD VSS=VSS VDD=VDD
Xspi_inst_active_reg DFFQSRX1 $PINS Q=spi_inst_active CLK=CTS_15 D=n_5593
+ RESETB=n_152 SETB=VDD VSS=VSS VDD=VDD
Xspi_inst_bit_count_reg[0] DFFQSRX1 $PINS Q=spi_inst_bit_count[0] CLK=CTS_2
+ D=n_6343 RESETB=n_152 SETB=VDD VSS=VSS VDD=VDD
Xspi_inst_bit_count_reg[1] DFFQSRX1 $PINS Q=spi_inst_bit_count[1] CLK=CTS_6
+ D=n_6690 RESETB=n_152 SETB=VDD VSS=VSS VDD=VDD
Xspi_inst_bit_count_reg[2] DFFQSRX1 $PINS Q=spi_inst_bit_count[2] CLK=CTS_15
+ D=n_6689 RESETB=n_152 SETB=VDD VSS=VSS VDD=VDD
Xspi_inst_bit_count_reg[3] DFFQSRX1 $PINS Q=spi_inst_bit_count[3] CLK=CTS_15
+ D=n_6687 RESETB=n_152 SETB=VDD VSS=VSS VDD=VDD
Xspi_inst_bit_count_reg[4] DFFQSRX1 $PINS Q=spi_inst_bit_count[4] CLK=CTS_15
+ D=n_6686 RESETB=n_152 SETB=VDD VSS=VSS VDD=VDD
Xspi_inst_bit_count_reg[5] DFFQSRX1 $PINS Q=spi_inst_bit_count[5] CLK=CTS_15
+ D=n_6685 RESETB=n_152 SETB=VDD VSS=VSS VDD=VDD
Xspi_inst_bit_count_reg[6] DFFQSRX1 $PINS Q=spi_inst_bit_count[6] CLK=CTS_15
+ D=n_6817 RESETB=n_152 SETB=VDD VSS=VSS VDD=VDD
Xspi_inst_input_text_reg[0] DFFQSRX1 $PINS Q=spi_rx_data[0] CLK=CTS_15 D=n_5824
+ RESETB=n_152 SETB=VDD VSS=VSS VDD=VDD
Xspi_inst_input_text_reg[1] DFFQSRX1 $PINS Q=spi_rx_data[1] CLK=CTS_2 D=n_5823
+ RESETB=n_152 SETB=VDD VSS=VSS VDD=VDD
Xspi_inst_input_text_reg[2] DFFQSRX1 $PINS Q=spi_rx_data[2] CLK=CTS_19 D=n_5884
+ RESETB=n_152 SETB=VDD VSS=VSS VDD=VDD
Xspi_inst_input_text_reg[3] DFFQSRX1 $PINS Q=spi_rx_data[3] CLK=CTS_19 D=n_5821
+ RESETB=n_152 SETB=VDD VSS=VSS VDD=VDD
Xspi_inst_input_text_reg[4] DFFQSRX1 $PINS Q=spi_rx_data[4] CLK=CTS_9 D=n_5820
+ RESETB=n_152 SETB=VDD VSS=VSS VDD=VDD
Xspi_inst_input_text_reg[5] DFFQSRX1 $PINS Q=spi_rx_data[5] CLK=CTS_8 D=n_5819
+ RESETB=n_152 SETB=VDD VSS=VSS VDD=VDD
Xspi_inst_input_text_reg[6] DFFQSRX1 $PINS Q=spi_rx_data[6] CLK=CTS_13 D=n_5818
+ RESETB=n_152 SETB=VDD VSS=VSS VDD=VDD
Xspi_inst_input_text_reg[7] DFFQSRX1 $PINS Q=spi_rx_data[7] CLK=CTS_10 D=n_5817
+ RESETB=n_152 SETB=VDD VSS=VSS VDD=VDD
Xspi_inst_input_text_reg[8] DFFQSRX1 $PINS Q=spi_rx_data[8] CLK=CTS_10 D=n_5816
+ RESETB=n_152 SETB=VDD VSS=VSS VDD=VDD
Xspi_inst_input_text_reg[9] DFFQSRX1 $PINS Q=spi_rx_data[9] CLK=CTS_10 D=n_5815
+ RESETB=n_152 SETB=VDD VSS=VSS VDD=VDD
Xspi_inst_input_text_reg[10] DFFQSRX1 $PINS Q=spi_rx_data[10] CLK=CTS_14
+ D=n_5814 RESETB=n_152 SETB=VDD VSS=VSS VDD=VDD
Xspi_inst_input_text_reg[11] DFFQSRX1 $PINS Q=spi_rx_data[11] CLK=CTS_14
+ D=n_5813 RESETB=n_152 SETB=VDD VSS=VSS VDD=VDD
Xspi_inst_input_text_reg[12] DFFQSRX1 $PINS Q=spi_rx_data[12] CLK=CTS_14
+ D=n_5812 RESETB=n_152 SETB=VDD VSS=VSS VDD=VDD
Xspi_inst_input_text_reg[13] DFFQSRX1 $PINS Q=spi_rx_data[13] CLK=CTS_11
+ D=n_5811 RESETB=n_152 SETB=VDD VSS=VSS VDD=VDD
Xspi_inst_input_text_reg[14] DFFQSRX1 $PINS Q=spi_rx_data[14] CLK=CTS_26
+ D=n_5810 RESETB=n_152 SETB=VDD VSS=VSS VDD=VDD
Xspi_inst_input_text_reg[15] DFFQSRX1 $PINS Q=spi_rx_data[15] CLK=CTS_37
+ D=n_5809 RESETB=n_152 SETB=VDD VSS=VSS VDD=VDD
Xspi_inst_input_text_reg[16] DFFQSRX1 $PINS Q=spi_rx_data[16] CLK=CTS_25
+ D=n_5808 RESETB=n_152 SETB=VDD VSS=VSS VDD=VDD
Xspi_inst_input_text_reg[17] DFFQSRX1 $PINS Q=spi_rx_data[17] CLK=CTS_44
+ D=n_5807 RESETB=n_152 SETB=VDD VSS=VSS VDD=VDD
Xspi_inst_input_text_reg[18] DFFQSRX1 $PINS Q=spi_rx_data[18] CLK=CTS_1
+ D=n_5806 RESETB=n_152 SETB=VDD VSS=VSS VDD=VDD
Xspi_inst_input_text_reg[19] DFFQSRX1 $PINS Q=spi_rx_data[19] CLK=CTS_3
+ D=n_5805 RESETB=n_152 SETB=VDD VSS=VSS VDD=VDD
Xspi_inst_input_text_reg[20] DFFQSRX1 $PINS Q=spi_rx_data[20] CLK=CTS_3
+ D=n_5804 RESETB=n_152 SETB=VDD VSS=VSS VDD=VDD
Xspi_inst_input_text_reg[21] DFFQSRX1 $PINS Q=spi_rx_data[21] CLK=CTS_3
+ D=n_5803 RESETB=n_152 SETB=VDD VSS=VSS VDD=VDD
Xspi_inst_input_text_reg[22] DFFQSRX1 $PINS Q=spi_rx_data[22] CLK=CTS_1
+ D=n_5802 RESETB=n_152 SETB=VDD VSS=VSS VDD=VDD
Xspi_inst_input_text_reg[23] DFFQSRX1 $PINS Q=spi_rx_data[23] CLK=CTS_19
+ D=n_5801 RESETB=n_152 SETB=VDD VSS=VSS VDD=VDD
Xspi_inst_input_text_reg[24] DFFQSRX1 $PINS Q=spi_rx_data[24] CLK=CTS_25
+ D=n_5800 RESETB=n_152 SETB=VDD VSS=VSS VDD=VDD
Xspi_inst_input_text_reg[25] DFFQSRX1 $PINS Q=spi_rx_data[25] CLK=CTS_42
+ D=n_5761 RESETB=n_152 SETB=VDD VSS=VSS VDD=VDD
Xspi_inst_input_text_reg[26] DFFQSRX1 $PINS Q=spi_rx_data[26] CLK=CTS_26
+ D=n_5799 RESETB=n_152 SETB=VDD VSS=VSS VDD=VDD
Xspi_inst_input_text_reg[27] DFFQSRX1 $PINS Q=spi_rx_data[27] CLK=CTS_8
+ D=n_5762 RESETB=n_152 SETB=VDD VSS=VSS VDD=VDD
Xspi_inst_input_text_reg[28] DFFQSRX1 $PINS Q=spi_rx_data[28] CLK=CTS_13
+ D=n_5798 RESETB=n_152 SETB=VDD VSS=VSS VDD=VDD
Xspi_inst_input_text_reg[29] DFFQSRX1 $PINS Q=spi_rx_data[29] CLK=CTS_11
+ D=n_5797 RESETB=n_152 SETB=VDD VSS=VSS VDD=VDD
Xspi_inst_input_text_reg[30] DFFQSRX1 $PINS Q=spi_rx_data[30] CLK=CTS_13
+ D=n_5796 RESETB=n_152 SETB=VDD VSS=VSS VDD=VDD
Xspi_inst_input_text_reg[31] DFFQSRX1 $PINS Q=spi_rx_data[31] CLK=CTS_8
+ D=n_5795 RESETB=n_152 SETB=VDD VSS=VSS VDD=VDD
Xspi_inst_input_text_reg[32] DFFQSRX1 $PINS Q=spi_rx_data[32] CLK=CTS_8
+ D=n_5794 RESETB=n_152 SETB=VDD VSS=VSS VDD=VDD
Xspi_inst_input_text_reg[33] DFFQSRX1 $PINS Q=spi_rx_data[33] CLK=CTS_26
+ D=n_5793 RESETB=n_152 SETB=VDD VSS=VSS VDD=VDD
Xspi_inst_input_text_reg[34] DFFQSRX1 $PINS Q=spi_rx_data[34] CLK=CTS_13
+ D=n_5792 RESETB=n_152 SETB=VDD VSS=VSS VDD=VDD
Xspi_inst_input_text_reg[35] DFFQSRX1 $PINS Q=spi_rx_data[35] CLK=CTS_13
+ D=n_5791 RESETB=n_152 SETB=VDD VSS=VSS VDD=VDD
Xspi_inst_input_text_reg[36] DFFQSRX1 $PINS Q=spi_rx_data[36] CLK=CTS_14
+ D=n_5790 RESETB=n_152 SETB=VDD VSS=VSS VDD=VDD
Xspi_inst_input_text_reg[37] DFFQSRX1 $PINS Q=spi_rx_data[37] CLK=CTS_11
+ D=n_5789 RESETB=n_152 SETB=VDD VSS=VSS VDD=VDD
Xspi_inst_input_text_reg[38] DFFQSRX1 $PINS Q=spi_rx_data[38] CLK=CTS_9
+ D=n_5788 RESETB=n_152 SETB=VDD VSS=VSS VDD=VDD
Xspi_inst_input_text_reg[39] DFFQSRX1 $PINS Q=spi_rx_data[39] CLK=CTS_42
+ D=n_5787 RESETB=n_152 SETB=VDD VSS=VSS VDD=VDD
Xspi_inst_input_text_reg[40] DFFQSRX1 $PINS Q=spi_rx_data[40] CLK=CTS_44
+ D=n_5786 RESETB=n_152 SETB=VDD VSS=VSS VDD=VDD
Xspi_inst_input_text_reg[41] DFFQSRX1 $PINS Q=spi_rx_data[41] CLK=CTS_19
+ D=n_5785 RESETB=n_152 SETB=VDD VSS=VSS VDD=VDD
Xspi_inst_input_text_reg[42] DFFQSRX1 $PINS Q=spi_rx_data[42] CLK=CTS_2
+ D=n_5784 RESETB=n_152 SETB=VDD VSS=VSS VDD=VDD
Xspi_inst_input_text_reg[43] DFFQSRX1 $PINS Q=spi_rx_data[43] CLK=CTS_2
+ D=n_5783 RESETB=n_152 SETB=VDD VSS=VSS VDD=VDD
Xspi_inst_input_text_reg[44] DFFQSRX1 $PINS Q=spi_rx_data[44] CLK=CTS_6
+ D=n_5782 RESETB=n_152 SETB=VDD VSS=VSS VDD=VDD
Xspi_inst_input_text_reg[45] DFFQSRX1 $PINS Q=spi_rx_data[45] CLK=CTS_6
+ D=n_5781 RESETB=n_152 SETB=VDD VSS=VSS VDD=VDD
Xspi_inst_input_text_reg[46] DFFQSRX1 $PINS Q=spi_rx_data[46] CLK=CTS_3
+ D=n_5780 RESETB=n_152 SETB=VDD VSS=VSS VDD=VDD
Xspi_inst_input_text_reg[47] DFFQSRX1 $PINS Q=spi_rx_data[47] CLK=CTS_19
+ D=n_5779 RESETB=n_152 SETB=VDD VSS=VSS VDD=VDD
Xspi_inst_input_text_reg[48] DFFQSRX1 $PINS Q=spi_rx_data[48] CLK=CTS_44
+ D=n_5778 RESETB=n_152 SETB=VDD VSS=VSS VDD=VDD
Xspi_inst_input_text_reg[49] DFFQSRX1 $PINS Q=spi_rx_data[49] CLK=CTS_41
+ D=n_5777 RESETB=n_152 SETB=VDD VSS=VSS VDD=VDD
Xspi_inst_input_text_reg[50] DFFQSRX1 $PINS Q=spi_rx_data[50] CLK=CTS_25
+ D=n_5776 RESETB=n_152 SETB=VDD VSS=VSS VDD=VDD
Xspi_inst_input_text_reg[51] DFFQSRX1 $PINS Q=spi_rx_data[51] CLK=CTS_25
+ D=n_5775 RESETB=n_152 SETB=VDD VSS=VSS VDD=VDD
Xspi_inst_input_text_reg[52] DFFQSRX1 $PINS Q=spi_rx_data[52] CLK=CTS_42
+ D=n_5774 RESETB=n_152 SETB=VDD VSS=VSS VDD=VDD
Xspi_inst_input_text_reg[53] DFFQSRX1 $PINS Q=spi_rx_data[53] CLK=CTS_42
+ D=n_5773 RESETB=n_152 SETB=VDD VSS=VSS VDD=VDD
Xspi_inst_input_text_reg[54] DFFQSRX1 $PINS Q=spi_rx_data[54] CLK=CTS_42
+ D=n_5763 RESETB=n_152 SETB=VDD VSS=VSS VDD=VDD
Xspi_inst_input_text_reg[55] DFFQSRX1 $PINS Q=spi_rx_data[55] CLK=CTS_25
+ D=n_5772 RESETB=n_152 SETB=VDD VSS=VSS VDD=VDD
Xspi_inst_input_text_reg[56] DFFQSRX1 $PINS Q=spi_rx_data[56] CLK=CTS_41
+ D=n_5771 RESETB=n_152 SETB=VDD VSS=VSS VDD=VDD
Xspi_inst_input_text_reg[57] DFFQSRX1 $PINS Q=spi_rx_data[57] CLK=CTS_44
+ D=n_5770 RESETB=n_152 SETB=VDD VSS=VSS VDD=VDD
Xspi_inst_input_text_reg[58] DFFQSRX1 $PINS Q=spi_rx_data[58] CLK=CTS_1
+ D=n_5769 RESETB=n_152 SETB=VDD VSS=VSS VDD=VDD
Xspi_inst_input_text_reg[59] DFFQSRX1 $PINS Q=spi_rx_data[59] CLK=CTS_7
+ D=n_5768 RESETB=n_152 SETB=VDD VSS=VSS VDD=VDD
Xspi_inst_input_text_reg[60] DFFQSRX1 $PINS Q=spi_rx_data[60] CLK=CTS_4
+ D=n_5767 RESETB=n_152 SETB=VDD VSS=VSS VDD=VDD
Xspi_inst_input_text_reg[61] DFFQSRX1 $PINS Q=spi_rx_data[61] CLK=CTS_4
+ D=n_5766 RESETB=n_152 SETB=VDD VSS=VSS VDD=VDD
Xspi_inst_input_text_reg[62] DFFQSRX1 $PINS Q=spi_rx_data[62] CLK=CTS_7
+ D=n_5765 RESETB=n_152 SETB=VDD VSS=VSS VDD=VDD
Xspi_inst_input_text_reg[63] DFFQSRX1 $PINS Q=spi_rx_data[63] CLK=CTS_4
+ D=n_5764 RESETB=n_152 SETB=VDD VSS=VSS VDD=VDD
Xspi_inst_miso_reg_reg DFFQSRX1 $PINS Q=miso CLK=CTS_43 D=n_6653 RESETB=n_152
+ SETB=VDD VSS=VSS VDD=VDD
Xspi_inst_sclk_prev_reg DFFQSRX1 $PINS Q=spi_inst_sclk_prev CLK=CTS_15
+ D=spi_inst_sclk_sync2 RESETB=n_152 SETB=VDD VSS=VSS VDD=VDD
Xspi_inst_sclk_sync1_reg DFFQSRX1 $PINS Q=spi_inst_sclk_sync1 CLK=CTS_4 D=sclk
+ RESETB=n_152 SETB=VDD VSS=VSS VDD=VDD
Xspi_inst_sclk_sync2_reg DFFQSRX1 $PINS Q=spi_inst_sclk_sync2 CLK=CTS_7
+ D=spi_inst_sclk_sync1 RESETB=n_152 SETB=VDD VSS=VSS VDD=VDD
Xspi_inst_shift_in_reg[0] DFFQSRX1 $PINS Q=spi_inst_shift_in[0] CLK=CTS_15
+ D=n_6496 RESETB=n_152 SETB=VDD VSS=VSS VDD=VDD
Xspi_inst_shift_in_reg[1] DFFQSRX1 $PINS Q=spi_inst_shift_in[1] CLK=CTS_15
+ D=n_6495 RESETB=n_152 SETB=VDD VSS=VSS VDD=VDD
Xspi_inst_shift_in_reg[2] DFFQSRX1 $PINS Q=spi_inst_shift_in[2] CLK=CTS_19
+ D=n_6494 RESETB=n_152 SETB=VDD VSS=VSS VDD=VDD
Xspi_inst_shift_in_reg[3] DFFQSRX1 $PINS Q=spi_inst_shift_in[3] CLK=CTS_19
+ D=n_6492 RESETB=n_152 SETB=VDD VSS=VSS VDD=VDD
Xspi_inst_shift_in_reg[4] DFFQSRX1 $PINS Q=spi_inst_shift_in[4] CLK=CTS_42
+ D=n_6491 RESETB=n_152 SETB=VDD VSS=VSS VDD=VDD
Xspi_inst_shift_in_reg[5] DFFQSRX1 $PINS Q=spi_inst_shift_in[5] CLK=CTS_9
+ D=n_6490 RESETB=n_152 SETB=VDD VSS=VSS VDD=VDD
Xspi_inst_shift_in_reg[6] DFFQSRX1 $PINS Q=spi_inst_shift_in[6] CLK=CTS_13
+ D=n_6489 RESETB=n_152 SETB=VDD VSS=VSS VDD=VDD
Xspi_inst_shift_in_reg[7] DFFQSRX1 $PINS Q=spi_inst_shift_in[7] CLK=CTS_10
+ D=n_6488 RESETB=n_152 SETB=VDD VSS=VSS VDD=VDD
Xspi_inst_shift_in_reg[8] DFFQSRX1 $PINS Q=spi_inst_shift_in[8] CLK=CTS_10
+ D=n_6487 RESETB=n_152 SETB=VDD VSS=VSS VDD=VDD
Xspi_inst_shift_in_reg[9] DFFQSRX1 $PINS Q=spi_inst_shift_in[9] CLK=CTS_10
+ D=n_6486 RESETB=n_152 SETB=VDD VSS=VSS VDD=VDD
Xspi_inst_shift_in_reg[10] DFFQSRX1 $PINS Q=spi_inst_shift_in[10] CLK=CTS_14
+ D=n_6485 RESETB=n_152 SETB=VDD VSS=VSS VDD=VDD
Xspi_inst_shift_in_reg[11] DFFQSRX1 $PINS Q=spi_inst_shift_in[11] CLK=CTS_14
+ D=n_6484 RESETB=n_152 SETB=VDD VSS=VSS VDD=VDD
Xspi_inst_shift_in_reg[12] DFFQSRX1 $PINS Q=spi_inst_shift_in[12] CLK=CTS_14
+ D=n_6483 RESETB=n_152 SETB=VDD VSS=VSS VDD=VDD
Xspi_inst_shift_in_reg[13] DFFQSRX1 $PINS Q=spi_inst_shift_in[13] CLK=CTS_14
+ D=n_6482 RESETB=n_152 SETB=VDD VSS=VSS VDD=VDD
Xspi_inst_shift_in_reg[14] DFFQSRX1 $PINS Q=spi_inst_shift_in[14] CLK=CTS_8
+ D=n_6480 RESETB=n_152 SETB=VDD VSS=VSS VDD=VDD
Xspi_inst_shift_in_reg[15] DFFQSRX1 $PINS Q=spi_inst_shift_in[15] CLK=CTS_9
+ D=n_6479 RESETB=n_152 SETB=VDD VSS=VSS VDD=VDD
Xspi_inst_shift_in_reg[16] DFFQSRX1 $PINS Q=spi_inst_shift_in[16] CLK=CTS_25
+ D=n_6478 RESETB=n_152 SETB=VDD VSS=VSS VDD=VDD
Xspi_inst_shift_in_reg[17] DFFQSRX1 $PINS Q=spi_inst_shift_in[17] CLK=CTS_44
+ D=n_6477 RESETB=n_152 SETB=VDD VSS=VSS VDD=VDD
Xspi_inst_shift_in_reg[18] DFFQSRX1 $PINS Q=spi_inst_shift_in[18] CLK=CTS_19
+ D=n_6476 RESETB=n_152 SETB=VDD VSS=VSS VDD=VDD
Xspi_inst_shift_in_reg[19] DFFQSRX1 $PINS Q=spi_inst_shift_in[19] CLK=CTS_1
+ D=n_6475 RESETB=n_152 SETB=VDD VSS=VSS VDD=VDD
Xspi_inst_shift_in_reg[20] DFFQSRX1 $PINS Q=spi_inst_shift_in[20] CLK=CTS_3
+ D=n_6474 RESETB=n_152 SETB=VDD VSS=VSS VDD=VDD
Xspi_inst_shift_in_reg[21] DFFQSRX1 $PINS Q=spi_inst_shift_in[21] CLK=CTS_6
+ D=n_6473 RESETB=n_152 SETB=VDD VSS=VSS VDD=VDD
Xspi_inst_shift_in_reg[22] DFFQSRX1 $PINS Q=spi_inst_shift_in[22] CLK=CTS_2
+ D=n_6472 RESETB=n_152 SETB=VDD VSS=VSS VDD=VDD
Xspi_inst_shift_in_reg[23] DFFQSRX1 $PINS Q=spi_inst_shift_in[23] CLK=CTS_19
+ D=n_6470 RESETB=n_152 SETB=VDD VSS=VSS VDD=VDD
Xspi_inst_shift_in_reg[24] DFFQSRX1 $PINS Q=spi_inst_shift_in[24] CLK=CTS_41
+ D=n_6469 RESETB=n_152 SETB=VDD VSS=VSS VDD=VDD
Xspi_inst_shift_in_reg[25] DFFQSRX1 $PINS Q=spi_inst_shift_in[25] CLK=CTS_25
+ D=n_6468 RESETB=n_152 SETB=VDD VSS=VSS VDD=VDD
Xspi_inst_shift_in_reg[26] DFFQSRX1 $PINS Q=spi_inst_shift_in[26] CLK=CTS_26
+ D=n_6467 RESETB=n_152 SETB=VDD VSS=VSS VDD=VDD
Xspi_inst_shift_in_reg[27] DFFQSRX1 $PINS Q=spi_inst_shift_in[27] CLK=CTS_8
+ D=n_6466 RESETB=n_152 SETB=VDD VSS=VSS VDD=VDD
Xspi_inst_shift_in_reg[28] DFFQSRX1 $PINS Q=spi_inst_shift_in[28] CLK=CTS_13
+ D=n_6465 RESETB=n_152 SETB=VDD VSS=VSS VDD=VDD
Xspi_inst_shift_in_reg[29] DFFQSRX1 $PINS Q=spi_inst_shift_in[29] CLK=CTS_14
+ D=n_6464 RESETB=n_152 SETB=VDD VSS=VSS VDD=VDD
Xspi_inst_shift_in_reg[30] DFFQSRX1 $PINS Q=spi_inst_shift_in[30] CLK=CTS_14
+ D=n_6526 RESETB=n_152 SETB=VDD VSS=VSS VDD=VDD
Xspi_inst_shift_in_reg[31] DFFQSRX1 $PINS Q=spi_inst_shift_in[31] CLK=CTS_8
+ D=n_6463 RESETB=n_152 SETB=VDD VSS=VSS VDD=VDD
Xspi_inst_shift_in_reg[32] DFFQSRX1 $PINS Q=spi_inst_shift_in[32] CLK=CTS_8
+ D=n_6462 RESETB=n_152 SETB=VDD VSS=VSS VDD=VDD
Xspi_inst_shift_in_reg[33] DFFQSRX1 $PINS Q=spi_inst_shift_in[33] CLK=CTS_8
+ D=n_6461 RESETB=n_152 SETB=VDD VSS=VSS VDD=VDD
Xspi_inst_shift_in_reg[34] DFFQSRX1 $PINS Q=spi_inst_shift_in[34] CLK=CTS_13
+ D=n_6460 RESETB=n_152 SETB=VDD VSS=VSS VDD=VDD
Xspi_inst_shift_in_reg[35] DFFQSRX1 $PINS Q=spi_inst_shift_in[35] CLK=CTS_13
+ D=n_6459 RESETB=n_152 SETB=VDD VSS=VSS VDD=VDD
Xspi_inst_shift_in_reg[36] DFFQSRX1 $PINS Q=spi_inst_shift_in[36] CLK=CTS_14
+ D=n_6458 RESETB=n_152 SETB=VDD VSS=VSS VDD=VDD
Xspi_inst_shift_in_reg[37] DFFQSRX1 $PINS Q=spi_inst_shift_in[37] CLK=CTS_14
+ D=n_6457 RESETB=n_152 SETB=VDD VSS=VSS VDD=VDD
Xspi_inst_shift_in_reg[38] DFFQSRX1 $PINS Q=spi_inst_shift_in[38] CLK=CTS_13
+ D=n_6456 RESETB=n_152 SETB=VDD VSS=VSS VDD=VDD
Xspi_inst_shift_in_reg[39] DFFQSRX1 $PINS Q=spi_inst_shift_in[39] CLK=CTS_37
+ D=n_6455 RESETB=n_152 SETB=VDD VSS=VSS VDD=VDD
Xspi_inst_shift_in_reg[40] DFFQSRX1 $PINS Q=spi_inst_shift_in[40] CLK=CTS_44
+ D=n_6453 RESETB=n_152 SETB=VDD VSS=VSS VDD=VDD
Xspi_inst_shift_in_reg[41] DFFQSRX1 $PINS Q=spi_inst_shift_in[41] CLK=CTS_19
+ D=n_6452 RESETB=n_152 SETB=VDD VSS=VSS VDD=VDD
Xspi_inst_shift_in_reg[42] DFFQSRX1 $PINS Q=spi_inst_shift_in[42] CLK=CTS_2
+ D=n_6451 RESETB=n_152 SETB=VDD VSS=VSS VDD=VDD
Xspi_inst_shift_in_reg[43] DFFQSRX1 $PINS Q=spi_inst_shift_in[43] CLK=CTS_2
+ D=n_6450 RESETB=n_152 SETB=VDD VSS=VSS VDD=VDD
Xspi_inst_shift_in_reg[44] DFFQSRX1 $PINS Q=spi_inst_shift_in[44] CLK=CTS_7
+ D=n_6449 RESETB=n_152 SETB=VDD VSS=VSS VDD=VDD
Xspi_inst_shift_in_reg[45] DFFQSRX1 $PINS Q=spi_inst_shift_in[45] CLK=CTS_6
+ D=n_6448 RESETB=n_152 SETB=VDD VSS=VSS VDD=VDD
Xspi_inst_shift_in_reg[46] DFFQSRX1 $PINS Q=spi_inst_shift_in[46] CLK=CTS_6
+ D=n_6447 RESETB=n_152 SETB=VDD VSS=VSS VDD=VDD
Xspi_inst_shift_in_reg[47] DFFQSRX1 $PINS Q=spi_inst_shift_in[47] CLK=CTS_1
+ D=n_6446 RESETB=n_152 SETB=VDD VSS=VSS VDD=VDD
Xspi_inst_shift_in_reg[48] DFFQSRX1 $PINS Q=spi_inst_shift_in[48] CLK=CTS_45
+ D=n_6445 RESETB=n_152 SETB=VDD VSS=VSS VDD=VDD
Xspi_inst_shift_in_reg[49] DFFQSRX1 $PINS Q=spi_inst_shift_in[49] CLK=CTS_44
+ D=n_6444 RESETB=n_152 SETB=VDD VSS=VSS VDD=VDD
Xspi_inst_shift_in_reg[50] DFFQSRX1 $PINS Q=spi_inst_shift_in[50] CLK=CTS_41
+ D=n_6443 RESETB=n_152 SETB=VDD VSS=VSS VDD=VDD
Xspi_inst_shift_in_reg[51] DFFQSRX1 $PINS Q=spi_inst_shift_in[51] CLK=CTS_25
+ D=n_6442 RESETB=n_152 SETB=VDD VSS=VSS VDD=VDD
Xspi_inst_shift_in_reg[52] DFFQSRX1 $PINS Q=spi_inst_shift_in[52] CLK=CTS_42
+ D=n_6441 RESETB=n_152 SETB=VDD VSS=VSS VDD=VDD
Xspi_inst_shift_in_reg[53] DFFQSRX1 $PINS Q=spi_inst_shift_in[53] CLK=CTS_37
+ D=n_6350 RESETB=n_152 SETB=VDD VSS=VSS VDD=VDD
Xspi_inst_shift_in_reg[54] DFFQSRX1 $PINS Q=spi_inst_shift_in[54] CLK=CTS_37
+ D=n_6440 RESETB=n_152 SETB=VDD VSS=VSS VDD=VDD
Xspi_inst_shift_in_reg[55] DFFQSRX1 $PINS Q=spi_inst_shift_in[55] CLK=CTS_42
+ D=n_6362 RESETB=n_152 SETB=VDD VSS=VSS VDD=VDD
Xspi_inst_shift_in_reg[56] DFFQSRX1 $PINS Q=spi_inst_shift_in[56] CLK=CTS_41
+ D=n_6375 RESETB=n_152 SETB=VDD VSS=VSS VDD=VDD
Xspi_inst_shift_in_reg[57] DFFQSRX1 $PINS Q=spi_inst_shift_in[57] CLK=CTS_44
+ D=n_6439 RESETB=n_152 SETB=VDD VSS=VSS VDD=VDD
Xspi_inst_shift_in_reg[58] DFFQSRX1 $PINS Q=spi_inst_shift_in[58] CLK=CTS_19
+ D=n_6437 RESETB=n_152 SETB=VDD VSS=VSS VDD=VDD
Xspi_inst_shift_in_reg[59] DFFQSRX1 $PINS Q=spi_inst_shift_in[59] CLK=CTS_7
+ D=n_6436 RESETB=n_152 SETB=VDD VSS=VSS VDD=VDD
Xspi_inst_shift_in_reg[60] DFFQSRX1 $PINS Q=spi_inst_shift_in[60] CLK=CTS_7
+ D=n_6435 RESETB=n_152 SETB=VDD VSS=VSS VDD=VDD
Xspi_inst_shift_in_reg[61] DFFQSRX1 $PINS Q=spi_inst_shift_in[61] CLK=CTS_7
+ D=n_6434 RESETB=n_152 SETB=VDD VSS=VSS VDD=VDD
Xspi_inst_shift_in_reg[62] DFFQSRX1 $PINS Q=spi_inst_shift_in[62] CLK=CTS_7
+ D=n_6432 RESETB=n_152 SETB=VDD VSS=VSS VDD=VDD
Xspi_inst_shift_in_reg[63] DFFQSRX1 $PINS Q=spi_inst_shift_in[63] CLK=CTS_7
+ D=n_6431 RESETB=n_152 SETB=VDD VSS=VSS VDD=VDD
Xspi_inst_shift_out_reg[0] DFFQSRX1 $PINS Q=spi_inst_shift_out[0] CLK=CTS_43
+ D=n_6676 RESETB=n_152 SETB=VDD VSS=VSS VDD=VDD
Xspi_inst_shift_out_reg[1] DFFQSRX1 $PINS Q=spi_inst_shift_out[1] CLK=CTS_43
+ D=n_6650 RESETB=n_152 SETB=VDD VSS=VSS VDD=VDD
Xspi_inst_shift_out_reg[2] DFFQSRX1 $PINS Q=spi_inst_shift_out[2] CLK=CTS_50
+ D=n_6649 RESETB=n_152 SETB=VDD VSS=VSS VDD=VDD
Xspi_inst_shift_out_reg[3] DFFQSRX1 $PINS Q=spi_inst_shift_out[3] CLK=CTS_54
+ D=n_6648 RESETB=n_152 SETB=VDD VSS=VSS VDD=VDD
Xspi_inst_shift_out_reg[4] DFFQSRX1 $PINS Q=spi_inst_shift_out[4] CLK=CTS_35
+ D=n_6647 RESETB=n_152 SETB=VDD VSS=VSS VDD=VDD
Xspi_inst_shift_out_reg[5] DFFQSRX1 $PINS Q=spi_inst_shift_out[5] CLK=CTS_36
+ D=n_6646 RESETB=n_152 SETB=VDD VSS=VSS VDD=VDD
Xspi_inst_shift_out_reg[6] DFFQSRX1 $PINS Q=spi_inst_shift_out[6] CLK=CTS_31
+ D=n_6645 RESETB=n_152 SETB=VDD VSS=VSS VDD=VDD
Xspi_inst_shift_out_reg[7] DFFQSRX1 $PINS Q=spi_inst_shift_out[7] CLK=CTS_28
+ D=n_6644 RESETB=n_152 SETB=VDD VSS=VSS VDD=VDD
Xspi_inst_shift_out_reg[8] DFFQSRX1 $PINS Q=spi_inst_shift_out[8] CLK=CTS_28
+ D=n_6643 RESETB=n_152 SETB=VDD VSS=VSS VDD=VDD
Xspi_inst_shift_out_reg[9] DFFQSRX1 $PINS Q=spi_inst_shift_out[9] CLK=CTS_28
+ D=n_6642 RESETB=n_152 SETB=VDD VSS=VSS VDD=VDD
Xspi_inst_shift_out_reg[10] DFFQSRX1 $PINS Q=spi_inst_shift_out[10] CLK=CTS_24
+ D=n_6641 RESETB=n_152 SETB=VDD VSS=VSS VDD=VDD
Xspi_inst_shift_out_reg[11] DFFQSRX1 $PINS Q=spi_inst_shift_out[11] CLK=CTS_24
+ D=n_6640 RESETB=n_152 SETB=VDD VSS=VSS VDD=VDD
Xspi_inst_shift_out_reg[12] DFFQSRX1 $PINS Q=spi_inst_shift_out[12] CLK=CTS_28
+ D=n_6639 RESETB=n_152 SETB=VDD VSS=VSS VDD=VDD
Xspi_inst_shift_out_reg[13] DFFQSRX1 $PINS Q=spi_inst_shift_out[13] CLK=CTS_28
+ D=n_6638 RESETB=n_152 SETB=VDD VSS=VSS VDD=VDD
Xspi_inst_shift_out_reg[14] DFFQSRX1 $PINS Q=spi_inst_shift_out[14] CLK=CTS_32
+ D=n_6637 RESETB=n_152 SETB=VDD VSS=VSS VDD=VDD
Xspi_inst_shift_out_reg[15] DFFQSRX1 $PINS Q=spi_inst_shift_out[15] CLK=CTS_36
+ D=n_6635 RESETB=n_152 SETB=VDD VSS=VSS VDD=VDD
Xspi_inst_shift_out_reg[16] DFFQSRX1 $PINS Q=spi_inst_shift_out[16] CLK=CTS_35
+ D=n_6634 RESETB=n_152 SETB=VDD VSS=VSS VDD=VDD
Xspi_inst_shift_out_reg[17] DFFQSRX1 $PINS Q=spi_inst_shift_out[17] CLK=CTS_54
+ D=n_6633 RESETB=n_152 SETB=VDD VSS=VSS VDD=VDD
Xspi_inst_shift_out_reg[18] DFFQSRX1 $PINS Q=spi_inst_shift_out[18] CLK=CTS_50
+ D=n_6632 RESETB=n_152 SETB=VDD VSS=VSS VDD=VDD
Xspi_inst_shift_out_reg[19] DFFQSRX1 $PINS Q=spi_inst_shift_out[19] CLK=CTS_50
+ D=n_6631 RESETB=n_152 SETB=VDD VSS=VSS VDD=VDD
Xspi_inst_shift_out_reg[20] DFFQSRX1 $PINS Q=spi_inst_shift_out[20] CLK=CTS_43
+ D=n_6630 RESETB=n_152 SETB=VDD VSS=VSS VDD=VDD
Xspi_inst_shift_out_reg[21] DFFQSRX1 $PINS Q=spi_inst_shift_out[21] CLK=CTS_43
+ D=n_6629 RESETB=n_152 SETB=VDD VSS=VSS VDD=VDD
Xspi_inst_shift_out_reg[22] DFFQSRX1 $PINS Q=spi_inst_shift_out[22] CLK=CTS_50
+ D=n_6628 RESETB=n_152 SETB=VDD VSS=VSS VDD=VDD
Xspi_inst_shift_out_reg[23] DFFQSRX1 $PINS Q=spi_inst_shift_out[23] CLK=CTS_50
+ D=n_6627 RESETB=n_152 SETB=VDD VSS=VSS VDD=VDD
Xspi_inst_shift_out_reg[24] DFFQSRX1 $PINS Q=spi_inst_shift_out[24] CLK=CTS_35
+ D=n_6626 RESETB=n_152 SETB=VDD VSS=VSS VDD=VDD
Xspi_inst_shift_out_reg[25] DFFQSRX1 $PINS Q=spi_inst_shift_out[25] CLK=CTS_35
+ D=n_6625 RESETB=n_152 SETB=VDD VSS=VSS VDD=VDD
Xspi_inst_shift_out_reg[26] DFFQSRX1 $PINS Q=spi_inst_shift_out[26] CLK=CTS_36
+ D=n_6624 RESETB=n_152 SETB=VDD VSS=VSS VDD=VDD
Xspi_inst_shift_out_reg[27] DFFQSRX1 $PINS Q=spi_inst_shift_out[27] CLK=CTS_32
+ D=n_6623 RESETB=n_152 SETB=VDD VSS=VSS VDD=VDD
Xspi_inst_shift_out_reg[28] DFFQSRX1 $PINS Q=spi_inst_shift_out[28] CLK=CTS_28
+ D=n_6622 RESETB=n_152 SETB=VDD VSS=VSS VDD=VDD
Xspi_inst_shift_out_reg[29] DFFQSRX1 $PINS Q=spi_inst_shift_out[29] CLK=CTS_28
+ D=n_6621 RESETB=n_152 SETB=VDD VSS=VSS VDD=VDD
Xspi_inst_shift_out_reg[30] DFFQSRX1 $PINS Q=spi_inst_shift_out[30] CLK=CTS_32
+ D=n_6620 RESETB=n_152 SETB=VDD VSS=VSS VDD=VDD
Xspi_inst_shift_out_reg[31] DFFQSRX1 $PINS Q=spi_inst_shift_out[31] CLK=CTS_32
+ D=n_6589 RESETB=n_152 SETB=VDD VSS=VSS VDD=VDD
Xspi_inst_shift_out_reg[32] DFFQSRX1 $PINS Q=spi_inst_shift_out[32] CLK=CTS_32
+ D=n_6619 RESETB=n_152 SETB=VDD VSS=VSS VDD=VDD
Xspi_inst_shift_out_reg[33] DFFQSRX1 $PINS Q=spi_inst_shift_out[33] CLK=CTS_32
+ D=n_6618 RESETB=n_152 SETB=VDD VSS=VSS VDD=VDD
Xspi_inst_shift_out_reg[34] DFFQSRX1 $PINS Q=spi_inst_shift_out[34] CLK=CTS_32
+ D=n_6617 RESETB=n_152 SETB=VDD VSS=VSS VDD=VDD
Xspi_inst_shift_out_reg[35] DFFQSRX1 $PINS Q=spi_inst_shift_out[35] CLK=CTS_32
+ D=n_6616 RESETB=n_152 SETB=VDD VSS=VSS VDD=VDD
Xspi_inst_shift_out_reg[36] DFFQSRX1 $PINS Q=spi_inst_shift_out[36] CLK=CTS_32
+ D=n_6615 RESETB=n_152 SETB=VDD VSS=VSS VDD=VDD
Xspi_inst_shift_out_reg[37] DFFQSRX1 $PINS Q=spi_inst_shift_out[37] CLK=CTS_32
+ D=n_6614 RESETB=n_152 SETB=VDD VSS=VSS VDD=VDD
Xspi_inst_shift_out_reg[38] DFFQSRX1 $PINS Q=spi_inst_shift_out[38] CLK=CTS_36
+ D=n_6613 RESETB=n_152 SETB=VDD VSS=VSS VDD=VDD
Xspi_inst_shift_out_reg[39] DFFQSRX1 $PINS Q=spi_inst_shift_out[39] CLK=CTS_35
+ D=n_6611 RESETB=n_152 SETB=VDD VSS=VSS VDD=VDD
Xspi_inst_shift_out_reg[40] DFFQSRX1 $PINS Q=spi_inst_shift_out[40] CLK=CTS_53
+ D=n_6610 RESETB=n_152 SETB=VDD VSS=VSS VDD=VDD
Xspi_inst_shift_out_reg[41] DFFQSRX1 $PINS Q=spi_inst_shift_out[41] CLK=CTS_50
+ D=n_6609 RESETB=n_152 SETB=VDD VSS=VSS VDD=VDD
Xspi_inst_shift_out_reg[42] DFFQSRX1 $PINS Q=spi_inst_shift_out[42] CLK=CTS_50
+ D=n_6608 RESETB=n_152 SETB=VDD VSS=VSS VDD=VDD
Xspi_inst_shift_out_reg[43] DFFQSRX1 $PINS Q=spi_inst_shift_out[43] CLK=CTS_43
+ D=n_6607 RESETB=n_152 SETB=VDD VSS=VSS VDD=VDD
Xspi_inst_shift_out_reg[44] DFFQSRX1 $PINS Q=spi_inst_shift_out[44] CLK=CTS_43
+ D=n_6606 RESETB=n_152 SETB=VDD VSS=VSS VDD=VDD
Xspi_inst_shift_out_reg[45] DFFQSRX1 $PINS Q=spi_inst_shift_out[45] CLK=CTS_43
+ D=n_6586 RESETB=n_152 SETB=VDD VSS=VSS VDD=VDD
Xspi_inst_shift_out_reg[46] DFFQSRX1 $PINS Q=spi_inst_shift_out[46] CLK=CTS_43
+ D=n_6605 RESETB=n_152 SETB=VDD VSS=VSS VDD=VDD
Xspi_inst_shift_out_reg[47] DFFQSRX1 $PINS Q=spi_inst_shift_out[47] CLK=CTS_50
+ D=n_6604 RESETB=n_152 SETB=VDD VSS=VSS VDD=VDD
Xspi_inst_shift_out_reg[48] DFFQSRX1 $PINS Q=spi_inst_shift_out[48] CLK=CTS_53
+ D=n_6603 RESETB=n_152 SETB=VDD VSS=VSS VDD=VDD
Xspi_inst_shift_out_reg[49] DFFQSRX1 $PINS Q=spi_inst_shift_out[49] CLK=CTS_53
+ D=n_6602 RESETB=n_152 SETB=VDD VSS=VSS VDD=VDD
Xspi_inst_shift_out_reg[50] DFFQSRX1 $PINS Q=spi_inst_shift_out[50] CLK=CTS_54
+ D=n_6601 RESETB=n_152 SETB=VDD VSS=VSS VDD=VDD
Xspi_inst_shift_out_reg[51] DFFQSRX1 $PINS Q=spi_inst_shift_out[51] CLK=CTS_35
+ D=n_6600 RESETB=n_152 SETB=VDD VSS=VSS VDD=VDD
Xspi_inst_shift_out_reg[52] DFFQSRX1 $PINS Q=spi_inst_shift_out[52] CLK=CTS_36
+ D=n_6599 RESETB=n_152 SETB=VDD VSS=VSS VDD=VDD
Xspi_inst_shift_out_reg[53] DFFQSRX1 $PINS Q=spi_inst_shift_out[53] CLK=CTS_36
+ D=n_6587 RESETB=n_152 SETB=VDD VSS=VSS VDD=VDD
Xspi_inst_shift_out_reg[54] DFFQSRX1 $PINS Q=spi_inst_shift_out[54] CLK=CTS_35
+ D=n_6591 RESETB=n_152 SETB=VDD VSS=VSS VDD=VDD
Xspi_inst_shift_out_reg[55] DFFQSRX1 $PINS Q=spi_inst_shift_out[55] CLK=CTS_35
+ D=n_6590 RESETB=n_152 SETB=VDD VSS=VSS VDD=VDD
Xspi_inst_shift_out_reg[56] DFFQSRX1 $PINS Q=spi_inst_shift_out[56] CLK=CTS_54
+ D=n_6654 RESETB=n_152 SETB=VDD VSS=VSS VDD=VDD
Xspi_inst_shift_out_reg[57] DFFQSRX1 $PINS Q=spi_inst_shift_out[57] CLK=CTS_53
+ D=n_6597 RESETB=n_152 SETB=VDD VSS=VSS VDD=VDD
Xspi_inst_shift_out_reg[58] DFFQSRX1 $PINS Q=spi_inst_shift_out[58] CLK=CTS_50
+ D=n_6598 RESETB=n_152 SETB=VDD VSS=VSS VDD=VDD
Xspi_inst_shift_out_reg[59] DFFQSRX1 $PINS Q=spi_inst_shift_out[59] CLK=CTS_43
+ D=n_6588 RESETB=n_152 SETB=VDD VSS=VSS VDD=VDD
Xspi_inst_shift_out_reg[60] DFFQSRX1 $PINS Q=spi_inst_shift_out[60] CLK=CTS_48
+ D=n_6651 RESETB=n_152 SETB=VDD VSS=VSS VDD=VDD
Xspi_inst_shift_out_reg[61] DFFQSRX1 $PINS Q=spi_inst_shift_out[61] CLK=CTS_48
+ D=n_6596 RESETB=n_152 SETB=VDD VSS=VSS VDD=VDD
Xspi_inst_shift_out_reg[62] DFFQSRX1 $PINS Q=spi_inst_shift_out[62] CLK=CTS_43
+ D=n_6595 RESETB=n_152 SETB=VDD VSS=VSS VDD=VDD
Xspi_tx_data_reg[0] DFFQSRX1 $PINS Q=spi_tx_data[0] CLK=CTS_48 D=n_6841
+ RESETB=n_152 SETB=VDD VSS=VSS VDD=VDD
Xspi_tx_data_reg[1] DFFQSRX1 $PINS Q=spi_tx_data[1] CLK=CTS_48 D=n_6812
+ RESETB=n_152 SETB=VDD VSS=VSS VDD=VDD
Xspi_tx_data_reg[2] DFFQSRX1 $PINS Q=spi_tx_data[2] CLK=CTS_53 D=n_6811
+ RESETB=n_152 SETB=VDD VSS=VSS VDD=VDD
Xspi_tx_data_reg[3] DFFQSRX1 $PINS Q=spi_tx_data[3] CLK=CTS_53 D=n_6810
+ RESETB=n_152 SETB=VDD VSS=VSS VDD=VDD
Xspi_tx_data_reg[4] DFFQSRX1 $PINS Q=spi_tx_data[4] CLK=CTS_35 D=n_6809
+ RESETB=n_152 SETB=VDD VSS=VSS VDD=VDD
Xspi_tx_data_reg[5] DFFQSRX1 $PINS Q=spi_tx_data[5] CLK=CTS_36 D=n_6808
+ RESETB=n_152 SETB=VDD VSS=VSS VDD=VDD
Xspi_tx_data_reg[6] DFFQSRX1 $PINS Q=spi_tx_data[6] CLK=CTS_28 D=n_6807
+ RESETB=n_152 SETB=VDD VSS=VSS VDD=VDD
Xspi_tx_data_reg[7] DFFQSRX1 $PINS Q=spi_tx_data[7] CLK=CTS_24 D=n_6806
+ RESETB=n_152 SETB=VDD VSS=VSS VDD=VDD
Xspi_tx_data_reg[8] DFFQSRX1 $PINS Q=spi_tx_data[8] CLK=CTS_24 D=n_6840
+ RESETB=n_152 SETB=VDD VSS=VSS VDD=VDD
Xspi_tx_data_reg[9] DFFQSRX1 $PINS Q=spi_tx_data[9] CLK=CTS_24 D=n_6804
+ RESETB=n_152 SETB=VDD VSS=VSS VDD=VDD
Xspi_tx_data_reg[10] DFFQSRX1 $PINS Q=spi_tx_data[10] CLK=CTS_24 D=n_6803
+ RESETB=n_152 SETB=VDD VSS=VSS VDD=VDD
Xspi_tx_data_reg[11] DFFQSRX1 $PINS Q=spi_tx_data[11] CLK=CTS_24 D=n_6802
+ RESETB=n_152 SETB=VDD VSS=VSS VDD=VDD
Xspi_tx_data_reg[12] DFFQSRX1 $PINS Q=spi_tx_data[12] CLK=CTS_24 D=n_6801
+ RESETB=n_152 SETB=VDD VSS=VSS VDD=VDD
Xspi_tx_data_reg[13] DFFQSRX1 $PINS Q=spi_tx_data[13] CLK=CTS_24 D=n_6800
+ RESETB=n_152 SETB=VDD VSS=VSS VDD=VDD
Xspi_tx_data_reg[14] DFFQSRX1 $PINS Q=spi_tx_data[14] CLK=CTS_31 D=n_6799
+ RESETB=n_152 SETB=VDD VSS=VSS VDD=VDD
Xspi_tx_data_reg[15] DFFQSRX1 $PINS Q=spi_tx_data[15] CLK=CTS_32 D=n_6798
+ RESETB=n_152 SETB=VDD VSS=VSS VDD=VDD
Xspi_tx_data_reg[16] DFFQSRX1 $PINS Q=spi_tx_data[16] CLK=CTS_54 D=n_6797
+ RESETB=n_152 SETB=VDD VSS=VSS VDD=VDD
Xspi_tx_data_reg[17] DFFQSRX1 $PINS Q=spi_tx_data[17] CLK=CTS_54 D=n_6796
+ RESETB=n_152 SETB=VDD VSS=VSS VDD=VDD
Xspi_tx_data_reg[18] DFFQSRX1 $PINS Q=spi_tx_data[18] CLK=CTS_50 D=n_6795
+ RESETB=n_152 SETB=VDD VSS=VSS VDD=VDD
Xspi_tx_data_reg[19] DFFQSRX1 $PINS Q=spi_tx_data[19] CLK=CTS_49 D=n_6794
+ RESETB=n_152 SETB=VDD VSS=VSS VDD=VDD
Xspi_tx_data_reg[20] DFFQSRX1 $PINS Q=spi_tx_data[20] CLK=CTS_49 D=n_6793
+ RESETB=n_152 SETB=VDD VSS=VSS VDD=VDD
Xspi_tx_data_reg[21] DFFQSRX1 $PINS Q=spi_tx_data[21] CLK=CTS_43 D=n_6843
+ RESETB=n_152 SETB=VDD VSS=VSS VDD=VDD
Xspi_tx_data_reg[22] DFFQSRX1 $PINS Q=spi_tx_data[22] CLK=CTS_49 D=n_6791
+ RESETB=n_152 SETB=VDD VSS=VSS VDD=VDD
Xspi_tx_data_reg[23] DFFQSRX1 $PINS Q=spi_tx_data[23] CLK=CTS_50 D=n_6790
+ RESETB=n_152 SETB=VDD VSS=VSS VDD=VDD
Xspi_tx_data_reg[24] DFFQSRX1 $PINS Q=spi_tx_data[24] CLK=CTS_54 D=n_6789
+ RESETB=n_152 SETB=VDD VSS=VSS VDD=VDD
Xspi_tx_data_reg[25] DFFQSRX1 $PINS Q=spi_tx_data[25] CLK=CTS_36 D=n_6788
+ RESETB=n_152 SETB=VDD VSS=VSS VDD=VDD
Xspi_tx_data_reg[26] DFFQSRX1 $PINS Q=spi_tx_data[26] CLK=CTS_30 D=n_6787
+ RESETB=n_152 SETB=VDD VSS=VSS VDD=VDD
Xspi_tx_data_reg[27] DFFQSRX1 $PINS Q=spi_tx_data[27] CLK=CTS_28 D=n_6786
+ RESETB=n_152 SETB=VDD VSS=VSS VDD=VDD
Xspi_tx_data_reg[28] DFFQSRX1 $PINS Q=spi_tx_data[28] CLK=CTS_29 D=n_6785
+ RESETB=n_152 SETB=VDD VSS=VSS VDD=VDD
Xspi_tx_data_reg[29] DFFQSRX1 $PINS Q=spi_tx_data[29] CLK=CTS_31 D=n_6784
+ RESETB=n_152 SETB=VDD VSS=VSS VDD=VDD
Xspi_tx_data_reg[30] DFFQSRX1 $PINS Q=spi_tx_data[30] CLK=CTS_31 D=n_6783
+ RESETB=n_152 SETB=VDD VSS=VSS VDD=VDD
Xspi_tx_data_reg[31] DFFQSRX1 $PINS Q=spi_tx_data[31] CLK=CTS_31 D=n_6782
+ RESETB=n_152 SETB=VDD VSS=VSS VDD=VDD
Xspi_tx_data_reg[32] DFFQSRX1 $PINS Q=spi_tx_data[32] CLK=CTS_30 D=n_6781
+ RESETB=n_152 SETB=VDD VSS=VSS VDD=VDD
Xspi_tx_data_reg[33] DFFQSRX1 $PINS Q=spi_tx_data[33] CLK=CTS_32 D=n_6780
+ RESETB=n_152 SETB=VDD VSS=VSS VDD=VDD
Xspi_tx_data_reg[34] DFFQSRX1 $PINS Q=spi_tx_data[34] CLK=CTS_30 D=n_6779
+ RESETB=n_152 SETB=VDD VSS=VSS VDD=VDD
Xspi_tx_data_reg[35] DFFQSRX1 $PINS Q=spi_tx_data[35] CLK=CTS_31 D=n_6778
+ RESETB=n_152 SETB=VDD VSS=VSS VDD=VDD
Xspi_tx_data_reg[36] DFFQSRX1 $PINS Q=spi_tx_data[36] CLK=CTS_28 D=n_6777
+ RESETB=n_152 SETB=VDD VSS=VSS VDD=VDD
Xspi_tx_data_reg[37] DFFQSRX1 $PINS Q=spi_tx_data[37] CLK=CTS_28 D=n_6792
+ RESETB=n_152 SETB=VDD VSS=VSS VDD=VDD
Xspi_tx_data_reg[38] DFFQSRX1 $PINS Q=spi_tx_data[38] CLK=CTS_30 D=n_6805
+ RESETB=n_152 SETB=VDD VSS=VSS VDD=VDD
Xspi_tx_data_reg[39] DFFQSRX1 $PINS Q=spi_tx_data[39] CLK=CTS_36 D=n_6813
+ RESETB=n_152 SETB=VDD VSS=VSS VDD=VDD
Xspi_tx_data_reg[40] DFFQSRX1 $PINS Q=spi_tx_data[40] CLK=CTS_50 D=n_6839
+ RESETB=n_152 SETB=VDD VSS=VSS VDD=VDD
Xspi_tx_data_reg[41] DFFQSRX1 $PINS Q=spi_tx_data[41] CLK=CTS_53 D=n_6814
+ RESETB=n_152 SETB=VDD VSS=VSS VDD=VDD
Xspi_tx_data_reg[42] DFFQSRX1 $PINS Q=spi_tx_data[42] CLK=CTS_49 D=n_6815
+ RESETB=n_152 SETB=VDD VSS=VSS VDD=VDD
Xspi_tx_data_reg[43] DFFQSRX1 $PINS Q=spi_tx_data[43] CLK=CTS_49 D=n_6816
+ RESETB=n_152 SETB=VDD VSS=VSS VDD=VDD
Xspi_tx_data_reg[44] DFFQSRX1 $PINS Q=spi_tx_data[44] CLK=CTS_48 D=n_6818
+ RESETB=n_152 SETB=VDD VSS=VSS VDD=VDD
Xspi_tx_data_reg[45] DFFQSRX1 $PINS Q=spi_tx_data[45] CLK=CTS_48 D=n_6819
+ RESETB=n_152 SETB=VDD VSS=VSS VDD=VDD
Xspi_tx_data_reg[46] DFFQSRX1 $PINS Q=spi_tx_data[46] CLK=CTS_43 D=n_6820
+ RESETB=n_152 SETB=VDD VSS=VSS VDD=VDD
Xspi_tx_data_reg[47] DFFQSRX1 $PINS Q=spi_tx_data[47] CLK=CTS_43 D=n_6821
+ RESETB=n_152 SETB=VDD VSS=VSS VDD=VDD
Xspi_tx_data_reg[48] DFFQSRX1 $PINS Q=spi_tx_data[48] CLK=CTS_53 D=n_6822
+ RESETB=n_152 SETB=VDD VSS=VSS VDD=VDD
Xspi_tx_data_reg[49] DFFQSRX1 $PINS Q=spi_tx_data[49] CLK=CTS_54 D=n_6823
+ RESETB=n_152 SETB=VDD VSS=VSS VDD=VDD
Xspi_tx_data_reg[50] DFFQSRX1 $PINS Q=spi_tx_data[50] CLK=CTS_54 D=n_6824
+ RESETB=n_152 SETB=VDD VSS=VSS VDD=VDD
Xspi_tx_data_reg[51] DFFQSRX1 $PINS Q=spi_tx_data[51] CLK=CTS_35 D=n_6825
+ RESETB=n_152 SETB=VDD VSS=VSS VDD=VDD
Xspi_tx_data_reg[52] DFFQSRX1 $PINS Q=spi_tx_data[52] CLK=CTS_30 D=n_6826
+ RESETB=n_152 SETB=VDD VSS=VSS VDD=VDD
Xspi_tx_data_reg[53] DFFQSRX1 $PINS Q=spi_tx_data[53] CLK=CTS_36 D=n_6827
+ RESETB=n_152 SETB=VDD VSS=VSS VDD=VDD
Xspi_tx_data_reg[54] DFFQSRX1 $PINS Q=spi_tx_data[54] CLK=CTS_36 D=n_6828
+ RESETB=n_152 SETB=VDD VSS=VSS VDD=VDD
Xspi_tx_data_reg[55] DFFQSRX1 $PINS Q=spi_tx_data[55] CLK=CTS_35 D=n_6829
+ RESETB=n_152 SETB=VDD VSS=VSS VDD=VDD
Xspi_tx_data_reg[56] DFFQSRX1 $PINS Q=spi_tx_data[56] CLK=CTS_54 D=n_6830
+ RESETB=n_152 SETB=VDD VSS=VSS VDD=VDD
Xspi_tx_data_reg[57] DFFQSRX1 $PINS Q=spi_tx_data[57] CLK=CTS_53 D=n_6831
+ RESETB=n_152 SETB=VDD VSS=VSS VDD=VDD
Xspi_tx_data_reg[58] DFFQSRX1 $PINS Q=spi_tx_data[58] CLK=CTS_49 D=n_6832
+ RESETB=n_152 SETB=VDD VSS=VSS VDD=VDD
Xspi_tx_data_reg[59] DFFQSRX1 $PINS Q=spi_tx_data[59] CLK=CTS_48 D=n_6833
+ RESETB=n_152 SETB=VDD VSS=VSS VDD=VDD
Xspi_tx_data_reg[60] DFFQSRX1 $PINS Q=spi_tx_data[60] CLK=CTS_18 D=n_6834
+ RESETB=n_152 SETB=VDD VSS=VSS VDD=VDD
Xspi_tx_data_reg[61] DFFQSRX1 $PINS Q=spi_tx_data[61] CLK=CTS_48 D=n_6835
+ RESETB=n_152 SETB=VDD VSS=VSS VDD=VDD
Xspi_tx_data_reg[62] DFFQSRX1 $PINS Q=spi_tx_data[62] CLK=CTS_48 D=n_6836
+ RESETB=n_152 SETB=VDD VSS=VSS VDD=VDD
Xspi_tx_data_reg[63] DFFQSRX1 $PINS Q=spi_tx_data[63] CLK=CTS_48 D=n_6837
+ RESETB=n_152 SETB=VDD VSS=VSS VDD=VDD
Xstart_decrypt_reg DFFQSRX1 $PINS Q=start_decrypt CLK=CTS_7 D=n_6838
+ RESETB=n_152 SETB=VDD VSS=VSS VDD=VDD
Xstart_encrypt_reg DFFQSRX1 $PINS Q=start_encrypt CLK=CTS_7 D=n_6842
+ RESETB=n_152 SETB=VDD VSS=VSS VDD=VDD
Xtransaction_state_reg[0] DFFQSRX1 $PINS Q=transaction_state[0] CLK=CTS_6
+ D=n_6397 RESETB=n_152 SETB=VDD VSS=VSS VDD=VDD
Xtransaction_state_reg[1] DFFQSRX1 $PINS Q=transaction_state[1] CLK=CTS_6
+ D=n_6667 RESETB=n_152 SETB=VDD VSS=VSS VDD=VDD
Xtrigger_operation_reg DFFQSRX1 $PINS Q=trigger_operation CLK=CTS_6 D=n_6158
+ RESETB=n_152 SETB=VDD VSS=VSS VDD=VDD
Xg116644__2398 NAND3X1 $PINS Z=n_8042 A=n_8032 B=n_5383 C=n_5047 VSS=VSS
+ VDD=VDD
Xg116645__5107 NAND3X1 $PINS Z=n_8041 A=n_8036 B=n_5351 C=n_5078 VSS=VSS
+ VDD=VDD
Xg116646__6260 NAND3X1 $PINS Z=n_8040 A=n_8033 B=n_5344 C=n_5096 VSS=VSS
+ VDD=VDD
Xg116647__4319 NAND3X1 $PINS Z=n_8039 A=n_8035 B=n_5392 C=n_5081 VSS=VSS
+ VDD=VDD
Xg116655__8428 NAND3X1 $PINS Z=n_8038 A=n_8012 B=n_5391 C=n_5092 VSS=VSS
+ VDD=VDD
Xg116656__5526 NAND3X1 $PINS Z=n_8037 A=n_8001 B=n_5397 C=n_5086 VSS=VSS
+ VDD=VDD
Xg116657__6783 OR2X1 $PINS Z=n_8036 A=n_1016 B=n_7990 VSS=VSS VDD=VDD
Xg116658__3680 NAND2X1 $PINS Z=n_8035 A=n_7988 B=n_84 VSS=VSS VDD=VDD
Xg116659__1617 NAND2X1 $PINS Z=n_8034 A=n_8000 B=n_5539 VSS=VSS VDD=VDD
Xg116660__2802 NAND2X1 $PINS Z=n_8033 A=n_8002 B=n_84 VSS=VSS VDD=VDD
Xg116661__1705 NAND2X1 $PINS Z=n_8032 A=n_7989 B=n_84 VSS=VSS VDD=VDD
Xg116670__5122 NAND3X1 $PINS Z=n_8031 A=n_7987 B=n_5356 C=n_5054 VSS=VSS
+ VDD=VDD
Xg116671__8246 NAND3X1 $PINS Z=n_8030 A=n_8010 B=n_5373 C=n_5070 VSS=VSS
+ VDD=VDD
Xg116672__7098 NAND3X1 $PINS Z=n_8029 A=n_8009 B=n_5374 C=n_5071 VSS=VSS
+ VDD=VDD
Xg116673__6131 NAND3X1 $PINS Z=n_8028 A=n_8008 B=n_5370 C=n_5069 VSS=VSS
+ VDD=VDD
Xg116674__1881 NAND3X1 $PINS Z=n_8027 A=n_8014 B=n_5366 C=n_5067 VSS=VSS
+ VDD=VDD
Xg116675__5115 NAND3X1 $PINS Z=n_8026 A=n_8007 B=n_5365 C=n_5063 VSS=VSS
+ VDD=VDD
Xg116676__7482 NAND3X1 $PINS Z=n_8025 A=n_8006 B=n_5358 C=n_5055 VSS=VSS
+ VDD=VDD
Xg116677__4733 NAND3X1 $PINS Z=n_8024 A=n_8011 B=n_5400 C=n_5079 VSS=VSS
+ VDD=VDD
Xg116678__6161 NAND3X1 $PINS Z=n_8023 A=n_7999 B=n_5355 C=n_5052 VSS=VSS
+ VDD=VDD
Xg116679__9315 NAND3X1 $PINS Z=n_8022 A=n_8005 B=n_5353 C=n_5050 VSS=VSS
+ VDD=VDD
Xg116680__9945 NAND3X1 $PINS Z=n_8021 A=n_8013 B=n_5350 C=n_5048 VSS=VSS
+ VDD=VDD
Xg116681__2883 NAND3X1 $PINS Z=n_8020 A=n_8004 B=n_5346 C=n_5044 VSS=VSS
+ VDD=VDD
Xg116682__2346 NAND3X1 $PINS Z=n_8019 A=n_8003 B=n_5345 C=n_5090 VSS=VSS
+ VDD=VDD
Xg116683__1666 NAND3X1 $PINS Z=n_8018 A=n_8015 B=n_5343 C=n_5043 VSS=VSS
+ VDD=VDD
Xg116684__7410 NAND3X1 $PINS Z=n_8017 A=n_8016 B=n_5338 C=n_5095 VSS=VSS
+ VDD=VDD
Xg116685__6417 NAND2X1 $PINS Z=n_8016 A=n_7972 B=n_84 VSS=VSS VDD=VDD
Xg116686__5477 NAND2X1 $PINS Z=n_8015 A=n_7965 B=n_84 VSS=VSS VDD=VDD
Xg116687__2398 OR2X1 $PINS Z=n_8014 A=n_1016 B=n_7976 VSS=VSS VDD=VDD
Xg116688__5107 OR2X1 $PINS Z=n_8013 A=n_1016 B=n_7975 VSS=VSS VDD=VDD
Xg116689__6260 OR2X1 $PINS Z=n_8012 A=n_1016 B=n_7974 VSS=VSS VDD=VDD
Xg116690__4319 NAND2X1 $PINS Z=n_8011 A=n_7962 B=n_84 VSS=VSS VDD=VDD
Xg116691__8428 NAND2X1 $PINS Z=n_8010 A=n_7961 B=n_84 VSS=VSS VDD=VDD
Xg116692__5526 NAND2X1 $PINS Z=n_8009 A=n_7960 B=n_84 VSS=VSS VDD=VDD
Xg116693__6783 NAND2X1 $PINS Z=n_8008 A=n_7964 B=n_84 VSS=VSS VDD=VDD
Xg116694__3680 NAND2X1 $PINS Z=n_8007 A=n_7968 B=n_84 VSS=VSS VDD=VDD
Xg116695__1617 NAND2X1 $PINS Z=n_8006 A=n_7967 B=n_84 VSS=VSS VDD=VDD
Xg116696__2802 NAND2X1 $PINS Z=n_8005 A=n_7963 B=n_84 VSS=VSS VDD=VDD
Xg116697__1705 OR2X1 $PINS Z=n_8004 A=n_1016 B=n_7986 VSS=VSS VDD=VDD
Xg116698__5122 NAND2X1 $PINS Z=n_8003 A=n_7966 B=n_84 VSS=VSS VDD=VDD
Xg116701__8246 XOR2X1 $PINS Z=n_8002 A=csm_inst_left_reg[26] B=n_7954 VSS=VSS
+ VDD=VDD
Xg116702__7098 NAND2X1 $PINS Z=n_8001 A=n_7971 B=n_84 VSS=VSS VDD=VDD
Xg116703__6131 NAND2X1 $PINS Z=n_8000 A=n_7970 B=n_84 VSS=VSS VDD=VDD
Xg116704__1881 NAND2X1 $PINS Z=n_7999 A=n_7969 B=n_84 VSS=VSS VDD=VDD
Xg116705__5115 NAND3X1 $PINS Z=n_7998 A=n_7981 B=n_5401 C=n_5105 VSS=VSS
+ VDD=VDD
Xg116706__7482 NAND3X1 $PINS Z=n_7997 A=n_7980 B=n_5387 C=n_5083 VSS=VSS
+ VDD=VDD
Xg116707__4733 NAND3X1 $PINS Z=n_7996 A=n_7973 B=n_5376 C=n_5099 VSS=VSS
+ VDD=VDD
Xg116708__6161 NAND3X1 $PINS Z=n_7995 A=n_7985 B=n_5382 C=n_5082 VSS=VSS
+ VDD=VDD
Xg116709__9315 NAND3X1 $PINS Z=n_7994 A=n_7984 B=n_5375 C=n_5074 VSS=VSS
+ VDD=VDD
Xg116710__9945 NAND3X1 $PINS Z=n_7993 A=n_7979 B=n_5361 C=n_5061 VSS=VSS
+ VDD=VDD
Xg116711__2883 NAND3X1 $PINS Z=n_7992 A=n_7983 B=n_5360 C=n_5057 VSS=VSS
+ VDD=VDD
Xg116712__2346 NAND3X1 $PINS Z=n_7991 A=n_7982 B=n_5349 C=n_5046 VSS=VSS
+ VDD=VDD
Xg116713__1666 XOR2X1 $PINS Z=n_7990 A=csm_inst_left_reg[21] B=n_7952 VSS=VSS
+ VDD=VDD
Xg116714__7410 XOR2X1 $PINS Z=n_7989 A=csm_inst_left_reg[3] B=n_7955 VSS=VSS
+ VDD=VDD
Xg116715__6417 XOR2X1 $PINS Z=n_7988 A=csm_inst_left_reg[5] B=n_7953 VSS=VSS
+ VDD=VDD
Xg116716__5477 NAND2X1 $PINS Z=n_7987 A=n_7959 B=n_84 VSS=VSS VDD=VDD
Xg116717__2398 XOR2X1 $PINS Z=n_7986 A=csm_inst_left_reg[24] B=n_7936 VSS=VSS
+ VDD=VDD
Xg116718__5107 NAND2X1 $PINS Z=n_7985 A=n_7948 B=n_84 VSS=VSS VDD=VDD
Xg116719__6260 NAND2X1 $PINS Z=n_7984 A=n_7947 B=n_84 VSS=VSS VDD=VDD
Xg116720__4319 OR2X1 $PINS Z=n_7983 A=n_1016 B=n_7958 VSS=VSS VDD=VDD
Xg116721__8428 NAND2X1 $PINS Z=n_7982 A=n_7946 B=n_84 VSS=VSS VDD=VDD
Xg116722__5526 NAND2X1 $PINS Z=n_7981 A=n_7945 B=n_84 VSS=VSS VDD=VDD
Xg116723__6783 NAND2X1 $PINS Z=n_7980 A=n_7950 B=n_84 VSS=VSS VDD=VDD
Xg116724__3680 NAND2X1 $PINS Z=n_7979 A=n_7949 B=n_84 VSS=VSS VDD=VDD
Xg116725__1617 NAND3X1 $PINS Z=n_7978 A=n_7957 B=n_5399 C=n_5088 VSS=VSS
+ VDD=VDD
Xg116726__2802 NAND3X1 $PINS Z=n_7977 A=n_7956 B=n_5363 C=n_5087 VSS=VSS
+ VDD=VDD
Xg116727__1705 XOR2X1 $PINS Z=n_7976 A=csm_inst_left_reg[12] B=n_7928 VSS=VSS
+ VDD=VDD
Xg116728__5122 XOR2X1 $PINS Z=n_7975 A=csm_inst_left_reg[22] B=n_7926 VSS=VSS
+ VDD=VDD
Xg116729__8246 XOR2X1 $PINS Z=n_7974 A=csm_inst_left_reg[6] B=n_7937 VSS=VSS
+ VDD=VDD
Xg116730__7098 NAND2X1 $PINS Z=n_7973 A=n_7951 B=n_84 VSS=VSS VDD=VDD
Xg116731__6131 XOR2X1 $PINS Z=n_7972 A=csm_inst_left_reg[28] B=n_7924 VSS=VSS
+ VDD=VDD
Xg116732__1881 XOR2X1 $PINS Z=n_7971 A=csm_inst_left_reg[31] B=n_7923 VSS=VSS
+ VDD=VDD
Xg116733__5115 XOR2X1 $PINS Z=n_7970 A=csm_inst_left_reg[11] B=n_7929 VSS=VSS
+ VDD=VDD
Xg116734__7482 XOR2X1 $PINS Z=n_7969 A=csm_inst_left_reg[19] B=n_7938 VSS=VSS
+ VDD=VDD
Xg116735__4733 XOR2X1 $PINS Z=n_7968 A=csm_inst_left_reg[13] B=n_7941 VSS=VSS
+ VDD=VDD
Xg116736__6161 XOR2X1 $PINS Z=n_7967 A=csm_inst_left_reg[17] B=n_7940 VSS=VSS
+ VDD=VDD
Xg116737__9315 XOR2X1 $PINS Z=n_7966 A=csm_inst_left_reg[25] B=n_7935 VSS=VSS
+ VDD=VDD
Xg116738__9945 XOR2X1 $PINS Z=n_7965 A=csm_inst_left_reg[27] B=n_7934 VSS=VSS
+ VDD=VDD
Xg116739__2883 XOR2X1 $PINS Z=n_7964 A=csm_inst_left_reg[10] B=n_7942 VSS=VSS
+ VDD=VDD
Xg116740__2346 XOR2X1 $PINS Z=n_7963 A=csm_inst_left_reg[20] B=n_7925 VSS=VSS
+ VDD=VDD
Xg116741__1666 XOR2X1 $PINS Z=n_7962 A=csm_inst_left_reg[7] B=n_7927 VSS=VSS
+ VDD=VDD
Xg116742__7410 XOR2X1 $PINS Z=n_7961 A=csm_inst_left_reg[2] B=n_7922 VSS=VSS
+ VDD=VDD
Xg116743__6417 XOR2X1 $PINS Z=n_7960 A=csm_inst_left_reg[9] B=n_7930 VSS=VSS
+ VDD=VDD
Xg116744__5477 XOR2X1 $PINS Z=n_7959 A=csm_inst_left_reg[18] B=n_7939 VSS=VSS
+ VDD=VDD
Xg116745__2398 XOR2X1 $PINS Z=n_7958 A=csm_inst_left_reg[16] B=n_7912 VSS=VSS
+ VDD=VDD
Xg116746__5107 NAND2X1 $PINS Z=n_7957 A=n_7931 B=n_84 VSS=VSS VDD=VDD
Xg116747__6260 OR2X1 $PINS Z=n_7956 A=n_1016 B=n_7932 VSS=VSS VDD=VDD
Xg116748__4319 NAND3X1 $PINS Z=n_7955 A=n_7901 B=n_7866 C=n_7902 VSS=VSS
+ VDD=VDD
Xg116749__8428 NAND3X1 $PINS Z=n_7954 A=n_7933 B=n_7697 C=n_7634 VSS=VSS
+ VDD=VDD
Xg116750__5526 NAND3X1 $PINS Z=n_7953 A=n_7944 B=n_7863 C=n_7838 VSS=VSS
+ VDD=VDD
Xg116751__6783 NAND3X1 $PINS Z=n_7952 A=n_7943 B=n_7874 C=n_7869 VSS=VSS
+ VDD=VDD
Xg116752__3680 XOR2X1 $PINS Z=n_7951 A=csm_inst_left_reg[4] B=n_7895 VSS=VSS
+ VDD=VDD
Xg116753__1617 XOR2X1 $PINS Z=n_7950 A=csm_inst_left_reg[1] B=n_7908 VSS=VSS
+ VDD=VDD
Xg116754__2802 XOR2X1 $PINS Z=n_7949 A=csm_inst_left_reg[15] B=n_7913 VSS=VSS
+ VDD=VDD
Xg116755__1705 XOR2X1 $PINS Z=n_7948 A=csm_inst_left_reg[0] B=n_7909 VSS=VSS
+ VDD=VDD
Xg116756__5122 XOR2X1 $PINS Z=n_7947 A=csm_inst_left_reg[8] B=n_7911 VSS=VSS
+ VDD=VDD
Xg116757__8246 XOR2X1 $PINS Z=n_7946 A=csm_inst_left_reg[23] B=n_7910 VSS=VSS
+ VDD=VDD
Xg116758__7098 XOR2X1 $PINS Z=n_7945 A=csm_inst_left_reg[29] B=n_7894 VSS=VSS
+ VDD=VDD
Xg116759__6131 NOR2X1 $PINS Z=n_7944 A=n_7778 B=n_7898 VSS=VSS VDD=VDD
Xg116760__1881 NAND2X1 $PINS Z=n_7943 A=n_7918 B=n_6901 VSS=VSS VDD=VDD
Xg116761__5115 NAND3X1 $PINS Z=n_7942 A=n_7916 B=n_7853 C=n_7771 VSS=VSS
+ VDD=VDD
Xg116762__7482 NOR2X1 $PINS Z=n_7941 A=n_7917 B=n_7870 VSS=VSS VDD=VDD
Xg116763__4733 NOR2X1 $PINS Z=n_7940 A=n_7903 B=n_7868 VSS=VSS VDD=VDD
Xg116764__6161 NAND3X1 $PINS Z=n_7939 A=n_7880 B=n_7877 C=n_7823 VSS=VSS
+ VDD=VDD
Xg116765__9315 NOR2X1 $PINS Z=n_7938 A=n_7876 B=n_7896 VSS=VSS VDD=VDD
Xg116766__9945 NOR2X1 $PINS Z=n_7937 A=n_7857 B=n_7897 VSS=VSS VDD=VDD
Xg116767__2883 NOR2X1 $PINS Z=n_7936 A=n_7845 B=n_7921 VSS=VSS VDD=VDD
Xg116768__2346 NOR2X1 $PINS Z=n_7935 A=n_7844 B=n_7907 VSS=VSS VDD=VDD
Xg116769__1666 NOR2X1 $PINS Z=n_7934 A=n_7851 B=n_7919 VSS=VSS VDD=VDD
Xg116770__7410 NOR2X1 $PINS Z=n_7933 A=n_7900 B=n_7809 VSS=VSS VDD=VDD
Xg116771__6417 XOR2X1 $PINS Z=n_7932 A=csm_inst_left_reg[14] B=n_7843 VSS=VSS
+ VDD=VDD
Xg116772__5477 XOR2X1 $PINS Z=n_7931 A=csm_inst_left_reg[30] B=n_7842 VSS=VSS
+ VDD=VDD
Xg116773__2398 NAND3X1 $PINS Z=n_7930 A=n_7882 B=n_7884 C=n_7791 VSS=VSS
+ VDD=VDD
Xg116774__5107 NOR2X1 $PINS Z=n_7929 A=n_7915 B=n_7864 VSS=VSS VDD=VDD
Xg116775__6260 NAND3X1 $PINS Z=n_7928 A=n_7914 B=n_7796 C=n_7734 VSS=VSS
+ VDD=VDD
Xg116776__4319 NAND3X1 $PINS Z=n_7927 A=n_7904 B=n_7837 C=n_7801 VSS=VSS
+ VDD=VDD
Xg116777__8428 NAND3X1 $PINS Z=n_7926 A=n_7899 B=n_7819 C=n_7682 VSS=VSS
+ VDD=VDD
Xg116778__5526 NAND3X1 $PINS Z=n_7925 A=n_7920 B=n_7787 C=n_7656 VSS=VSS
+ VDD=VDD
Xg116779__6783 NAND3X1 $PINS Z=n_7924 A=n_7906 B=n_7631 C=n_7718 VSS=VSS
+ VDD=VDD
Xg116780__3680 NOR2X1 $PINS Z=n_7923 A=n_7889 B=n_7905 VSS=VSS VDD=VDD
Xg116781__1617 NAND3X1 $PINS Z=n_7922 A=n_7883 B=n_7878 C=n_7630 VSS=VSS
+ VDD=VDD
Xg116782__2802 NAND3X1 $PINS Z=n_7921 A=n_7815 B=n_7814 C=n_7705 VSS=VSS
+ VDD=VDD
Xg116783__1705 NOR2X1 $PINS Z=n_7920 A=n_7820 B=n_7848 VSS=VSS VDD=VDD
Xg116784__5122 NAND3X1 $PINS Z=n_7919 A=n_7763 B=n_7841 C=n_7632 VSS=VSS
+ VDD=VDD
Xg116785__8246 NAND2X1 $PINS Z=n_7918 A=n_7875 B=n_7439 VSS=VSS VDD=VDD
Xg116786__7098 NAND3X1 $PINS Z=n_7917 A=n_7892 B=n_7731 C=n_7730 VSS=VSS
+ VDD=VDD
Xg116787__6131 NAND2X1 $PINS Z=n_7916 A=n_7881 B=n_7003 VSS=VSS VDD=VDD
Xg116788__1881 NAND2X1 $PINS Z=n_7915 A=n_7893 B=n_7782 VSS=VSS VDD=VDD
Xg116789__5115 NOR2X1 $PINS Z=n_7914 A=n_7826 B=n_7852 VSS=VSS VDD=VDD
Xg116790__7482 NAND3X1 $PINS Z=n_7913 A=n_7770 B=n_7879 C=n_7824 VSS=VSS
+ VDD=VDD
Xg116791__4733 NOR2X1 $PINS Z=n_7912 A=n_7850 B=n_7849 VSS=VSS VDD=VDD
Xg116792__6161 NOR2X1 $PINS Z=n_7911 A=n_7867 B=n_7855 VSS=VSS VDD=VDD
Xg116793__9315 NOR2X1 $PINS Z=n_7910 A=n_7846 B=n_7847 VSS=VSS VDD=VDD
Xg116794__9945 NOR2X1 $PINS Z=n_7909 A=n_7858 B=n_7859 VSS=VSS VDD=VDD
Xg116795__2883 NAND3X1 $PINS Z=n_7908 A=n_7885 B=n_7830 C=n_7745 VSS=VSS
+ VDD=VDD
Xg116796__2346 NAND3X1 $PINS Z=n_7907 A=n_7709 B=n_7813 C=n_7663 VSS=VSS
+ VDD=VDD
Xg116797__1666 NOR2X1 $PINS Z=n_7906 A=n_7699 B=n_7861 VSS=VSS VDD=VDD
Xg116798__7410 NAND3X1 $PINS Z=n_7905 A=n_7891 B=n_7610 C=n_7661 VSS=VSS
+ VDD=VDD
Xg116799__6417 NOR2X1 $PINS Z=n_7904 A=n_7856 B=n_7805 VSS=VSS VDD=VDD
Xg116800__5477 NAND3X1 $PINS Z=n_7903 A=n_7854 B=n_7788 C=n_7616 VSS=VSS
+ VDD=VDD
Xg116801__2398 NAND2X1 $PINS Z=n_7902 A=n_7871 B=n_6884 VSS=VSS VDD=VDD
Xg116802__5107 NOR2X1 $PINS Z=n_7901 A=n_7802 B=n_7860 VSS=VSS VDD=VDD
Xg116803__6260 NAND2X1 $PINS Z=n_7900 A=n_7872 B=n_7457 VSS=VSS VDD=VDD
Xg116804__4319 NOR2X1 $PINS Z=n_7899 A=n_7818 B=n_7873 VSS=VSS VDD=VDD
Xg116805__8428 NAND3X1 $PINS Z=n_7898 A=n_7887 B=n_7831 C=n_7743 VSS=VSS
+ VDD=VDD
Xg116806__5526 NAND3X1 $PINS Z=n_7897 A=n_7886 B=n_7620 C=n_7666 VSS=VSS
+ VDD=VDD
Xg116807__6783 NAND3X1 $PINS Z=n_7896 A=n_7862 B=n_7822 C=n_7255 VSS=VSS
+ VDD=VDD
Xg116808__3680 NAND3X1 $PINS Z=n_7895 A=n_7888 B=n_7753 C=n_7481 VSS=VSS
+ VDD=VDD
Xg116809__1617 NOR2X1 $PINS Z=n_7894 A=n_7890 B=n_7865 VSS=VSS VDD=VDD
Xg116810__2802 NAND2X1 $PINS Z=n_7893 A=n_7828 B=n_6931 VSS=VSS VDD=VDD
Xg116811__1705 NAND2X1 $PINS Z=n_7892 A=n_7790 B=n_6900 VSS=VSS VDD=VDD
Xg116812__5122 NAND2X1 $PINS Z=n_7891 A=n_7781 B=n_7170 VSS=VSS VDD=VDD
Xg116813__8246 NAND3X1 $PINS Z=n_7890 A=n_7835 B=n_7750 C=n_7567 VSS=VSS
+ VDD=VDD
Xg116814__7098 NAND2X1 $PINS Z=n_7889 A=n_7761 B=n_7476 VSS=VSS VDD=VDD
Xg116815__6131 NOR2X1 $PINS Z=n_7888 A=n_7799 B=n_7779 VSS=VSS VDD=VDD
Xg116816__1881 NAND2X1 $PINS Z=n_7887 A=n_7832 B=n_6878 VSS=VSS VDD=VDD
Xg116817__5115 NOR2X1 $PINS Z=n_7886 A=n_7627 B=n_7777 VSS=VSS VDD=VDD
Xg116818__7482 NOR2X1 $PINS Z=n_7885 A=n_7775 B=n_7774 VSS=VSS VDD=VDD
Xg116819__4733 NAND2X1 $PINS Z=n_7884 A=n_7773 B=n_6869 VSS=VSS VDD=VDD
Xg116820__6161 NOR2X1 $PINS Z=n_7883 A=n_7840 B=n_7752 VSS=VSS VDD=VDD
Xg116821__9315 NOR2X1 $PINS Z=n_7882 A=n_7772 B=n_7829 VSS=VSS VDD=VDD
Xg116822__9945 NAND2X1 $PINS Z=n_7881 A=n_7804 B=n_7688 VSS=VSS VDD=VDD
Xg116823__2883 AND2X1 $PINS Z=n_7880 A=n_7793 B=n_7762 VSS=VSS VDD=VDD
Xg116824__2346 NAND2X1 $PINS Z=n_7879 A=n_7780 B=n_6869 VSS=VSS VDD=VDD
Xg116825__1666 NAND2X1 $PINS Z=n_7878 A=n_7767 B=n_6857 VSS=VSS VDD=VDD
Xg116826__7410 NOR2X1 $PINS Z=n_7877 A=n_7662 B=n_7768 VSS=VSS VDD=VDD
Xg116827__6417 OR2X1 $PINS Z=n_7876 A=n_7640 B=n_7783 VSS=VSS VDD=VDD
Xg116828__5477 NAND2X1 $PINS Z=n_7875 A=n_7766 B=n_7377 VSS=VSS VDD=VDD
Xg116829__2398 NOR2X1 $PINS Z=n_7874 A=n_7807 B=n_7765 VSS=VSS VDD=VDD
Xg116830__5107 NAND3X1 $PINS Z=n_7873 A=n_7817 B=n_7532 C=n_7624 VSS=VSS
+ VDD=VDD
Xg116831__6260 NAND2X1 $PINS Z=n_7872 A=n_7812 B=n_6899 VSS=VSS VDD=VDD
Xg116832__4319 NAND2X1 $PINS Z=n_7871 A=n_7794 B=n_7583 VSS=VSS VDD=VDD
Xg116833__8428 NAND3X1 $PINS Z=n_7870 A=n_7704 B=n_7670 C=n_7497 VSS=VSS
+ VDD=VDD
Xg116834__5526 NAND2X1 $PINS Z=n_7869 A=n_7806 B=n_6900 VSS=VSS VDD=VDD
Xg116835__6783 NAND3X1 $PINS Z=n_7868 A=n_7672 B=n_7726 C=n_7525 VSS=VSS
+ VDD=VDD
Xg116836__3680 NAND3X1 $PINS Z=n_7867 A=n_7808 B=n_8057 C=n_7738 VSS=VSS
+ VDD=VDD
Xg116837__1617 NOR2X1 $PINS Z=n_7866 A=n_7550 B=n_7792 VSS=VSS VDD=VDD
Xg116838__2802 NAND3X1 $PINS Z=n_7865 A=n_7751 B=n_7784 C=n_7760 VSS=VSS
+ VDD=VDD
Xg116839__1705 NAND3X1 $PINS Z=n_7864 A=n_7827 B=n_7667 C=n_7687 VSS=VSS
+ VDD=VDD
Xg116840__5122 NAND2X1 $PINS Z=n_7863 A=n_7785 B=n_7193 VSS=VSS VDD=VDD
Xg116841__8246 NAND2X1 $PINS Z=n_7862 A=n_7786 B=n_7019 VSS=VSS VDD=VDD
Xg116842__7098 NAND3X1 $PINS Z=n_7861 A=n_7811 B=n_7454 C=n_7553 VSS=VSS
+ VDD=VDD
Xg116843__6131 NAND3X1 $PINS Z=n_7860 A=n_7683 B=n_7393 C=n_7747 VSS=VSS
+ VDD=VDD
Xg116844__1881 NAND3X1 $PINS Z=n_7859 A=n_7833 B=n_7302 C=n_7716 VSS=VSS
+ VDD=VDD
Xg116845__5115 NAND3X1 $PINS Z=n_7858 A=n_7797 B=n_7748 C=n_7650 VSS=VSS
+ VDD=VDD
Xg116846__7482 NAND3X1 $PINS Z=n_7857 A=n_7742 B=n_7572 C=n_7701 VSS=VSS
+ VDD=VDD
Xg116847__4733 NAND3X1 $PINS Z=n_7856 A=n_7741 B=n_7702 C=n_7354 VSS=VSS
+ VDD=VDD
Xg116848__6161 NAND3X1 $PINS Z=n_7855 A=n_7739 B=n_7839 C=n_7528 VSS=VSS
+ VDD=VDD
Xg116849__9315 NAND2X1 $PINS Z=n_7854 A=n_7795 B=n_7628 VSS=VSS VDD=VDD
Xg116850__9945 NOR2X1 $PINS Z=n_7853 A=n_7707 B=n_7821 VSS=VSS VDD=VDD
Xg116851__2883 NAND3X1 $PINS Z=n_7852 A=n_7468 B=n_7836 C=n_7700 VSS=VSS
+ VDD=VDD
Xg116852__2346 NAND3X1 $PINS Z=n_7851 A=n_7703 B=n_7789 C=n_7456 VSS=VSS
+ VDD=VDD
Xg116853__1666 NAND3X1 $PINS Z=n_7850 A=n_7728 B=n_7727 C=n_7676 VSS=VSS
+ VDD=VDD
Xg116854__7410 NAND3X1 $PINS Z=n_7849 A=n_7769 B=n_7417 C=n_7480 VSS=VSS
+ VDD=VDD
Xg116855__6417 NAND3X1 $PINS Z=n_7848 A=n_7679 B=n_7659 C=n_7343 VSS=VSS
+ VDD=VDD
Xg116856__5477 NAND3X1 $PINS Z=n_7847 A=n_7800 B=n_7754 C=n_7351 VSS=VSS
+ VDD=VDD
Xg116857__2398 NAND3X1 $PINS Z=n_7846 A=n_7816 B=n_7243 C=n_7461 VSS=VSS
+ VDD=VDD
Xg116858__5107 NAND3X1 $PINS Z=n_7845 A=n_7803 B=n_7487 C=n_7269 VSS=VSS
+ VDD=VDD
Xg116859__6260 NAND3X1 $PINS Z=n_7844 A=n_7798 B=n_7574 C=n_7698 VSS=VSS
+ VDD=VDD
Xg116860__4319 NAND3X1 $PINS Z=n_7843 A=n_7825 B=n_7729 C=n_7673 VSS=VSS
+ VDD=VDD
Xg116861__8428 NAND3X1 $PINS Z=n_7842 A=n_7834 B=n_7749 C=n_7657 VSS=VSS
+ VDD=VDD
Xg116862 INVX2 $PINS Z=n_7841 A=n_7810 VSS=VSS VDD=VDD
Xg116863__5526 NAND3X1 $PINS Z=n_7840 A=n_7342 B=n_7463 C=n_7464 VSS=VSS
+ VDD=VDD
Xg116864__6783 NAND2X1 $PINS Z=n_7839 A=n_7647 B=n_6894 VSS=VSS VDD=VDD
Xg116865__3680 NAND2X1 $PINS Z=n_7838 A=n_7674 B=n_7165 VSS=VSS VDD=VDD
Xg116866__1617 NAND2X1 $PINS Z=n_7837 A=n_7648 B=n_7175 VSS=VSS VDD=VDD
Xg116867__2802 NAND2X1 $PINS Z=n_7836 A=n_7756 B=n_6890 VSS=VSS VDD=VDD
Xg116868__1705 NOR2X1 $PINS Z=n_7835 A=n_7713 B=n_7711 VSS=VSS VDD=VDD
Xg116869__5122 NOR2X1 $PINS Z=n_7834 A=n_7652 B=n_7651 VSS=VSS VDD=VDD
Xg116870__8246 NOR2X1 $PINS Z=n_7833 A=n_7607 B=n_7746 VSS=VSS VDD=VDD
Xg116871__7098 NAND2X1 $PINS Z=n_7832 A=n_7649 B=n_7438 VSS=VSS VDD=VDD
Xg116872__6131 NAND2X1 $PINS Z=n_7831 A=n_7653 B=n_6960 VSS=VSS VDD=VDD
Xg116873__1881 AND2X1 $PINS Z=n_7830 A=n_7664 B=n_7740 VSS=VSS VDD=VDD
Xg116874__5115 OR2X1 $PINS Z=n_7829 A=n_7428 B=n_7686 VSS=VSS VDD=VDD
Xg116875__7482 NAND2X1 $PINS Z=n_7828 A=n_7535 B=n_7736 VSS=VSS VDD=VDD
Xg116876__4733 NOR2X1 $PINS Z=n_7827 A=n_7735 B=n_7646 VSS=VSS VDD=VDD
Xg116877__6161 OR2X1 $PINS Z=n_7826 A=n_7576 B=n_7732 VSS=VSS VDD=VDD
Xg116878__9315 NOR2X1 $PINS Z=n_7825 A=n_7643 B=n_7644 VSS=VSS VDD=VDD
Xg116879__9945 AND2X1 $PINS Z=n_7824 A=n_7755 B=n_7684 VSS=VSS VDD=VDD
Xg116880__2883 NAND2X1 $PINS Z=n_7823 A=n_7641 B=n_7163 VSS=VSS VDD=VDD
Xg116881__2346 NAND2X1 $PINS Z=n_7822 A=n_7714 B=n_6854 VSS=VSS VDD=VDD
Xg116882__1666 NAND3X1 $PINS Z=n_7821 A=n_7571 B=n_7595 C=n_7737 VSS=VSS
+ VDD=VDD
Xg116883__7410 NOR2X1 $PINS Z=n_7820 A=n_7415 B=n_7715 VSS=VSS VDD=VDD
Xg116884__6417 NOR2X1 $PINS Z=n_7819 A=n_7396 B=n_7724 VSS=VSS VDD=VDD
Xg116885__5477 NOR2X1 $PINS Z=n_7818 A=n_6948 B=n_7723 VSS=VSS VDD=VDD
Xg116886__2398 NAND2X1 $PINS Z=n_7817 A=n_7638 B=n_6927 VSS=VSS VDD=VDD
Xg116887__5107 NAND2X1 $PINS Z=n_7816 A=n_7759 B=n_6935 VSS=VSS VDD=VDD
Xg116888__6260 NAND2X1 $PINS Z=n_7815 A=n_7721 B=n_7637 VSS=VSS VDD=VDD
Xg116889__4319 AND2X1 $PINS Z=n_7814 A=n_7706 B=n_7636 VSS=VSS VDD=VDD
Xg116890__8428 NAND2X1 $PINS Z=n_7813 A=n_7635 B=n_6849 VSS=VSS VDD=VDD
Xg116891__5526 NAND2X1 $PINS Z=n_7812 A=n_7719 B=n_7299 VSS=VSS VDD=VDD
Xg116892__6783 NAND2X1 $PINS Z=n_7811 A=n_7717 B=n_6884 VSS=VSS VDD=VDD
Xg116893__3680 NAND3X1 $PINS Z=n_7810 A=n_8055 B=n_7579 C=n_7246 VSS=VSS
+ VDD=VDD
Xg116894__1617 NAND3X1 $PINS Z=n_7809 A=n_7507 B=n_7633 C=n_7573 VSS=VSS
+ VDD=VDD
Xg116895__2802 NAND2X1 $PINS Z=n_7808 A=n_7757 B=n_7319 VSS=VSS VDD=VDD
Xg116896__1705 NOR2X1 $PINS Z=n_7807 A=n_7162 B=n_7710 VSS=VSS VDD=VDD
Xg116897__5122 NAND2X1 $PINS Z=n_7806 A=n_7508 B=n_7725 VSS=VSS VDD=VDD
Xg116898__8246 NOR2X1 $PINS Z=n_7805 A=n_6847 B=n_7708 VSS=VSS VDD=VDD
Xg116899__7098 NAND2X1 $PINS Z=n_7804 A=n_7695 B=n_6849 VSS=VSS VDD=VDD
Xg116900__6131 NOR2X1 $PINS Z=n_7803 A=n_7569 B=n_7629 VSS=VSS VDD=VDD
Xg116901__1881 NAND3X1 $PINS Z=n_7802 A=n_7712 B=n_7529 C=n_7557 VSS=VSS
+ VDD=VDD
Xg116902 INVX2 $PINS Z=n_7801 A=n_7776 VSS=VSS VDD=VDD
Xg116903 INVX2 $PINS Z=n_7800 A=n_7764 VSS=VSS VDD=VDD
Xg116904__5115 NAND3X1 $PINS Z=n_7799 A=n_7605 B=n_7482 C=n_7275 VSS=VSS
+ VDD=VDD
Xg116905__7482 NAND2X1 $PINS Z=n_7798 A=n_7720 B=n_6937 VSS=VSS VDD=VDD
Xg116906__4733 NAND3X1 $PINS Z=n_7797 A=n_7758 B=n_7151 C=n_6873 VSS=VSS
+ VDD=VDD
Xg116907__6161 NOR2X1 $PINS Z=n_7796 A=n_7733 B=n_7645 VSS=VSS VDD=VDD
Xg116908__9315 NAND2X1 $PINS Z=n_7795 A=n_7690 B=n_7365 VSS=VSS VDD=VDD
Xg116909__9945 NAND2X1 $PINS Z=n_7794 A=n_7677 B=n_6900 VSS=VSS VDD=VDD
Xg116910__2883 NAND2X1 $PINS Z=n_7793 A=n_7685 B=n_6847 VSS=VSS VDD=VDD
Xg116911__2346 NOR2X1 $PINS Z=n_7792 A=n_7028 B=n_7681 VSS=VSS VDD=VDD
Xg116912__1666 NAND2X1 $PINS Z=n_7791 A=n_7665 B=n_6935 VSS=VSS VDD=VDD
Xg116913__7410 NAND3X1 $PINS Z=n_7790 A=n_7533 B=n_7439 C=n_7285 VSS=VSS
+ VDD=VDD
Xg116914__6417 OR2X1 $PINS Z=n_7789 A=n_7438 B=n_7680 VSS=VSS VDD=VDD
Xg116915__5477 NAND2X1 $PINS Z=n_7788 A=n_7691 B=n_6974 VSS=VSS VDD=VDD
Xg116916__2398 NAND3X1 $PINS Z=n_7787 A=n_7694 B=n_6848 C=n_6875 VSS=VSS
+ VDD=VDD
Xg116917__5107 NAND2X1 $PINS Z=n_7786 A=n_7660 B=n_7033 VSS=VSS VDD=VDD
Xg116918__6260 NAND2X1 $PINS Z=n_7785 A=n_7675 B=n_7322 VSS=VSS VDD=VDD
Xg116919__4319 NAND2X1 $PINS Z=n_7784 A=n_7668 B=n_7163 VSS=VSS VDD=VDD
Xg116920__8428 NOR2X1 $PINS Z=n_7783 A=n_6999 B=n_7655 VSS=VSS VDD=VDD
Xg116921__5526 NAND3X1 $PINS Z=n_7782 A=n_7693 B=n_7235 C=n_7187 VSS=VSS
+ VDD=VDD
Xg116922__6783 NAND3X1 $PINS Z=n_7781 A=n_7228 B=n_7548 C=n_7210 VSS=VSS
+ VDD=VDD
Xg116923__3680 NAND3X1 $PINS Z=n_7780 A=n_7544 B=n_7614 C=n_7124 VSS=VSS
+ VDD=VDD
Xg116924__1617 NAND3X1 $PINS Z=n_7779 A=n_7744 B=n_7282 C=n_7226 VSS=VSS
+ VDD=VDD
Xg116925__2802 NOR2X1 $PINS Z=n_7778 A=n_7602 B=n_7692 VSS=VSS VDD=VDD
Xg116926__1705 NAND3X1 $PINS Z=n_7777 A=n_7474 B=n_7376 C=n_7600 VSS=VSS
+ VDD=VDD
Xg116927__5122 NAND3X1 $PINS Z=n_7776 A=n_7473 B=n_7398 C=n_7224 VSS=VSS
+ VDD=VDD
Xg116928__8246 NAND3X1 $PINS Z=n_7775 A=n_7671 B=n_7472 C=n_7479 VSS=VSS
+ VDD=VDD
Xg116929__7098 NAND3X1 $PINS Z=n_7774 A=n_7669 B=n_7619 C=n_7222 VSS=VSS
+ VDD=VDD
Xg116930__6131 NAND3X1 $PINS Z=n_7773 A=n_7485 B=n_7515 C=n_7038 VSS=VSS
+ VDD=VDD
Xg116931__1881 NAND3X1 $PINS Z=n_7772 A=n_7568 B=n_7263 C=n_7517 VSS=VSS
+ VDD=VDD
Xg116932__5115 NOR2X1 $PINS Z=n_7771 A=n_7622 B=n_7696 VSS=VSS VDD=VDD
Xg116933__7482 NOR2X1 $PINS Z=n_7770 A=n_7689 B=n_7642 VSS=VSS VDD=VDD
Xg116934__4733 NAND3X1 $PINS Z=n_7769 A=n_7587 B=n_7575 C=n_6909 VSS=VSS
+ VDD=VDD
Xg116935__6161 NAND3X1 $PINS Z=n_7768 A=n_7466 B=n_7543 C=n_7563 VSS=VSS
+ VDD=VDD
Xg116936__9315 NAND3X1 $PINS Z=n_7767 A=n_7564 B=n_7570 C=n_7347 VSS=VSS
+ VDD=VDD
Xg116937__9945 NAND3X1 $PINS Z=n_7766 A=n_7536 B=n_7513 C=n_7437 VSS=VSS
+ VDD=VDD
Xg116938__2883 NAND3X1 $PINS Z=n_7765 A=n_7639 B=n_7462 C=n_7262 VSS=VSS
+ VDD=VDD
Xg116939__2346 NAND3X1 $PINS Z=n_7764 A=n_7722 B=n_7483 C=n_7458 VSS=VSS
+ VDD=VDD
Xg116940__1666 NAND3X1 $PINS Z=n_7763 A=n_7654 B=n_7075 C=n_6931 VSS=VSS
+ VDD=VDD
Xg116941__7410 MUX2X1 $PINS Z=n_7762 A=n_7506 B=n_7465 S=n_7313 VSS=VSS VDD=VDD
Xg116942__6417 MUX2X1 $PINS Z=n_7761 A=n_7017 B=n_7252 S=n_7452 VSS=VSS VDD=VDD
Xg116943__5477 OR2X1 $PINS Z=n_7760 A=n_7313 B=n_7556 VSS=VSS VDD=VDD
Xg116944__2398 NAND2X1 $PINS Z=n_7759 A=n_7460 B=n_7202 VSS=VSS VDD=VDD
Xg116945__5107 NAND2X1 $PINS Z=n_7758 A=n_7307 B=n_7541 VSS=VSS VDD=VDD
Xg116946__6260 NAND2X1 $PINS Z=n_7757 A=n_7478 B=n_7129 VSS=VSS VDD=VDD
Xg116947__4319 NAND2X1 $PINS Z=n_7756 A=n_7469 B=n_7049 VSS=VSS VDD=VDD
Xg116948__8428 NAND2X1 $PINS Z=n_7755 A=n_7467 B=n_6965 VSS=VSS VDD=VDD
Xg116949__5526 NAND2X1 $PINS Z=n_7754 A=n_7477 B=n_7083 VSS=VSS VDD=VDD
Xg116950__6783 NAND2X1 $PINS Z=n_7753 A=n_7495 B=n_6957 VSS=VSS VDD=VDD
Xg116951__3680 AND2X1 $PINS Z=n_7752 A=n_7471 B=n_7093 VSS=VSS VDD=VDD
Xg116952__1617 OR2X1 $PINS Z=n_7751 A=n_7172 B=n_7577 VSS=VSS VDD=VDD
Xg116953__2802 AND2X1 $PINS Z=n_7750 A=n_7527 B=n_7233 VSS=VSS VDD=VDD
Xg116954__1705 NAND2X1 $PINS Z=n_7749 A=n_7611 B=n_6870 VSS=VSS VDD=VDD
Xg116955__5122 NAND2X1 $PINS Z=n_7748 A=n_7612 B=n_6866 VSS=VSS VDD=VDD
Xg116956__8246 NOR2X1 $PINS Z=n_7747 A=n_7551 B=n_7615 VSS=VSS VDD=VDD
Xg116957__7098 NOR2X1 $PINS Z=n_7746 A=n_7309 B=n_7606 VSS=VSS VDD=VDD
Xg116958__6131 NAND2X1 $PINS Z=n_7745 A=n_7603 B=n_7082 VSS=VSS VDD=VDD
Xg116959__1881 NAND2X1 $PINS Z=n_7744 A=n_7604 B=n_6947 VSS=VSS VDD=VDD
Xg116960__5115 NAND2X1 $PINS Z=n_7743 A=n_7601 B=n_6929 VSS=VSS VDD=VDD
Xg116961__7482 AND2X1 $PINS Z=n_7742 A=n_7475 B=n_7552 VSS=VSS VDD=VDD
Xg116962__4733 NAND2X1 $PINS Z=n_7741 A=n_7623 B=n_7182 VSS=VSS VDD=VDD
Xg116963__6161 NAND2X1 $PINS Z=n_7740 A=n_7599 B=n_6869 VSS=VSS VDD=VDD
Xg116964__9315 NAND2X1 $PINS Z=n_7739 A=n_7598 B=n_6899 VSS=VSS VDD=VDD
Xg116965__9945 NAND2X1 $PINS Z=n_7738 A=n_7537 B=n_7023 VSS=VSS VDD=VDD
Xg116966__2883 NAND3X1 $PINS Z=n_7737 A=n_7596 B=n_6848 C=n_6874 VSS=VSS
+ VDD=VDD
Xg116967__2346 NAND2X1 $PINS Z=n_7736 A=n_7594 B=n_6929 VSS=VSS VDD=VDD
Xg116968__1666 NOR2X1 $PINS Z=n_7735 A=n_6929 B=n_7593 VSS=VSS VDD=VDD
Xg116969__7410 NAND2X1 $PINS Z=n_7734 A=n_7591 B=n_7421 VSS=VSS VDD=VDD
Xg116970__6417 NOR2X1 $PINS Z=n_7733 A=n_7022 B=n_7558 VSS=VSS VDD=VDD
Xg116971__5477 NOR2X1 $PINS Z=n_7732 A=n_6882 B=n_7590 VSS=VSS VDD=VDD
Xg116972__2398 NOR2X1 $PINS Z=n_7731 A=n_7431 B=n_7565 VSS=VSS VDD=VDD
Xg116973__5107 OR2X1 $PINS Z=n_7730 A=n_7321 B=n_7589 VSS=VSS VDD=VDD
Xg116974__6260 NAND2X1 $PINS Z=n_7729 A=n_7613 B=n_6995 VSS=VSS VDD=VDD
Xg116975__4319 NAND2X1 $PINS Z=n_7728 A=n_7504 B=n_7108 VSS=VSS VDD=VDD
Xg116976__8428 NAND2X1 $PINS Z=n_7727 A=n_7618 B=n_7109 VSS=VSS VDD=VDD
Xg116977__5526 OR2X1 $PINS Z=n_7726 A=n_7085 B=n_7524 VSS=VSS VDD=VDD
Xg116978__6783 NAND2X1 $PINS Z=n_7725 A=n_7586 B=n_6884 VSS=VSS VDD=VDD
Xg116979__3680 AND2X1 $PINS Z=n_7724 A=n_7584 B=n_6948 VSS=VSS VDD=VDD
Xg116980__1617 NOR2X1 $PINS Z=n_7723 A=n_7560 B=n_7627 VSS=VSS VDD=VDD
Xg116981__2802 NAND2X1 $PINS Z=n_7722 A=n_7459 B=n_7082 VSS=VSS VDD=VDD
Xg116982__1705 NAND2X1 $PINS Z=n_7721 A=n_7486 B=n_7176 VSS=VSS VDD=VDD
Xg116983__5122 NAND2X1 $PINS Z=n_7720 A=n_7582 B=n_7450 VSS=VSS VDD=VDD
Xg116984__8246 NAND2X1 $PINS Z=n_7719 A=n_7537 B=n_6863 VSS=VSS VDD=VDD
Xg116985__7098 NAND2X1 $PINS Z=n_7718 A=n_7578 B=n_7162 VSS=VSS VDD=VDD
Xg116986__6131 NAND2X1 $PINS Z=n_7717 A=n_7391 B=n_7455 VSS=VSS VDD=VDD
Xg116987__1881 NAND2X1 $PINS Z=n_7716 A=n_7608 B=n_7020 VSS=VSS VDD=VDD
Xg116988__5115 NOR2X1 $PINS Z=n_7715 A=n_7020 B=n_7626 VSS=VSS VDD=VDD
Xg116989__7482 NAND3X1 $PINS Z=n_7714 A=n_7281 B=n_7427 C=n_7036 VSS=VSS
+ VDD=VDD
Xg116990__4733 NOR2X1 $PINS Z=n_7713 A=n_7192 B=n_7492 VSS=VSS VDD=VDD
Xg116991__6161 NAND2X1 $PINS Z=n_7712 A=n_7609 B=n_7321 VSS=VSS VDD=VDD
Xg116992__9315 NOR2X1 $PINS Z=n_7711 A=n_7181 B=n_7453 VSS=VSS VDD=VDD
Xg116993__9945 NOR2X1 $PINS Z=n_7710 A=n_7442 B=n_7585 VSS=VSS VDD=VDD
Xg116994__2883 NAND2X1 $PINS Z=n_7709 A=n_7625 B=n_7073 VSS=VSS VDD=VDD
Xg116995__2346 NOR2X1 $PINS Z=n_7708 A=n_7367 B=n_7562 VSS=VSS VDD=VDD
Xg116996__1666 NOR2X1 $PINS Z=n_7707 A=n_6936 B=n_7597 VSS=VSS VDD=VDD
Xg116997__7410 NAND3X1 $PINS Z=n_7706 A=n_7434 B=n_7279 C=n_7198 VSS=VSS
+ VDD=VDD
Xg116998__6417 NAND2X1 $PINS Z=n_7705 A=n_7538 B=n_7199 VSS=VSS VDD=VDD
Xg116999__5477 OR2X1 $PINS Z=n_7704 A=n_7028 B=n_7545 VSS=VSS VDD=VDD
Xg117000__2398 NAND2X1 $PINS Z=n_7703 A=n_7540 B=n_6928 VSS=VSS VDD=VDD
Xg117001__5107 NAND2X1 $PINS Z=n_7702 A=n_7549 B=n_7199 VSS=VSS VDD=VDD
Xg117002__6260 NAND3X1 $PINS Z=n_7701 A=n_7509 B=n_7100 C=n_7026 VSS=VSS
+ VDD=VDD
Xg117003__4319 NAND2X1 $PINS Z=n_7700 A=n_7561 B=n_6994 VSS=VSS VDD=VDD
Xg117004__8428 NOR2X1 $PINS Z=n_7699 A=n_7311 B=n_7500 VSS=VSS VDD=VDD
Xg117005__5526 NAND3X1 $PINS Z=n_7698 A=n_7206 B=n_7382 C=n_6936 VSS=VSS
+ VDD=VDD
Xg117006__6783 NAND2X1 $PINS Z=n_7697 A=n_7580 B=n_7168 VSS=VSS VDD=VDD
Xg117007__3680 NAND2X1 $PINS Z=n_7696 A=n_7470 B=n_7426 VSS=VSS VDD=VDD
Xg117008 INVX2 $PINS Z=n_7695 A=n_7694 VSS=VSS VDD=VDD
Xg117009 INVX2 $PINS Z=n_7693 A=n_7692 VSS=VSS VDD=VDD
Xg117010__1617 XOR2X1 $PINS Z=n_7691 A=n_6931 B=n_7315 VSS=VSS VDD=VDD
Xg117011__2802 NAND2X1 $PINS Z=n_7690 A=n_7499 B=n_7193 VSS=VSS VDD=VDD
Xg117012__1705 NAND2X1 $PINS Z=n_7689 A=n_7511 B=n_7518 VSS=VSS VDD=VDD
Xg117013__5122 NAND3X1 $PINS Z=n_7688 A=n_7380 B=n_7406 C=n_7215 VSS=VSS
+ VDD=VDD
Xg117014__8246 OR2X1 $PINS Z=n_7687 A=n_6952 B=n_7628 VSS=VSS VDD=VDD
Xg117015__7098 NOR2X1 $PINS Z=n_7686 A=n_6851 B=n_7542 VSS=VSS VDD=VDD
Xg117016__6131 NAND2X1 $PINS Z=n_7685 A=n_7555 B=n_7250 VSS=VSS VDD=VDD
Xg117017__1881 NAND2X1 $PINS Z=n_7684 A=n_7520 B=n_6945 VSS=VSS VDD=VDD
Xg117018__5115 NAND2X1 $PINS Z=n_7683 A=n_7522 B=n_6924 VSS=VSS VDD=VDD
Xg117019__7482 NAND2X1 $PINS Z=n_7682 A=n_7546 B=n_7071 VSS=VSS VDD=VDD
Xg117020__4733 NOR2X1 $PINS Z=n_7681 A=n_7350 B=n_7514 VSS=VSS VDD=VDD
Xg117021__6161 NOR2X1 $PINS Z=n_7680 A=n_7054 B=n_7539 VSS=VSS VDD=VDD
Xg117022__9315 NAND3X1 $PINS Z=n_7679 A=n_7414 B=n_7309 C=n_6849 VSS=VSS
+ VDD=VDD
Xg117024__2883 NAND2X1 $PINS Z=n_7677 A=n_7439 B=n_7510 VSS=VSS VDD=VDD
Xg117025__2346 NAND2X1 $PINS Z=n_7676 A=n_7537 B=n_6998 VSS=VSS VDD=VDD
Xg117026__1666 NAND2X1 $PINS Z=n_7675 A=n_7539 B=n_6931 VSS=VSS VDD=VDD
Xg117027__7410 NAND3X1 $PINS Z=n_7674 A=n_7488 B=n_7065 C=n_7032 VSS=VSS
+ VDD=VDD
Xg117028__6417 OR2X1 $PINS Z=n_7673 A=n_6999 B=n_7521 VSS=VSS VDD=VDD
Xg117029__5477 OR2X1 $PINS Z=n_7672 A=n_7166 B=n_7535 VSS=VSS VDD=VDD
Xg117030__2398 NOR2X1 $PINS Z=n_7671 A=n_7257 B=n_7512 VSS=VSS VDD=VDD
Xg117031__5107 OR2X1 $PINS Z=n_7670 A=n_7005 B=n_7536 VSS=VSS VDD=VDD
Xg117032__6260 NAND2X1 $PINS Z=n_7669 A=n_7516 B=n_6949 VSS=VSS VDD=VDD
Xg117033__4319 NAND3X1 $PINS Z=n_7668 A=n_7338 B=n_7341 C=n_7254 VSS=VSS
+ VDD=VDD
Xg117034__8428 NAND2X1 $PINS Z=n_7667 A=n_7519 B=n_7317 VSS=VSS VDD=VDD
Xg117035__5526 NAND2X1 $PINS Z=n_7666 A=n_7502 B=n_6948 VSS=VSS VDD=VDD
Xg117036__6783 NAND2X1 $PINS Z=n_7665 A=n_7498 B=n_7260 VSS=VSS VDD=VDD
Xg117037__3680 NAND2X1 $PINS Z=n_7664 A=n_8059 B=n_6964 VSS=VSS VDD=VDD
Xg117038__1617 NAND2X1 $PINS Z=n_7663 A=n_7626 B=n_7107 VSS=VSS VDD=VDD
Xg117039__2802 AND2X1 $PINS Z=n_7662 A=n_7538 B=n_7164 VSS=VSS VDD=VDD
Xg117040__1705 NAND2X1 $PINS Z=n_7661 A=n_7547 B=n_6948 VSS=VSS VDD=VDD
Xg117041__5122 NAND2X1 $PINS Z=n_7660 A=n_7530 B=n_6865 VSS=VSS VDD=VDD
Xg117042__8246 NAND3X1 $PINS Z=n_7659 A=n_7308 B=n_7361 C=n_7003 VSS=VSS
+ VDD=VDD
Xg117044__6131 OR2X1 $PINS Z=n_7657 A=n_6999 B=n_7493 VSS=VSS VDD=VDD
Xg117045__1881 NAND3X1 $PINS Z=n_7656 A=n_7617 B=n_6867 C=n_6888 VSS=VSS
+ VDD=VDD
Xg117046__5115 NOR2X1 $PINS Z=n_7655 A=n_7331 B=n_7489 VSS=VSS VDD=VDD
Xg117047__7482 NAND2X1 $PINS Z=n_7654 A=n_7535 B=n_6959 VSS=VSS VDD=VDD
Xg117048__4733 NAND3X1 $PINS Z=n_7653 A=n_7353 B=n_7356 C=n_7346 VSS=VSS
+ VDD=VDD
Xg117049__6161 NAND3X1 $PINS Z=n_7652 A=n_7494 B=n_7232 C=n_7231 VSS=VSS
+ VDD=VDD
Xg117050__9315 NAND3X1 $PINS Z=n_7651 A=n_7348 B=n_7229 C=n_7581 VSS=VSS
+ VDD=VDD
Xg117051__9945 NAND3X1 $PINS Z=n_7650 A=n_7621 B=n_7003 C=n_6980 VSS=VSS
+ VDD=VDD
Xg117052__2883 NAND3X1 $PINS Z=n_7649 A=n_7315 B=n_7335 C=n_7057 VSS=VSS
+ VDD=VDD
Xg117053__2346 NAND3X1 $PINS Z=n_7648 A=n_7505 B=n_7181 C=n_7306 VSS=VSS
+ VDD=VDD
Xg117054__1666 NAND3X1 $PINS Z=n_7647 A=n_7526 B=n_7404 C=n_7394 VSS=VSS
+ VDD=VDD
Xg117055__7410 NAND3X1 $PINS Z=n_7646 A=n_7345 B=n_7592 C=n_7239 VSS=VSS
+ VDD=VDD
Xg117056__6417 NAND3X1 $PINS Z=n_7645 A=n_7420 B=n_7559 C=n_7430 VSS=VSS
+ VDD=VDD
Xg117057__5477 NAND3X1 $PINS Z=n_7644 A=n_7375 B=n_7588 C=n_7248 VSS=VSS
+ VDD=VDD
Xg117058__2398 NAND3X1 $PINS Z=n_7643 A=n_7566 B=n_7039 C=n_7035 VSS=VSS
+ VDD=VDD
Xg117059__5107 NAND3X1 $PINS Z=n_7642 A=n_7484 B=n_7288 C=n_7372 VSS=VSS
+ VDD=VDD
Xg117060__6260 NAND3X1 $PINS Z=n_7641 A=n_7490 B=n_7433 C=n_7181 VSS=VSS
+ VDD=VDD
Xg117061__4319 NAND3X1 $PINS Z=n_7640 A=n_7253 B=n_7554 C=n_7251 VSS=VSS
+ VDD=VDD
Xg117062__8428 NAND3X1 $PINS Z=n_7639 A=n_7503 B=n_7113 C=n_6940 VSS=VSS
+ VDD=VDD
Xg117063__5526 NAND3X1 $PINS Z=n_7638 A=n_7410 B=n_7409 C=n_7385 VSS=VSS
+ VDD=VDD
Xg117064__6783 NAND3X1 $PINS Z=n_7637 A=n_7303 B=n_7244 C=n_7204 VSS=VSS
+ VDD=VDD
Xg117065__3680 NAND3X1 $PINS Z=n_7636 A=n_7256 B=n_7298 C=n_7204 VSS=VSS
+ VDD=VDD
Xg117066__1617 NAND3X1 $PINS Z=n_7635 A=n_7297 B=n_7378 C=n_7238 VSS=VSS
+ VDD=VDD
Xg117067__2802 NAND3X1 $PINS Z=n_7634 A=n_7123 B=n_7300 C=n_6857 VSS=VSS
+ VDD=VDD
Xg117068__1705 NAND3X1 $PINS Z=n_7633 A=n_7089 B=n_7392 C=n_7194 VSS=VSS
+ VDD=VDD
Xg117069__5122 NAND3X1 $PINS Z=n_7632 A=n_7523 B=n_7317 C=n_7334 VSS=VSS
+ VDD=VDD
Xg117070__8246 OR2X1 $PINS Z=n_7631 A=n_6984 B=n_7536 VSS=VSS VDD=VDD
Xg117071__7098 MUX2X1 $PINS Z=n_7630 A=n_7344 B=n_7241 S=n_7203 VSS=VSS VDD=VDD
Xg117072__6131 MUX2X1 $PINS Z=n_7629 A=n_7304 B=n_6973 S=n_7163 VSS=VSS VDD=VDD
Xg117073__1881 XOR2X1 $PINS Z=n_7694 A=n_6873 B=n_7309 VSS=VSS VDD=VDD
Xg117074__5115 NOR2X1 $PINS Z=n_7692 A=n_6860 B=n_7491 VSS=VSS VDD=VDD
Xg117075__7482 NAND2X1 $PINS Z=n_7625 A=n_7381 B=n_7154 VSS=VSS VDD=VDD
Xg117076__4733 AND2X1 $PINS Z=n_7624 A=n_7264 B=n_7411 VSS=VSS VDD=VDD
Xg117077__6161 NAND2X1 $PINS Z=n_7623 A=n_7443 B=n_7357 VSS=VSS VDD=VDD
Xg117078__9315 NOR2X1 $PINS Z=n_7622 A=n_6848 B=n_7325 VSS=VSS VDD=VDD
Xg117079__9945 NAND2X1 $PINS Z=n_7621 A=n_7402 B=n_7196 VSS=VSS VDD=VDD
Xg117080__2883 NAND3X1 $PINS Z=n_7620 A=n_7324 B=n_6990 C=n_6927 VSS=VSS
+ VDD=VDD
Xg117081__2346 OR2X1 $PINS Z=n_7619 A=n_7330 B=n_7202 VSS=VSS VDD=VDD
Xg117082__1666 NAND2X1 $PINS Z=n_7618 A=n_7156 B=n_7416 VSS=VSS VDD=VDD
Xg117083__7410 NAND2X1 $PINS Z=n_7617 A=n_7205 B=n_7325 VSS=VSS VDD=VDD
Xg117084__6417 OR2X1 $PINS Z=n_7616 A=n_6928 B=n_7340 VSS=VSS VDD=VDD
Xg117085__5477 NOR2X1 $PINS Z=n_7615 A=n_7115 B=n_7320 VSS=VSS VDD=VDD
Xg117086__2398 OR2X1 $PINS Z=n_7614 A=n_6850 B=n_7330 VSS=VSS VDD=VDD
Xg117087__5107 NAND2X1 $PINS Z=n_7613 A=n_7289 B=n_7106 VSS=VSS VDD=VDD
Xg117088__6260 NAND2X1 $PINS Z=n_7612 A=n_7325 B=n_7240 VSS=VSS VDD=VDD
Xg117089__4319 NAND2X1 $PINS Z=n_7611 A=n_7332 B=n_7063 VSS=VSS VDD=VDD
Xg117090__8428 NAND2X1 $PINS Z=n_7610 A=n_7424 B=n_7071 VSS=VSS VDD=VDD
Xg117091__5526 NAND2X1 $PINS Z=n_7609 A=n_7188 B=n_7386 VSS=VSS VDD=VDD
Xg117092__6783 NAND2X1 $PINS Z=n_7608 A=n_7423 B=n_7390 VSS=VSS VDD=VDD
Xg117093__3680 NOR2X1 $PINS Z=n_7607 A=n_7216 B=n_7450 VSS=VSS VDD=VDD
Xg117094__1617 NOR2X1 $PINS Z=n_7606 A=n_7206 B=n_7440 VSS=VSS VDD=VDD
Xg117095__2802 NAND2X1 $PINS Z=n_7605 A=n_7105 B=n_7429 VSS=VSS VDD=VDD
Xg117096__1705 NAND2X1 $PINS Z=n_7604 A=n_7397 B=n_7395 VSS=VSS VDD=VDD
Xg117097__5122 NAND2X1 $PINS Z=n_7603 A=n_7370 B=n_7122 VSS=VSS VDD=VDD
Xg117098__8246 NAND2X1 $PINS Z=n_7602 A=n_7422 B=n_7187 VSS=VSS VDD=VDD
Xg117099__7098 NAND2X1 $PINS Z=n_7601 A=n_7363 B=n_7225 VSS=VSS VDD=VDD
Xg117100__6131 NAND2X1 $PINS Z=n_7600 A=n_7447 B=n_6972 VSS=VSS VDD=VDD
Xg117101__1881 NAND2X1 $PINS Z=n_7599 A=n_7296 B=n_7223 VSS=VSS VDD=VDD
Xg117102__5115 NAND2X1 $PINS Z=n_7598 A=n_7277 B=n_7290 VSS=VSS VDD=VDD
Xg117103__7482 NOR2X1 $PINS Z=n_7597 A=n_7212 B=n_7440 VSS=VSS VDD=VDD
Xg117104__4733 NAND2X1 $PINS Z=n_7596 A=n_7236 B=n_7268 VSS=VSS VDD=VDD
Xg117105__6161 AND2X1 $PINS Z=n_7595 A=n_7355 B=n_7237 VSS=VSS VDD=VDD
Xg117106__9315 NAND2X1 $PINS Z=n_7594 A=n_7101 B=n_7249 VSS=VSS VDD=VDD
Xg117107__9945 AND2X1 $PINS Z=n_7593 A=n_7340 B=n_7360 VSS=VSS VDD=VDD
Xg117108__2883 NAND3X1 $PINS Z=n_7592 A=n_7084 B=n_7166 C=n_6860 VSS=VSS
+ VDD=VDD
Xg117109__2346 NAND2X1 $PINS Z=n_7591 A=n_7389 B=n_7210 VSS=VSS VDD=VDD
Xg117110__1666 NOR2X1 $PINS Z=n_7590 A=n_7432 B=n_7405 VSS=VSS VDD=VDD
Xg117111__7410 NOR2X1 $PINS Z=n_7589 A=n_7146 B=n_7419 VSS=VSS VDD=VDD
Xg117112__6417 NAND2X1 $PINS Z=n_7588 A=n_7418 B=n_6947 VSS=VSS VDD=VDD
Xg117113__5477 OR2X1 $PINS Z=n_7587 A=n_7319 B=n_7209 VSS=VSS VDD=VDD
Xg117114__2398 NAND2X1 $PINS Z=n_7586 A=n_7219 B=n_7437 VSS=VSS VDD=VDD
Xg117115__5107 NOR2X1 $PINS Z=n_7585 A=n_7217 B=n_7412 VSS=VSS VDD=VDD
Xg117116__6260 OR2X1 $PINS Z=n_7584 A=n_7447 B=n_7155 VSS=VSS VDD=VDD
Xg117117__4319 NAND2X1 $PINS Z=n_7583 A=n_7408 B=n_6940 VSS=VSS VDD=VDD
Xg117118__8428 NAND2X1 $PINS Z=n_7582 A=n_7440 B=n_6889 VSS=VSS VDD=VDD
Xg117119__5526 AND2X1 $PINS Z=n_7581 A=n_7425 B=n_7230 VSS=VSS VDD=VDD
Xg117120__6783 NAND2X1 $PINS Z=n_7580 A=n_7407 B=n_7153 VSS=VSS VDD=VDD
Xg117121__3680 OR2X1 $PINS Z=n_7579 A=n_7085 B=n_7364 VSS=VSS VDD=VDD
Xg117122__1617 NAND2X1 $PINS Z=n_7578 A=n_7388 B=n_7098 VSS=VSS VDD=VDD
Xg117123__2802 NOR2X1 $PINS Z=n_7577 A=n_6955 B=n_7444 VSS=VSS VDD=VDD
Xg117124__1705 NOR2X1 $PINS Z=n_7576 A=n_7011 B=n_7446 VSS=VSS VDD=VDD
Xg117125__5122 NAND2X1 $PINS Z=n_7575 A=n_7149 B=n_7319 VSS=VSS VDD=VDD
Xg117126__8246 NAND2X1 $PINS Z=n_7574 A=n_7294 B=n_7309 VSS=VSS VDD=VDD
Xg117127__7098 OR2X1 $PINS Z=n_7573 A=n_7287 B=n_7123 VSS=VSS VDD=VDD
Xg117128__6131 NAND2X1 $PINS Z=n_7572 A=n_7401 B=n_7001 VSS=VSS VDD=VDD
Xg117129__1881 NAND2X1 $PINS Z=n_7571 A=n_7206 B=n_7400 VSS=VSS VDD=VDD
Xg117130__5115 NAND3X1 $PINS Z=n_7570 A=n_7436 B=n_6998 C=n_6894 VSS=VSS
+ VDD=VDD
Xg117131__7482 NOR2X1 $PINS Z=n_7569 A=n_6846 B=n_7448 VSS=VSS VDD=VDD
Xg117132__4733 NAND3X1 $PINS Z=n_7568 A=n_7097 B=n_7323 C=n_6868 VSS=VSS
+ VDD=VDD
Xg117133__6161 NAND2X1 $PINS Z=n_7567 A=n_8061 B=n_7199 VSS=VSS VDD=VDD
Xg117134__9315 NAND2X1 $PINS Z=n_7566 A=n_7374 B=n_7029 VSS=VSS VDD=VDD
Xg117135__9945 NOR2X1 $PINS Z=n_7565 A=n_7104 B=n_7451 VSS=VSS VDD=VDD
Xg117136__2883 NAND3X1 $PINS Z=n_7564 A=n_7060 B=n_7158 C=n_6862 VSS=VSS
+ VDD=VDD
Xg117137__2346 NAND3X1 $PINS Z=n_7563 A=n_7180 B=n_7090 C=n_6938 VSS=VSS
+ VDD=VDD
Xg117138__1666 AND2X1 $PINS Z=n_7562 A=n_7313 B=n_7449 VSS=VSS VDD=VDD
Xg117139__7410 NAND2X1 $PINS Z=n_7561 A=n_7291 B=n_7132 VSS=VSS VDD=VDD
Xg117140__6417 NOR2X1 $PINS Z=n_7560 A=n_6994 B=n_7441 VSS=VSS VDD=VDD
Xg117141__5477 OR2X1 $PINS Z=n_7559 A=n_7017 B=n_7336 VSS=VSS VDD=VDD
Xg117142__2398 NOR2X1 $PINS Z=n_7558 A=n_7245 B=n_7140 VSS=VSS VDD=VDD
Xg117143__5107 OR2X1 $PINS Z=n_7557 A=n_7005 B=n_7437 VSS=VSS VDD=VDD
Xg117144__6260 NOR2X1 $PINS Z=n_7556 A=n_7384 B=n_7434 VSS=VSS VDD=VDD
Xg117145__4319 NAND2X1 $PINS Z=n_7555 A=n_7434 B=n_6938 VSS=VSS VDD=VDD
Xg117146__8428 NAND3X1 $PINS Z=n_7554 A=n_7080 B=n_7059 C=n_6912 VSS=VSS
+ VDD=VDD
Xg117147__5526 NAND2X1 $PINS Z=n_7553 A=n_7442 B=n_7217 VSS=VSS VDD=VDD
Xg117148__6783 OR2X1 $PINS Z=n_7552 A=n_7017 B=n_7441 VSS=VSS VDD=VDD
Xg117149__3680 NOR2X1 $PINS Z=n_7551 A=n_7005 B=n_7227 VSS=VSS VDD=VDD
Xg117150__1617 NOR2X1 $PINS Z=n_7550 A=n_6900 B=n_7451 VSS=VSS VDD=VDD
Xg117151__2802 NAND2X1 $PINS Z=n_7549 A=n_7366 B=n_7030 VSS=VSS VDD=VDD
Xg117152__1705 NAND2X1 $PINS Z=n_7548 A=n_7337 B=n_6994 VSS=VSS VDD=VDD
Xg117153__5122 NAND2X1 $PINS Z=n_7547 A=n_7352 B=n_7371 VSS=VSS VDD=VDD
Xg117154__8246 NAND2X1 $PINS Z=n_7546 A=n_7387 B=n_7052 VSS=VSS VDD=VDD
Xg117155__7098 NOR2X1 $PINS Z=n_7545 A=n_7349 B=n_7339 VSS=VSS VDD=VDD
Xg117156__6131 NAND2X1 $PINS Z=n_7544 A=n_7323 B=n_6906 VSS=VSS VDD=VDD
Xg117157__1881 OR2X1 $PINS Z=n_7543 A=n_6914 B=n_7338 VSS=VSS VDD=VDD
Xg117158__5115 NOR2X1 $PINS Z=n_7542 A=n_7092 B=n_7445 VSS=VSS VDD=VDD
Xg117159__7482 NAND2X1 $PINS Z=n_7541 A=n_7309 B=n_7003 VSS=VSS VDD=VDD
Xg117160__4733 NAND2X1 $PINS Z=n_7628 A=n_7315 B=n_6944 VSS=VSS VDD=VDD
Xg117161__6161 NOR2X1 $PINS Z=n_7627 A=n_6994 B=n_7446 VSS=VSS VDD=VDD
Xg117162__9315 AND2X1 $PINS Z=n_7626 A=n_7308 B=n_6873 VSS=VSS VDD=VDD
Xg117163 INVX2 $PINS Z=n_7540 A=n_7501 VSS=VSS VDD=VDD
Xg117165__2883 OR2X1 $PINS Z=n_7533 A=n_6844 B=n_7437 VSS=VSS VDD=VDD
Xg117166__2346 NAND3X1 $PINS Z=n_7532 A=n_7324 B=n_7001 C=n_6926 VSS=VSS
+ VDD=VDD
Xg117168__7410 XOR2X1 $PINS Z=n_7530 A=n_6854 B=n_7086 VSS=VSS VDD=VDD
Xg117169__6417 NAND2X1 $PINS Z=n_7529 A=n_7442 B=n_7185 VSS=VSS VDD=VDD
Xg117170__5477 NAND3X1 $PINS Z=n_7528 A=n_7014 B=n_7194 C=n_6857 VSS=VSS
+ VDD=VDD
Xg117171__2398 NAND3X1 $PINS Z=n_7527 A=n_7091 B=n_7182 C=n_6938 VSS=VSS
+ VDD=VDD
Xg117172__5107 NAND2X1 $PINS Z=n_7526 A=n_7089 B=n_7436 VSS=VSS VDD=VDD
Xg117173__6260 OR2X1 $PINS Z=n_7525 A=n_7179 B=n_7322 VSS=VSS VDD=VDD
Xg117174__4319 AND2X1 $PINS Z=n_7524 A=n_7438 B=n_7368 VSS=VSS VDD=VDD
Xg117175__8428 NAND2X1 $PINS Z=n_7523 A=n_7322 B=n_7179 VSS=VSS VDD=VDD
Xg117176__5526 NAND2X1 $PINS Z=n_7522 A=n_7295 B=n_7369 VSS=VSS VDD=VDD
Xg117177__6783 NOR2X1 $PINS Z=n_7521 A=n_7067 B=n_7274 VSS=VSS VDD=VDD
Xg117178__3680 NAND2X1 $PINS Z=n_7520 A=n_7062 B=n_7273 VSS=VSS VDD=VDD
Xg117179__1617 NAND2X1 $PINS Z=n_7519 A=n_7438 B=n_7305 VSS=VSS VDD=VDD
Xg117180__2802 NAND2X1 $PINS Z=n_7518 A=n_7096 B=n_7445 VSS=VSS VDD=VDD
Xg117181__1705 NAND3X1 $PINS Z=n_7517 A=n_7078 B=n_7083 C=n_6967 VSS=VSS
+ VDD=VDD
Xg117182__5122 OR2X1 $PINS Z=n_7516 A=n_7278 B=n_7323 VSS=VSS VDD=VDD
Xg117183__8246 NAND2X1 $PINS Z=n_7515 A=n_7323 B=n_6876 VSS=VSS VDD=VDD
Xg117184__7098 AND2X1 $PINS Z=n_7514 A=n_7311 B=n_7184 VSS=VSS VDD=VDD
Xg117185__6131 NAND2X1 $PINS Z=n_7513 A=n_7293 B=n_6940 VSS=VSS VDD=VDD
Xg117186__1881 AND2X1 $PINS Z=n_7512 A=n_7092 B=n_7265 VSS=VSS VDD=VDD
Xg117187__5115 NAND2X1 $PINS Z=n_7511 A=n_7327 B=n_7092 VSS=VSS VDD=VDD
Xg117188__7482 OR2X1 $PINS Z=n_7510 A=n_6924 B=n_7321 VSS=VSS VDD=VDD
Xg117189__4733 XOR2X1 $PINS Z=n_7509 A=n_7071 B=n_6994 VSS=VSS VDD=VDD
Xg117190__6161 NAND2X1 $PINS Z=n_7508 A=n_7339 B=n_6924 VSS=VSS VDD=VDD
Xg117191__9315 NAND2X1 $PINS Z=n_7507 A=n_7110 B=n_7436 VSS=VSS VDD=VDD
Xg117192__9945 NAND2X1 $PINS Z=n_7506 A=n_7333 B=n_6973 VSS=VSS VDD=VDD
Xg117193__2883 NAND2X1 $PINS Z=n_7505 A=n_7434 B=n_6847 VSS=VSS VDD=VDD
Xg117194__2346 NAND3X1 $PINS Z=n_7504 A=n_7133 B=n_7403 C=n_7139 VSS=VSS
+ VDD=VDD
Xg117195__1666 NAND2X1 $PINS Z=n_7503 A=n_7188 B=n_7362 VSS=VSS VDD=VDD
Xg117196__7410 NAND2X1 $PINS Z=n_7502 A=n_7053 B=n_7373 VSS=VSS VDD=VDD
Xg117197__6417 MUX2X1 $PINS Z=n_7501 A=n_7101 B=n_6952 S=n_7165 VSS=VSS VDD=VDD
Xg117198__5477 MUX2X1 $PINS Z=n_7500 A=n_7028 B=n_7188 S=n_6845 VSS=VSS VDD=VDD
Xg117199__2398 NAND2X1 $PINS Z=n_7499 A=n_7056 B=n_7234 VSS=VSS VDD=VDD
Xg117200__5107 NAND2X1 $PINS Z=n_7498 A=n_7284 B=n_6905 VSS=VSS VDD=VDD
Xg117201__6260 NAND2X1 $PINS Z=n_7497 A=n_7189 B=n_7311 VSS=VSS VDD=VDD
Xg117203__8428 NAND3X1 $PINS Z=n_7495 A=n_7131 B=n_7116 C=n_6999 VSS=VSS
+ VDD=VDD
Xg117204__5526 NAND2X1 $PINS Z=n_7494 A=n_7283 B=n_6954 VSS=VSS VDD=VDD
Xg117205__6783 NOR2X1 $PINS Z=n_7493 A=n_7270 B=n_7271 VSS=VSS VDD=VDD
Xg117206__3680 MUX2X1 $PINS Z=n_7492 A=n_7204 B=n_6939 S=n_6847 VSS=VSS VDD=VDD
Xg117207__1617 NOR2X1 $PINS Z=n_7491 A=n_6878 B=n_7317 VSS=VSS VDD=VDD
Xg117208__2802 NAND2X1 $PINS Z=n_7490 A=n_7242 B=n_6887 VSS=VSS VDD=VDD
Xg117209__1705 NOR2X1 $PINS Z=n_7489 A=n_6893 B=n_7261 VSS=VSS VDD=VDD
Xg117210__5122 NAND2X1 $PINS Z=n_7488 A=n_7267 B=n_6860 VSS=VSS VDD=VDD
Xg117211__8246 OR2X1 $PINS Z=n_7487 A=n_7280 B=n_7313 VSS=VSS VDD=VDD
Xg117212__7098 NAND3X1 $PINS Z=n_7486 A=n_7358 B=n_7055 C=n_6896 VSS=VSS
+ VDD=VDD
Xg117213__6131 OR2X1 $PINS Z=n_7485 A=n_7097 B=n_7329 VSS=VSS VDD=VDD
Xg117214__1881 NAND2X1 $PINS Z=n_7484 A=n_7272 B=n_7083 VSS=VSS VDD=VDD
Xg117215__5115 NAND2X1 $PINS Z=n_7483 A=n_7327 B=n_6949 VSS=VSS VDD=VDD
Xg117216__7482 NAND3X1 $PINS Z=n_7482 A=n_7081 B=n_7000 C=n_6855 VSS=VSS
+ VDD=VDD
Xg117217__4733 NAND3X1 $PINS Z=n_7481 A=n_7276 B=n_6963 C=n_6892 VSS=VSS
+ VDD=VDD
Xg117218__6161 NAND3X1 $PINS Z=n_7480 A=n_7093 B=n_7023 C=n_6857 VSS=VSS
+ VDD=VDD
Xg117219__9315 NAND3X1 $PINS Z=n_7479 A=n_7328 B=n_6945 C=n_6958 VSS=VSS
+ VDD=VDD
Xg117220__9945 MUX2X1 $PINS Z=n_7478 A=n_7147 B=n_6989 S=n_6899 VSS=VSS VDD=VDD
Xg117221__2883 NAND3X1 $PINS Z=n_7477 A=n_7266 B=n_7048 C=n_7069 VSS=VSS
+ VDD=VDD
Xg117222__2346 NAND3X1 $PINS Z=n_7476 A=n_7399 B=n_7103 C=n_7125 VSS=VSS
+ VDD=VDD
Xg117223__1666 NAND3X1 $PINS Z=n_7475 A=n_7088 B=n_7159 C=n_7011 VSS=VSS
+ VDD=VDD
Xg117224__7410 NAND3X1 $PINS Z=n_7474 A=n_7102 B=n_7071 C=n_6881 VSS=VSS
+ VDD=VDD
Xg117225__6417 NAND3X1 $PINS Z=n_7473 A=n_7176 B=n_7171 C=n_6897 VSS=VSS
+ VDD=VDD
Xg117226__5477 NAND3X1 $PINS Z=n_7472 A=n_7097 B=n_7079 C=n_7130 VSS=VSS
+ VDD=VDD
Xg117227__2398 OR2X1 $PINS Z=n_7471 A=n_7089 B=n_7413 VSS=VSS VDD=VDD
Xg117228__5107 NAND3X1 $PINS Z=n_7470 A=n_7020 B=n_7379 C=n_6875 VSS=VSS
+ VDD=VDD
Xg117229__6260 OR2X1 $PINS Z=n_7469 A=n_6919 B=n_7441 VSS=VSS VDD=VDD
Xg117230__4319 NAND3X1 $PINS Z=n_7468 A=n_7324 B=n_7001 C=n_6927 VSS=VSS
+ VDD=VDD
Xg117231__8428 NAND3X1 $PINS Z=n_7467 A=n_7301 B=n_7058 C=n_7077 VSS=VSS
+ VDD=VDD
Xg117232__5526 NAND3X1 $PINS Z=n_7466 A=n_7312 B=n_6955 C=n_6942 VSS=VSS
+ VDD=VDD
Xg117233__6783 NAND3X1 $PINS Z=n_7465 A=n_7286 B=n_6887 C=n_6897 VSS=VSS
+ VDD=VDD
Xg117234__3680 NAND3X1 $PINS Z=n_7464 A=n_7436 B=n_7023 C=n_6856 VSS=VSS
+ VDD=VDD
Xg117235__1617 NAND3X1 $PINS Z=n_7463 A=n_7435 B=n_6998 C=n_6895 VSS=VSS
+ VDD=VDD
Xg117236__2802 NAND3X1 $PINS Z=n_7462 A=n_7310 B=n_7004 C=n_7197 VSS=VSS
+ VDD=VDD
Xg117237__1705 NAND3X1 $PINS Z=n_7461 A=n_7044 B=n_7068 C=n_6869 VSS=VSS
+ VDD=VDD
Xg117238__5122 NAND3X1 $PINS Z=n_7460 A=n_7259 B=n_6851 C=n_6876 VSS=VSS
+ VDD=VDD
Xg117239__8246 NAND3X1 $PINS Z=n_7459 A=n_7202 B=n_7040 C=n_7047 VSS=VSS
+ VDD=VDD
Xg117240__7098 NAND3X1 $PINS Z=n_7458 A=n_7079 B=n_7061 C=n_6964 VSS=VSS
+ VDD=VDD
Xg117241__6131 NAND3X1 $PINS Z=n_7457 A=n_7109 B=n_7007 C=n_7148 VSS=VSS
+ VDD=VDD
Xg117242__1881 NAND3X1 $PINS Z=n_7456 A=n_7316 B=n_6977 C=n_6944 VSS=VSS
+ VDD=VDD
Xg117243__5115 NAND3X1 $PINS Z=n_7455 A=n_7184 B=n_7161 C=n_6901 VSS=VSS
+ VDD=VDD
Xg117244__7482 NAND2X1 $PINS Z=n_7454 A=n_7292 B=n_7311 VSS=VSS VDD=VDD
Xg117245__4733 NOR2X1 $PINS Z=n_7453 A=n_7143 B=n_7444 VSS=VSS VDD=VDD
Xg117246__6161 AND2X1 $PINS Z=n_7539 A=n_7317 B=n_6879 VSS=VSS VDD=VDD
Xg117247__9315 NOR2X1 $PINS Z=n_7538 A=n_6969 B=n_7333 VSS=VSS VDD=VDD
Xg117248__9945 NAND3X1 $PINS Z=n_7452 A=n_7100 B=n_7070 C=n_6880 VSS=VSS
+ VDD=VDD
Xg117249__2883 NOR2X1 $PINS Z=n_7537 A=n_7319 B=n_7006 VSS=VSS VDD=VDD
Xg117250__2346 NAND2X1 $PINS Z=n_7536 A=n_7311 B=n_6924 VSS=VSS VDD=VDD
Xg117251__1666 OR2X1 $PINS Z=n_7535 A=n_6860 B=n_7322 VSS=VSS VDD=VDD
Xg117252 INVX2 $PINS Z=n_7449 A=n_7448 VSS=VSS VDD=VDD
Xg117253 INVX2 $PINS Z=n_7443 A=n_7444 VSS=VSS VDD=VDD
Xg117254 INVX2 $PINS Z=n_7435 A=n_7436 VSS=VSS VDD=VDD
Xg117255 INVX2 $PINS Z=n_7433 A=n_7434 VSS=VSS VDD=VDD
Xg117256__7410 NOR2X1 $PINS Z=n_7432 A=n_7070 B=n_7050 VSS=VSS VDD=VDD
Xg117257__6417 NOR2X1 $PINS Z=n_7431 A=n_7211 B=n_7098 VSS=VSS VDD=VDD
Xg117258__5477 OR2X1 $PINS Z=n_7430 A=n_7170 B=n_7117 VSS=VSS VDD=VDD
Xg117259__2398 NAND2X1 $PINS Z=n_7429 A=n_7099 B=n_7018 VSS=VSS VDD=VDD
Xg117260__5107 NOR2X1 $PINS Z=n_7428 A=n_7076 B=n_7122 VSS=VSS VDD=VDD
Xg117261__6260 OR2X1 $PINS Z=n_7427 A=n_6864 B=n_7099 VSS=VSS VDD=VDD
Xg117262__4319 OR2X1 $PINS Z=n_7426 A=n_7177 B=n_7114 VSS=VSS VDD=VDD
Xg117263__8428 OR2X1 $PINS Z=n_7425 A=n_6956 B=n_7099 VSS=VSS VDD=VDD
Xg117264__5526 OR2X1 $PINS Z=n_7424 A=n_7160 B=n_7218 VSS=VSS VDD=VDD
Xg117265__6783 NAND2X1 $PINS Z=n_7423 A=n_7025 B=n_7216 VSS=VSS VDD=VDD
Xg117266__3680 OR2X1 $PINS Z=n_7422 A=n_6977 B=n_7084 VSS=VSS VDD=VDD
Xg117267__1617 NAND2X1 $PINS Z=n_7421 A=n_7214 B=n_6859 VSS=VSS VDD=VDD
Xg117268__2802 NAND2X1 $PINS Z=n_7420 A=n_7218 B=n_6972 VSS=VSS VDD=VDD
Xg117269__1705 NOR2X1 $PINS Z=n_7419 A=n_6845 B=n_7115 VSS=VSS VDD=VDD
Xg117270__5122 NAND2X1 $PINS Z=n_7418 A=n_7119 B=n_7099 VSS=VSS VDD=VDD
Xg117271__8246 NAND3X1 $PINS Z=n_7417 A=n_7110 B=n_6862 C=n_6908 VSS=VSS
+ VDD=VDD
Xg117272__7098 NAND3X1 $PINS Z=n_7416 A=n_7167 B=n_6862 C=n_6894 VSS=VSS
+ VDD=VDD
Xg117273__6131 NAND2X1 $PINS Z=n_7415 A=n_7145 B=n_6874 VSS=VSS VDD=VDD
Xg117274__1881 OR2X1 $PINS Z=n_7414 A=n_7008 B=n_7157 VSS=VSS VDD=VDD
Xg117275__5115 OR2X1 $PINS Z=n_7413 A=n_7110 B=n_7209 VSS=VSS VDD=VDD
Xg117276__7482 AND2X1 $PINS Z=n_7412 A=n_7141 B=n_7098 VSS=VSS VDD=VDD
Xg117277__4733 OR2X1 $PINS Z=n_7411 A=n_7174 B=n_7117 VSS=VSS VDD=VDD
Xg117278__6161 OR2X1 $PINS Z=n_7410 A=n_6858 B=n_7210 VSS=VSS VDD=VDD
Xg117279__9315 NAND3X1 $PINS Z=n_7409 A=n_7102 B=n_6880 C=n_6890 VSS=VSS
+ VDD=VDD
Xg117280__9945 NAND2X1 $PINS Z=n_7408 A=n_7219 B=n_7041 VSS=VSS VDD=VDD
Xg117281__2883 NAND2X1 $PINS Z=n_7407 A=n_7209 B=n_6857 VSS=VSS VDD=VDD
Xg117282__2346 NOR2X1 $PINS Z=n_7406 A=n_6849 B=n_7136 VSS=VSS VDD=VDD
Xg117283__1666 NOR2X1 $PINS Z=n_7405 A=n_7100 B=n_7214 VSS=VSS VDD=VDD
Xg117284__7410 NAND3X1 $PINS Z=n_7404 A=n_7093 B=n_6862 C=n_6856 VSS=VSS
+ VDD=VDD
Xg117285__6417 NAND2X1 $PINS Z=n_7403 A=n_7095 B=n_6862 VSS=VSS VDD=VDD
Xg117286__5477 NAND3X1 $PINS Z=n_7402 A=n_7152 B=n_6872 C=n_6889 VSS=VSS
+ VDD=VDD
Xg117287__2398 OR2X1 $PINS Z=n_7401 A=n_7013 B=n_7088 VSS=VSS VDD=VDD
Xg117288__5107 NAND2X1 $PINS Z=n_7400 A=n_7196 B=n_6866 VSS=VSS VDD=VDD
Xg117289__6260 NAND2X1 $PINS Z=n_7399 A=n_7135 B=n_6926 VSS=VSS VDD=VDD
Xg117290__4319 NAND2X1 $PINS Z=n_7398 A=n_7220 B=n_6939 VSS=VSS VDD=VDD
Xg117291__8428 OR2X1 $PINS Z=n_7397 A=n_6995 B=n_7144 VSS=VSS VDD=VDD
Xg117292__5526 AND2X1 $PINS Z=n_7396 A=n_7088 B=n_7010 VSS=VSS VDD=VDD
Xg117293__6783 NAND3X1 $PINS Z=n_7395 A=n_7081 B=n_6870 C=n_6912 VSS=VSS
+ VDD=VDD
Xg117294__3680 OR2X1 $PINS Z=n_7394 A=n_7194 B=n_6917 VSS=VSS VDD=VDD
Xg117295__1617 NAND2X1 $PINS Z=n_7393 A=n_7189 B=n_7021 VSS=VSS VDD=VDD
Xg117296__2802 OR2X1 $PINS Z=n_7392 A=n_6894 B=n_7093 VSS=VSS VDD=VDD
Xg117297__1705 NAND2X1 $PINS Z=n_7391 A=n_7128 B=n_7185 VSS=VSS VDD=VDD
Xg117298__5122 NAND2X1 $PINS Z=n_7390 A=n_7178 B=n_6875 VSS=VSS VDD=VDD
Xg117299__8246 NAND2X1 $PINS Z=n_7389 A=n_7088 B=n_6993 VSS=VSS VDD=VDD
Xg117300__7098 NAND2X1 $PINS Z=n_7388 A=n_7197 B=n_6845 VSS=VSS VDD=VDD
Xg117301__6131 NAND2X1 $PINS Z=n_7387 A=n_7064 B=n_7013 VSS=VSS VDD=VDD
Xg117302__1881 OR2X1 $PINS Z=n_7386 A=n_6916 B=n_7098 VSS=VSS VDD=VDD
Xg117303__5115 NAND2X1 $PINS Z=n_7385 A=n_7051 B=n_6994 VSS=VSS VDD=VDD
Xg117304__7482 NOR2X1 $PINS Z=n_7384 A=n_6847 B=n_7190 VSS=VSS VDD=VDD
Xg117306__6161 NAND2X1 $PINS Z=n_7382 A=n_7177 B=n_6866 VSS=VSS VDD=VDD
Xg117307__9315 OR2X1 $PINS Z=n_7381 A=n_7009 B=n_7107 VSS=VSS VDD=VDD
Xg117308__9945 OR2X1 $PINS Z=n_7380 A=n_7073 B=n_7112 VSS=VSS VDD=VDD
Xg117309__2883 OR2X1 $PINS Z=n_7379 A=n_7073 B=n_7111 VSS=VSS VDD=VDD
Xg117310__2346 NAND2X1 $PINS Z=n_7378 A=n_7003 B=n_7111 VSS=VSS VDD=VDD
Xg117311__1666 NAND2X1 $PINS Z=n_7377 A=n_7142 B=n_6884 VSS=VSS VDD=VDD
Xg117312__7410 NAND3X1 $PINS Z=n_7376 A=n_7013 B=n_7173 C=n_6853 VSS=VSS
+ VDD=VDD
Xg117313__6417 NAND2X1 $PINS Z=n_7375 A=n_7105 B=n_6996 VSS=VSS VDD=VDD
Xg117314__5477 NAND2X1 $PINS Z=n_7374 A=n_7042 B=n_7126 VSS=VSS VDD=VDD
Xg117315__2398 OR2X1 $PINS Z=n_7373 A=n_7170 B=n_7011 VSS=VSS VDD=VDD
Xg117316__5107 NAND3X1 $PINS Z=n_7372 A=n_6967 B=n_7082 C=n_6868 VSS=VSS
+ VDD=VDD
Xg117317__6260 OR2X1 $PINS Z=n_7371 A=n_6880 B=n_7170 VSS=VSS VDD=VDD
Xg117318__4319 OR2X1 $PINS Z=n_7370 A=n_6876 B=n_7202 VSS=VSS VDD=VDD
Xg117319__8428 NAND2X1 $PINS Z=n_7369 A=n_6961 B=n_7211 VSS=VSS VDD=VDD
Xg117320__5526 NAND2X1 $PINS Z=n_7368 A=n_7179 B=n_6860 VSS=VSS VDD=VDD
Xg117321__6783 NOR2X1 $PINS Z=n_7367 A=n_7164 B=n_7181 VSS=VSS VDD=VDD
Xg117322__3680 NAND2X1 $PINS Z=n_7366 A=n_7191 B=n_6847 VSS=VSS VDD=VDD
Xg117323__1617 NAND2X1 $PINS Z=n_7365 A=n_7138 B=n_6903 VSS=VSS VDD=VDD
Xg117324__2802 NOR2X1 $PINS Z=n_7364 A=n_7187 B=n_7193 VSS=VSS VDD=VDD
Xg117325__1705 OR2X1 $PINS Z=n_7363 A=n_7179 B=n_6952 VSS=VSS VDD=VDD
Xg117326__5122 NAND2X1 $PINS Z=n_7362 A=n_7197 B=n_6900 VSS=VSS VDD=VDD
Xg117327__8246 OR2X1 $PINS Z=n_7361 A=n_7073 B=n_6983 VSS=VSS VDD=VDD
Xg117328__7098 NAND2X1 $PINS Z=n_7360 A=n_6974 B=n_7186 VSS=VSS VDD=VDD
Xg117329__6131 NAND2X1 $PINS Z=n_7359 A=n_7186 B=n_6903 VSS=VSS VDD=VDD
Xg117330__1881 OR2X1 $PINS Z=n_7358 A=n_6955 B=n_7172 VSS=VSS VDD=VDD
Xg117331__5115 NAND3X1 $PINS Z=n_7357 A=n_7091 B=n_6938 C=n_6897 VSS=VSS
+ VDD=VDD
Xg117332__7482 NAND2X1 $PINS Z=n_7356 A=n_7075 B=n_6930 VSS=VSS VDD=VDD
Xg117333__4733 NAND3X1 $PINS Z=n_7355 A=n_7002 B=n_7024 C=n_6936 VSS=VSS
+ VDD=VDD
Xg117334__6161 OR2X1 $PINS Z=n_7354 A=n_7091 B=n_7192 VSS=VSS VDD=VDD
Xg117335__9315 OR2X1 $PINS Z=n_7353 A=n_6929 B=n_7179 VSS=VSS VDD=VDD
Xg117336__9945 OR2X1 $PINS Z=n_7352 A=n_7174 B=n_6994 VSS=VSS VDD=VDD
Xg117337__2883 NAND2X1 $PINS Z=n_7351 A=n_7092 B=n_7068 VSS=VSS VDD=VDD
Xg117338__2346 NOR2X1 $PINS Z=n_7350 A=n_6845 B=n_7161 VSS=VSS VDD=VDD
Xg117339__1666 AND2X1 $PINS Z=n_7349 A=n_7162 B=n_6924 VSS=VSS VDD=VDD
Xg117340__7410 NAND2X1 $PINS Z=n_7348 A=n_7105 B=n_7000 VSS=VSS VDD=VDD
Xg117341__6417 OR2X1 $PINS Z=n_7347 A=n_6998 B=n_7094 VSS=VSS VDD=VDD
Xg117342__5477 NAND2X1 $PINS Z=n_7346 A=n_7187 B=n_6903 VSS=VSS VDD=VDD
Xg117343__2398 OR2X1 $PINS Z=n_7345 A=n_7179 B=n_7101 VSS=VSS VDD=VDD
Xg117344__5107 OR2X1 $PINS Z=n_7344 A=n_6898 B=n_7168 VSS=VSS VDD=VDD
Xg117345__6260 NAND3X1 $PINS Z=n_7343 A=n_7002 B=n_7024 C=n_6888 VSS=VSS
+ VDD=VDD
Xg117346__4319 NAND2X1 $PINS Z=n_7342 A=n_7089 B=n_7007 VSS=VSS VDD=VDD
Xg117347__8428 NOR2X1 $PINS Z=n_7341 A=n_6920 B=n_7127 VSS=VSS VDD=VDD
Xg117348__5526 NAND2X1 $PINS Z=n_7451 A=n_7197 B=n_7185 VSS=VSS VDD=VDD
Xg117349__6783 NAND2X1 $PINS Z=n_7450 A=n_7107 B=n_7025 VSS=VSS VDD=VDD
Xg117350__3680 NAND2X1 $PINS Z=n_7448 A=n_7191 B=n_6887 VSS=VSS VDD=VDD
Xg117351__1617 NOR2X1 $PINS Z=n_7447 A=n_6891 B=n_7174 VSS=VSS VDD=VDD
Xg117352__2802 NAND2X1 $PINS Z=n_7446 A=n_6972 B=n_7169 VSS=VSS VDD=VDD
Xg117353__1705 NOR2X1 $PINS Z=n_7445 A=n_6869 B=n_7069 VSS=VSS VDD=VDD
Xg117354__5122 NOR2X1 $PINS Z=n_7444 A=n_6846 B=n_7204 VSS=VSS VDD=VDD
Xg117355__8246 AND2X1 $PINS Z=n_7442 A=n_6961 B=n_7184 VSS=VSS VDD=VDD
Xg117356__7098 OR2X1 $PINS Z=n_7441 A=n_6852 B=n_7170 VSS=VSS VDD=VDD
Xg117357__6131 NOR2X1 $PINS Z=n_7440 A=n_6872 B=n_7114 VSS=VSS VDD=VDD
Xg117358__1881 OR2X1 $PINS Z=n_7439 A=n_7183 B=n_7217 VSS=VSS VDD=VDD
Xg117359__5115 NAND2X1 $PINS Z=n_7438 A=n_7193 B=n_6930 VSS=VSS VDD=VDD
Xg117360__7482 NAND2X1 $PINS Z=n_7437 A=n_7185 B=n_6925 VSS=VSS VDD=VDD
Xg117361__4733 NAND2X1 $PINS Z=n_7436 A=n_7168 B=n_7194 VSS=VSS VDD=VDD
Xg117362__6161 NOR2X1 $PINS Z=n_7434 A=n_6887 B=n_7190 VSS=VSS VDD=VDD
Xg117363 INVX2 $PINS Z=n_7337 A=n_7336 VSS=VSS VDD=VDD
Xg117364 INVX2 $PINS Z=n_7335 A=n_7334 VSS=VSS VDD=VDD
Xg117365 INVX2 $PINS Z=n_7332 A=n_7331 VSS=VSS VDD=VDD
Xg117366 INVX2 $PINS Z=n_7329 A=n_7328 VSS=VSS VDD=VDD
Xg117368 INVX2 $PINS Z=n_7320 A=n_7321 VSS=VSS VDD=VDD
Xg117370 INVX2 $PINS Z=n_7316 A=n_7317 VSS=VSS VDD=VDD
Xg117372 INVX2 $PINS Z=n_7312 A=n_7313 VSS=VSS VDD=VDD
Xg117373 INVX2 $PINS Z=n_7310 A=n_7311 VSS=VSS VDD=VDD
Xg117374 INVX2 $PINS Z=n_7308 A=n_7309 VSS=VSS VDD=VDD
Xg117375__9315 NAND3X1 $PINS Z=n_7307 A=n_7150 B=n_6937 C=n_6874 VSS=VSS
+ VDD=VDD
Xg117376__9945 NAND2X1 $PINS Z=n_7306 A=n_7171 B=n_6896 VSS=VSS VDD=VDD
Xg117377__2883 NAND2X1 $PINS Z=n_7305 A=n_7165 B=n_6977 VSS=VSS VDD=VDD
Xg117378__2346 NOR2X1 $PINS Z=n_7304 A=n_6970 B=n_7172 VSS=VSS VDD=VDD
Xg117379__1666 NAND2X1 $PINS Z=n_7303 A=n_7171 B=n_6846 VSS=VSS VDD=VDD
Xg117380__7410 NAND2X1 $PINS Z=n_7302 A=n_7212 B=n_7072 VSS=VSS VDD=VDD
Xg117381__6417 NAND2X1 $PINS Z=n_7301 A=n_7068 B=n_6978 VSS=VSS VDD=VDD
Xg117382__5477 NAND2X1 $PINS Z=n_7300 A=n_7168 B=n_7137 VSS=VSS VDD=VDD
Xg117383__2398 NAND2X1 $PINS Z=n_7299 A=n_7015 B=n_7095 VSS=VSS VDD=VDD
Xg117384__5107 NOR2X1 $PINS Z=n_7298 A=n_6846 B=n_7207 VSS=VSS VDD=VDD
Xg117385__6260 NAND3X1 $PINS Z=n_7297 A=n_7009 B=n_7195 C=n_6867 VSS=VSS
+ VDD=VDD
Xg117386__4319 NAND2X1 $PINS Z=n_7296 A=n_7118 B=n_7077 VSS=VSS VDD=VDD
Xg117387__8428 NAND2X1 $PINS Z=n_7295 A=n_7104 B=n_7162 VSS=VSS VDD=VDD
Xg117388__5526 MUX2X1 $PINS Z=n_7294 A=n_7002 B=n_7020 S=n_7009 VSS=VSS VDD=VDD
Xg117389__6783 OR2X1 $PINS Z=n_7293 A=n_6884 B=n_7184 VSS=VSS VDD=VDD
Xg117390__3680 NOR2X1 $PINS Z=n_7292 A=n_6924 B=n_7104 VSS=VSS VDD=VDD
Xg117391__1617 NAND2X1 $PINS Z=n_7291 A=n_7071 B=n_6882 VSS=VSS VDD=VDD
Xg117392__2802 NAND2X1 $PINS Z=n_7290 A=n_7015 B=n_7167 VSS=VSS VDD=VDD
Xg117393__1705 NAND3X1 $PINS Z=n_7289 A=n_7045 B=n_6946 C=n_6870 VSS=VSS
+ VDD=VDD
Xg117394__5122 NAND2X1 $PINS Z=n_7288 A=n_7118 B=n_7068 VSS=VSS VDD=VDD
Xg117395__8246 NAND3X1 $PINS Z=n_7287 A=n_7167 B=n_6895 C=n_6856 VSS=VSS
+ VDD=VDD
Xg117396__7098 OR2X1 $PINS Z=n_7286 A=n_6971 B=n_7182 VSS=VSS VDD=VDD
Xg117397__6131 NAND2X1 $PINS Z=n_7285 A=n_7162 B=n_6884 VSS=VSS VDD=VDD
Xg117398__1881 NAND2X1 $PINS Z=n_7284 A=n_7120 B=n_7046 VSS=VSS VDD=VDD
Xg117399__5115 NAND2X1 $PINS Z=n_7283 A=n_7043 B=n_7037 VSS=VSS VDD=VDD
Xg117400__7482 NAND3X1 $PINS Z=n_7282 A=n_7201 B=n_6996 C=n_6854 VSS=VSS
+ VDD=VDD
Xg117401__4733 OR2X1 $PINS Z=n_7281 A=n_6997 B=n_7106 VSS=VSS VDD=VDD
Xg117402__6161 OR2X1 $PINS Z=n_7280 A=n_6846 B=n_7192 VSS=VSS VDD=VDD
Xg117403__9315 NAND2X1 $PINS Z=n_7279 A=n_7176 B=n_6847 VSS=VSS VDD=VDD
Xg117404__9945 AND2X1 $PINS Z=n_7278 A=n_7068 B=n_6965 VSS=VSS VDD=VDD
Xg117405__2883 NAND3X1 $PINS Z=n_7277 A=n_7203 B=n_6932 C=n_6856 VSS=VSS
+ VDD=VDD
Xg117406__2346 OR2X1 $PINS Z=n_7276 A=n_6995 B=n_7200 VSS=VSS VDD=VDD
Xg117407__1666 OR2X1 $PINS Z=n_7275 A=n_6966 B=n_7119 VSS=VSS VDD=VDD
Xg117408__7410 NOR2X1 $PINS Z=n_7274 A=n_6910 B=n_7080 VSS=VSS VDD=VDD
Xg117409__6417 NAND2X1 $PINS Z=n_7273 A=n_7082 B=n_6850 VSS=VSS VDD=VDD
Xg117410__5477 OR2X1 $PINS Z=n_7272 A=n_6967 B=n_7121 VSS=VSS VDD=VDD
Xg117411__2398 NOR2X1 $PINS Z=n_7271 A=n_6892 B=n_7106 VSS=VSS VDD=VDD
Xg117412__5107 AND2X1 $PINS Z=n_7270 A=n_7081 B=n_6947 VSS=VSS VDD=VDD
Xg117413__6260 NAND3X1 $PINS Z=n_7269 A=n_7180 B=n_6846 C=n_6915 VSS=VSS
+ VDD=VDD
Xg117414__4319 NAND2X1 $PINS Z=n_7268 A=n_7073 B=n_6867 VSS=VSS VDD=VDD
Xg117415__8428 NAND2X1 $PINS Z=n_7267 A=n_6952 B=n_7074 VSS=VSS VDD=VDD
Xg117416__5526 OR2X1 $PINS Z=n_7266 A=n_6876 B=n_7079 VSS=VSS VDD=VDD
Xg117417__6783 NAND2X1 $PINS Z=n_7265 A=n_7077 B=n_6850 VSS=VSS VDD=VDD
Xg117418__3680 NAND3X1 $PINS Z=n_7264 A=n_7016 B=n_7169 C=n_6852 VSS=VSS
+ VDD=VDD
Xg117419__1617 NAND2X1 $PINS Z=n_7263 A=n_7121 B=n_7076 VSS=VSS VDD=VDD
Xg117420__2802 NAND3X1 $PINS Z=n_7262 A=n_7162 B=n_6925 C=n_6845 VSS=VSS
+ VDD=VDD
Xg117421__1705 NOR2X1 $PINS Z=n_7261 A=n_6947 B=n_7034 VSS=VSS VDD=VDD
Xg117422__5122 NAND2X1 $PINS Z=n_7260 A=n_7079 B=n_6958 VSS=VSS VDD=VDD
Xg117423__8246 OR2X1 $PINS Z=n_7259 A=n_6958 B=n_7078 VSS=VSS VDD=VDD
Xg117425__6131 AND2X1 $PINS Z=n_7257 A=n_7083 B=n_6945 VSS=VSS VDD=VDD
Xg117426__1881 OR2X1 $PINS Z=n_7256 A=n_6955 B=n_7163 VSS=VSS VDD=VDD
Xg117427__5115 NAND3X1 $PINS Z=n_7255 A=n_6995 B=n_7027 C=n_6911 VSS=VSS
+ VDD=VDD
Xg117428__7482 NAND2X1 $PINS Z=n_7254 A=n_7208 B=n_6955 VSS=VSS VDD=VDD
Xg117429__4733 NAND3X1 $PINS Z=n_7253 A=n_7086 B=n_6996 C=n_6865 VSS=VSS
+ VDD=VDD
Xg117430__6161 NAND3X1 $PINS Z=n_7252 A=n_7013 B=n_6979 C=n_6858 VSS=VSS
+ VDD=VDD
Xg117431__9315 OR2X1 $PINS Z=n_7251 A=n_6992 B=n_7116 VSS=VSS VDD=VDD
Xg117432__9945 OR2X1 $PINS Z=n_7250 A=n_7176 B=n_7192 VSS=VSS VDD=VDD
Xg117433__2883 NAND3X1 $PINS Z=n_7249 A=n_6923 B=n_6903 C=n_6943 VSS=VSS
+ VDD=VDD
Xg117434__2346 NAND3X1 $PINS Z=n_7248 A=n_7201 B=n_7019 C=n_6854 VSS=VSS
+ VDD=VDD
Xg117435__1666 NAND2X1 $PINS Z=n_7247 A=n_7187 B=n_6878 VSS=VSS VDD=VDD
Xg117436__7410 NAND2X1 $PINS Z=n_7246 A=n_6960 B=n_7186 VSS=VSS VDD=VDD
Xg117437__6417 AND2X1 $PINS Z=n_7245 A=n_6948 B=n_7173 VSS=VSS VDD=VDD
Xg117438__5477 NAND2X1 $PINS Z=n_7244 A=n_7182 B=n_6897 VSS=VSS VDD=VDD
Xg117439__2398 OR2X1 $PINS Z=n_7243 A=n_6905 B=n_7120 VSS=VSS VDD=VDD
Xg117440__5107 MUX2X1 $PINS Z=n_7242 A=n_6847 B=n_6968 S=n_6942 VSS=VSS VDD=VDD
Xg117441__6260 NAND2X1 $PINS Z=n_7241 A=n_7095 B=n_6856 VSS=VSS VDD=VDD
Xg117442__4319 NAND2X1 $PINS Z=n_7240 A=n_7024 B=n_7073 VSS=VSS VDD=VDD
Xg117443__8428 NAND3X1 $PINS Z=n_7239 A=n_6960 B=n_6902 C=n_6944 VSS=VSS
+ VDD=VDD
Xg117444__5526 NAND2X1 $PINS Z=n_7238 A=n_7024 B=n_7178 VSS=VSS VDD=VDD
Xg117445__6783 NAND3X1 $PINS Z=n_7237 A=n_7025 B=n_6866 C=n_6937 VSS=VSS
+ VDD=VDD
Xg117446__3680 NAND3X1 $PINS Z=n_7236 A=n_7178 B=n_6866 C=n_6873 VSS=VSS
+ VDD=VDD
Xg117447__1617 OR2X1 $PINS Z=n_7235 A=n_6861 B=n_7075 VSS=VSS VDD=VDD
Xg117448__2802 NAND2X1 $PINS Z=n_7234 A=n_7075 B=n_6879 VSS=VSS VDD=VDD
Xg117449__1705 NAND3X1 $PINS Z=n_7233 A=n_7171 B=n_6973 C=n_6915 VSS=VSS
+ VDD=VDD
Xg117450__5122 NAND3X1 $PINS Z=n_7232 A=n_6996 B=n_6947 C=n_6871 VSS=VSS
+ VDD=VDD
Xg117451__8246 NAND3X1 $PINS Z=n_7231 A=n_7087 B=n_6995 C=n_6855 VSS=VSS
+ VDD=VDD
Xg117452__7098 NAND3X1 $PINS Z=n_7230 A=n_6997 B=n_6963 C=n_6871 VSS=VSS
+ VDD=VDD
Xg117453__6131 NAND3X1 $PINS Z=n_7229 A=n_7201 B=n_7019 C=n_6962 VSS=VSS
+ VDD=VDD
Xg117454__1881 NAND3X1 $PINS Z=n_7228 A=n_7213 B=n_6927 C=n_6853 VSS=VSS
+ VDD=VDD
Xg117455__5115 NAND3X1 $PINS Z=n_7227 A=n_6925 B=n_6941 C=n_6885 VSS=VSS
+ VDD=VDD
Xg117456__7482 NAND3X1 $PINS Z=n_7226 A=n_6957 B=n_6995 C=n_6865 VSS=VSS
+ VDD=VDD
Xg117457__4733 NAND3X1 $PINS Z=n_7225 A=n_7186 B=n_6903 C=n_6879 VSS=VSS
+ VDD=VDD
Xg117458__6161 NAND3X1 $PINS Z=n_7224 A=n_7163 B=n_6955 C=n_6887 VSS=VSS
+ VDD=VDD
Xg117459__9315 NAND3X1 $PINS Z=n_7223 A=n_7068 B=n_6950 C=n_6851 VSS=VSS
+ VDD=VDD
Xg117460__9945 NAND3X1 $PINS Z=n_7222 A=n_6967 B=n_6935 C=n_6869 VSS=VSS
+ VDD=VDD
Xg117461__2883 NAND3X1 $PINS Z=n_7340 A=n_6951 B=n_7166 C=n_6861 VSS=VSS
+ VDD=VDD
Xg117462__2346 NOR2X1 $PINS Z=n_7339 A=n_6940 B=n_7113 VSS=VSS VDD=VDD
Xg117463__1666 NAND2X1 $PINS Z=n_7338 A=n_7182 B=n_6971 VSS=VSS VDD=VDD
Xg117464__7410 NAND2X1 $PINS Z=n_7336 A=n_7173 B=n_6852 VSS=VSS VDD=VDD
Xg117465__6417 NOR2X1 $PINS Z=n_7334 A=n_6861 B=n_7186 VSS=VSS VDD=VDD
Xg117466__5477 NOR2X1 $PINS Z=n_7333 A=n_7208 B=n_7182 VSS=VSS VDD=VDD
Xg117467__2398 NOR2X1 $PINS Z=n_7331 A=n_6956 B=n_7081 VSS=VSS VDD=VDD
Xg117468__5107 NAND3X1 $PINS Z=n_7330 A=n_6935 B=n_6905 C=n_6877 VSS=VSS
+ VDD=VDD
Xg117469__6260 NAND2X1 $PINS Z=n_7328 A=n_7069 B=n_7077 VSS=VSS VDD=VDD
Xg117470__4319 NOR2X1 $PINS Z=n_7327 A=n_6850 B=n_7077 VSS=VSS VDD=VDD
Xg117471__8428 NAND3X1 $PINS Z=n_7325 A=n_7195 B=n_6873 C=n_6874 VSS=VSS
+ VDD=VDD
Xg117472__5526 MUX2X1 $PINS Z=n_7324 A=n_6891 B=n_7016 S=n_6853 VSS=VSS VDD=VDD
Xg117473__6783 AND2X1 $PINS Z=n_7323 A=n_7082 B=n_6851 VSS=VSS VDD=VDD
Xg117474__3680 NAND2X1 $PINS Z=n_7322 A=n_7075 B=n_6878 VSS=VSS VDD=VDD
Xg117475__1617 XOR2X1 $PINS Z=n_7321 A=n_6844 B=n_6940 VSS=VSS VDD=VDD
Xg117476__2802 XOR2X1 $PINS Z=n_7319 A=n_6933 B=n_6857 VSS=VSS VDD=VDD
Xg117477__1705 OR2X1 $PINS Z=n_7317 A=n_7066 B=n_7075 VSS=VSS VDD=VDD
Xg117478__5122 XOR2X1 $PINS Z=n_7315 A=n_6860 B=n_6929 VSS=VSS VDD=VDD
Xg117479__8246 NAND2X1 $PINS Z=n_7313 A=n_7164 B=n_7176 VSS=VSS VDD=VDD
Xg117480__7098 NOR2X1 $PINS Z=n_7311 A=n_7185 B=n_7162 VSS=VSS VDD=VDD
Xg117481__6131 NOR2X1 $PINS Z=n_7309 A=n_7178 B=n_7073 VSS=VSS VDD=VDD
Xg117483 INVX2 $PINS Z=n_7216 A=n_7215 VSS=VSS VDD=VDD
Xg117484 INVX2 $PINS Z=n_7213 A=n_7214 VSS=VSS VDD=VDD
Xg117485 INVX2 $PINS Z=n_7208 A=n_7207 VSS=VSS VDD=VDD
Xg117486 INVX2 $PINS Z=n_7205 A=n_7206 VSS=VSS VDD=VDD
Xg117487 INVX2 $PINS Z=n_7201 A=n_7200 VSS=VSS VDD=VDD
Xg117488 INVX2 $PINS Z=n_7199 A=n_7198 VSS=VSS VDD=VDD
Xg117489 INVX2 $PINS Z=n_7196 A=n_7195 VSS=VSS VDD=VDD
Xg117490 INVX2 $PINS Z=n_7190 A=n_7191 VSS=VSS VDD=VDD
Xg117491 INVX2 $PINS Z=n_7189 A=n_7188 VSS=VSS VDD=VDD
Xg117492 INVX2 $PINS Z=n_7183 A=n_7184 VSS=VSS VDD=VDD
Xg117493 INVX2 $PINS Z=n_7180 A=n_7181 VSS=VSS VDD=VDD
Xg117494 INVX2 $PINS Z=n_7177 A=n_7178 VSS=VSS VDD=VDD
Xg117495 INVX2 $PINS Z=n_7175 A=n_7176 VSS=VSS VDD=VDD
Xg117496 INVX2 $PINS Z=n_7173 A=n_7174 VSS=VSS VDD=VDD
Xg117497 INVX2 $PINS Z=n_7171 A=n_7172 VSS=VSS VDD=VDD
Xg117498 INVX2 $PINS Z=n_7169 A=n_7170 VSS=VSS VDD=VDD
Xg117499 INVX2 $PINS Z=n_7167 A=n_7168 VSS=VSS VDD=VDD
Xg117500 INVX2 $PINS Z=n_7165 A=n_7166 VSS=VSS VDD=VDD
Xg117501 INVX2 $PINS Z=n_7163 A=n_7164 VSS=VSS VDD=VDD
Xg117502 INVX2 $PINS Z=n_7161 A=n_7162 VSS=VSS VDD=VDD
Xg117503__1881 NOR2X1 $PINS Z=n_7160 A=n_6883 B=n_7022 VSS=VSS VDD=VDD
Xg117504__5115 NAND2X1 $PINS Z=n_7159 A=n_7022 B=n_6859 VSS=VSS VDD=VDD
Xg117505__7482 NAND2X1 $PINS Z=n_7158 A=n_7006 B=n_6933 VSS=VSS VDD=VDD
Xg117506__4733 AND2X1 $PINS Z=n_7157 A=n_7002 B=n_7025 VSS=VSS VDD=VDD
Xg117507__6161 NAND2X1 $PINS Z=n_7156 A=n_7007 B=n_6932 VSS=VSS VDD=VDD
Xg117508__9315 NOR2X1 $PINS Z=n_7155 A=n_6858 B=n_7022 VSS=VSS VDD=VDD
Xg117509__9945 NAND2X1 $PINS Z=n_7154 A=n_7003 B=n_6848 VSS=VSS VDD=VDD
Xg117510__2883 NAND2X1 $PINS Z=n_7153 A=n_7023 B=n_6894 VSS=VSS VDD=VDD
Xg117511__2346 NAND2X1 $PINS Z=n_7152 A=n_6848 B=n_6936 VSS=VSS VDD=VDD
Xg117512__1666 NAND2X1 $PINS Z=n_7151 A=n_6848 B=n_6986 VSS=VSS VDD=VDD
Xg117513__7410 OR2X1 $PINS Z=n_7150 A=n_6848 B=n_7002 VSS=VSS VDD=VDD
Xg117514__6417 OR2X1 $PINS Z=n_7149 A=n_6862 B=n_7014 VSS=VSS VDD=VDD
Xg117515__5477 NOR2X1 $PINS Z=n_7148 A=n_6932 B=n_6863 VSS=VSS VDD=VDD
Xg117516__2398 NAND2X1 $PINS Z=n_7147 A=n_7015 B=n_6909 VSS=VSS VDD=VDD
Xg117517__5107 AND2X1 $PINS Z=n_7146 A=n_6961 B=n_6916 VSS=VSS VDD=VDD
Xg117518__6260 NAND2X1 $PINS Z=n_7145 A=n_6918 B=n_6848 VSS=VSS VDD=VDD
Xg117519__4319 NOR2X1 $PINS Z=n_7144 A=n_6991 B=n_7029 VSS=VSS VDD=VDD
Xg117520__8428 NOR2X1 $PINS Z=n_7143 A=n_6847 B=n_6939 VSS=VSS VDD=VDD
Xg117521__5526 NAND2X1 $PINS Z=n_7142 A=n_7021 B=n_6940 VSS=VSS VDD=VDD
Xg117522__6783 NAND2X1 $PINS Z=n_7141 A=n_6961 B=n_6845 VSS=VSS VDD=VDD
Xg117523__3680 AND2X1 $PINS Z=n_7140 A=n_6972 B=n_6859 VSS=VSS VDD=VDD
Xg117524__1617 NAND2X1 $PINS Z=n_7139 A=n_7031 B=n_6908 VSS=VSS VDD=VDD
Xg117525__2802 NAND2X1 $PINS Z=n_7138 A=n_6959 B=n_6943 VSS=VSS VDD=VDD
Xg117526__1705 NAND2X1 $PINS Z=n_7137 A=n_6895 B=n_6932 VSS=VSS VDD=VDD
Xg117527__5122 NOR2X1 $PINS Z=n_7136 A=n_6936 B=n_6873 VSS=VSS VDD=VDD
Xg117528__8246 NAND2X1 $PINS Z=n_7135 A=n_7010 B=n_6852 VSS=VSS VDD=VDD
Xg117530__6131 NAND2X1 $PINS Z=n_7133 A=n_7015 B=n_6933 VSS=VSS VDD=VDD
Xg117531__1881 NAND2X1 $PINS Z=n_7132 A=n_7026 B=n_6853 VSS=VSS VDD=VDD
Xg117532__5115 NAND2X1 $PINS Z=n_7131 A=n_7019 B=n_7027 VSS=VSS VDD=VDD
Xg117533__7482 NOR2X1 $PINS Z=n_7130 A=n_6851 B=n_6935 VSS=VSS VDD=VDD
Xg117534__4733 NAND2X1 $PINS Z=n_7129 A=n_6998 B=n_7007 VSS=VSS VDD=VDD
Xg117535__6161 NAND2X1 $PINS Z=n_7128 A=n_7005 B=n_6925 VSS=VSS VDD=VDD
Xg117536__9315 AND2X1 $PINS Z=n_7127 A=n_6976 B=n_7030 VSS=VSS VDD=VDD
Xg117537__9945 NAND2X1 $PINS Z=n_7126 A=n_6947 B=n_6912 VSS=VSS VDD=VDD
Xg117538__2883 NAND2X1 $PINS Z=n_7125 A=n_6891 B=n_6927 VSS=VSS VDD=VDD
Xg117539__2346 NAND2X1 $PINS Z=n_7124 A=n_6964 B=n_6935 VSS=VSS VDD=VDD
Xg117540__1666 NOR2X1 $PINS Z=n_7220 A=n_6887 B=n_6969 VSS=VSS VDD=VDD
Xg117541__7410 NAND2X1 $PINS Z=n_7219 A=n_7021 B=n_6925 VSS=VSS VDD=VDD
Xg117542__6417 AND2X1 $PINS Z=n_7218 A=n_7001 B=n_6890 VSS=VSS VDD=VDD
Xg117543__5477 OR2X1 $PINS Z=n_7217 A=n_6916 B=n_6940 VSS=VSS VDD=VDD
Xg117544__2398 NAND2X1 $PINS Z=n_7215 A=n_6937 B=n_6889 VSS=VSS VDD=VDD
Xg117545__5107 NAND2X1 $PINS Z=n_7214 A=n_7001 B=n_6891 VSS=VSS VDD=VDD
Xg117546__6260 AND2X1 $PINS Z=n_7212 A=n_7002 B=n_7008 VSS=VSS VDD=VDD
Xg117547__4319 NOR2X1 $PINS Z=n_7211 A=n_6844 B=n_6940 VSS=VSS VDD=VDD
Xg117548__8428 OR2X1 $PINS Z=n_7210 A=n_6979 B=n_7012 VSS=VSS VDD=VDD
Xg117549__5526 AND2X1 $PINS Z=n_7209 A=n_7014 B=n_6863 VSS=VSS VDD=VDD
Xg117550__6783 NAND2X1 $PINS Z=n_7207 A=n_6942 B=n_6886 VSS=VSS VDD=VDD
Xg117551__3680 NOR2X1 $PINS Z=n_7206 A=n_6849 B=n_7009 VSS=VSS VDD=VDD
Xg117552__1617 NAND2X1 $PINS Z=n_7204 A=n_6939 B=n_6915 VSS=VSS VDD=VDD
Xg117553__2802 OR2X1 $PINS Z=n_7203 A=n_7031 B=n_7015 VSS=VSS VDD=VDD
Xg117554__1705 NAND2X1 $PINS Z=n_7202 A=n_6958 B=n_6868 VSS=VSS VDD=VDD
Xg117555__5122 NOR2X1 $PINS Z=n_7200 A=n_7027 B=n_7029 VSS=VSS VDD=VDD
Xg117556__8246 NAND2X1 $PINS Z=n_7198 A=n_6938 B=n_6914 VSS=VSS VDD=VDD
Xg117557__7098 NOR2X1 $PINS Z=n_7197 A=n_6885 B=n_6925 VSS=VSS VDD=VDD
Xg117558__6131 NOR2X1 $PINS Z=n_7195 A=n_6889 B=n_6937 VSS=VSS VDD=VDD
Xg117559__1881 NAND2X1 $PINS Z=n_7194 A=n_6932 B=n_6908 VSS=VSS VDD=VDD
Xg117560__5115 NOR2X1 $PINS Z=n_7193 A=n_6944 B=n_6860 VSS=VSS VDD=VDD
Xg117561__7482 OR2X1 $PINS Z=n_7192 A=n_6942 B=n_6975 VSS=VSS VDD=VDD
Xg117562__4733 NOR2X1 $PINS Z=n_7191 A=n_6897 B=n_6942 VSS=VSS VDD=VDD
Xg117563__6161 NAND2X1 $PINS Z=n_7188 A=n_6961 B=n_6925 VSS=VSS VDD=VDD
Xg117564__9315 NOR2X1 $PINS Z=n_7187 A=n_6943 B=n_6931 VSS=VSS VDD=VDD
Xg117565__9945 NOR2X1 $PINS Z=n_7186 A=n_6944 B=n_6930 VSS=VSS VDD=VDD
Xg117566__2883 AND2X1 $PINS Z=n_7185 A=n_6941 B=n_6916 VSS=VSS VDD=VDD
Xg117567__2346 NOR2X1 $PINS Z=n_7184 A=n_6845 B=n_6925 VSS=VSS VDD=VDD
Xg117568__1666 NOR2X1 $PINS Z=n_7182 A=n_6886 B=n_6942 VSS=VSS VDD=VDD
Xg117569__7410 NAND2X1 $PINS Z=n_7181 A=n_6976 B=n_6942 VSS=VSS VDD=VDD
Xg117570__6417 NAND2X1 $PINS Z=n_7179 A=n_6930 B=n_6943 VSS=VSS VDD=VDD
Xg117571__5477 NOR2X1 $PINS Z=n_7178 A=n_6888 B=n_6937 VSS=VSS VDD=VDD
Xg117572__2398 NAND2X1 $PINS Z=n_7176 A=n_6938 B=n_6915 VSS=VSS VDD=VDD
Xg117573__5107 NAND2X1 $PINS Z=n_7174 A=n_6926 B=n_6859 VSS=VSS VDD=VDD
Xg117574__6260 NAND2X1 $PINS Z=n_7172 A=n_6942 B=n_6887 VSS=VSS VDD=VDD
Xg117575__4319 NAND2X1 $PINS Z=n_7170 A=n_6926 B=n_6858 VSS=VSS VDD=VDD
Xg117576__8428 NAND2X1 $PINS Z=n_7168 A=n_6933 B=n_6909 VSS=VSS VDD=VDD
Xg117577__5526 NAND2X1 $PINS Z=n_7166 A=n_6931 B=n_6944 VSS=VSS VDD=VDD
Xg117578__6783 NAND2X1 $PINS Z=n_7164 A=n_6939 B=n_6914 VSS=VSS VDD=VDD
Xg117579__3680 NOR2X1 $PINS Z=n_7162 A=n_6916 B=n_6941 VSS=VSS VDD=VDD
Xg117580 INVX2 $PINS Z=n_7112 A=n_7111 VSS=VSS VDD=VDD
Xg117581 INVX2 $PINS Z=n_7108 A=n_7109 VSS=VSS VDD=VDD
Xg117582 INVX2 $PINS Z=n_7103 A=n_7102 VSS=VSS VDD=VDD
Xg117583 INVX2 $PINS Z=n_7097 A=n_7096 VSS=VSS VDD=VDD
Xg117584 INVX2 $PINS Z=n_7094 A=n_7095 VSS=VSS VDD=VDD
Xg117585 INVX2 $PINS Z=n_7090 A=n_7091 VSS=VSS VDD=VDD
Xg117586 INVX2 $PINS Z=n_7087 A=n_7086 VSS=VSS VDD=VDD
Xg117587 INVX2 $PINS Z=n_7084 A=n_7085 VSS=VSS VDD=VDD
Xg117588 INVX2 $PINS Z=n_7080 A=n_7081 VSS=VSS VDD=VDD
Xg117589 INVX2 $PINS Z=n_7078 A=n_7079 VSS=VSS VDD=VDD
Xg117590 INVX2 $PINS Z=n_7076 A=n_7077 VSS=VSS VDD=VDD
Xg117591 INVX2 $PINS Z=n_7074 A=n_7075 VSS=VSS VDD=VDD
Xg117592 INVX2 $PINS Z=n_7072 A=n_7073 VSS=VSS VDD=VDD
Xg117593 INVX2 $PINS Z=n_7070 A=n_7071 VSS=VSS VDD=VDD
Xg117594 INVX2 $PINS Z=n_7068 A=n_7069 VSS=VSS VDD=VDD
Xg117595__1617 NOR2X1 $PINS Z=n_7067 A=n_6864 B=n_6962 VSS=VSS VDD=VDD
Xg117596__2802 NOR2X1 $PINS Z=n_7066 A=n_6929 B=n_6902 VSS=VSS VDD=VDD
Xg117597__1705 NAND2X1 $PINS Z=n_7065 A=n_6974 B=n_6928 VSS=VSS VDD=VDD
Xg117598__5122 OR2X1 $PINS Z=n_7064 A=n_6921 B=n_7001 VSS=VSS VDD=VDD
Xg117599__8246 NAND3X1 $PINS Z=n_7063 A=n_6995 B=n_6854 C=n_6865 VSS=VSS
+ VDD=VDD
Xg117600__7098 NAND2X1 $PINS Z=n_7062 A=n_6958 B=n_6935 VSS=VSS VDD=VDD
Xg117601__6131 NOR2X1 $PINS Z=n_7061 A=n_6850 B=n_6935 VSS=VSS VDD=VDD
Xg117602__1881 OR2X1 $PINS Z=n_7060 A=n_6933 B=n_7014 VSS=VSS VDD=VDD
Xg117603__5115 MUX2X1 $PINS Z=n_7059 A=n_6910 B=n_6855 S=n_6871 VSS=VSS VDD=VDD
Xg117604__7482 OR2X1 $PINS Z=n_7058 A=n_6905 B=n_6950 VSS=VSS VDD=VDD
Xg117605__4733 NAND2X1 $PINS Z=n_7057 A=n_6861 B=n_6931 VSS=VSS VDD=VDD
Xg117606__6161 NAND2X1 $PINS Z=n_7056 A=n_6951 B=n_6931 VSS=VSS VDD=VDD
Xg117607__9315 NAND2X1 $PINS Z=n_7055 A=n_6969 B=n_6886 VSS=VSS VDD=VDD
Xg117608__9945 NOR2X1 $PINS Z=n_7054 A=n_6928 B=n_6952 VSS=VSS VDD=VDD
Xg117609__2883 NAND2X1 $PINS Z=n_7053 A=n_6994 B=n_6926 VSS=VSS VDD=VDD
Xg117610__2346 NAND2X1 $PINS Z=n_7052 A=n_6994 B=n_6882 VSS=VSS VDD=VDD
Xg117611__1666 MUX2X1 $PINS Z=n_7051 A=n_6853 B=n_6883 S=n_6859 VSS=VSS VDD=VDD
Xg117612__7410 NOR2X1 $PINS Z=n_7050 A=n_6988 B=n_7010 VSS=VSS VDD=VDD
Xg117613__6417 NAND2X1 $PINS Z=n_7049 A=n_6948 B=n_6926 VSS=VSS VDD=VDD
Xg117614__5477 NAND2X1 $PINS Z=n_7048 A=n_6945 B=n_6905 VSS=VSS VDD=VDD
Xg117615__2398 NAND2X1 $PINS Z=n_7047 A=n_6945 B=n_6907 VSS=VSS VDD=VDD
Xg117616__5107 NAND2X1 $PINS Z=n_7046 A=n_6945 B=n_6851 VSS=VSS VDD=VDD
Xg117617__6260 NAND2X1 $PINS Z=n_7045 A=n_6956 B=n_6864 VSS=VSS VDD=VDD
Xg117618__4319 NAND2X1 $PINS Z=n_7044 A=n_6922 B=n_6906 VSS=VSS VDD=VDD
Xg117619__8428 NAND2X1 $PINS Z=n_7043 A=n_6996 B=n_6855 VSS=VSS VDD=VDD
Xg117620__5526 NAND2X1 $PINS Z=n_7042 A=n_6997 B=n_6957 VSS=VSS VDD=VDD
Xg117621__6783 NAND3X1 $PINS Z=n_7041 A=n_6924 B=n_6845 C=n_6916 VSS=VSS
+ VDD=VDD
Xg117622__3680 NAND2X1 $PINS Z=n_7040 A=n_6965 B=n_6877 VSS=VSS VDD=VDD
Xg117623__1617 NAND3X1 $PINS Z=n_7039 A=n_7000 B=n_6855 C=n_6893 VSS=VSS
+ VDD=VDD
Xg117624__2802 NAND2X1 $PINS Z=n_7038 A=n_6949 B=n_6851 VSS=VSS VDD=VDD
Xg117625__1705 NAND2X1 $PINS Z=n_7037 A=n_6947 B=n_6995 VSS=VSS VDD=VDD
Xg117626__5122 NAND2X1 $PINS Z=n_7036 A=n_6995 B=n_6954 VSS=VSS VDD=VDD
Xg117627__8246 OR2X1 $PINS Z=n_7035 A=n_6953 B=n_6966 VSS=VSS VDD=VDD
Xg117628__7098 NOR2X1 $PINS Z=n_7034 A=n_6865 B=n_6966 VSS=VSS VDD=VDD
Xg117629__6131 NAND2X1 $PINS Z=n_7033 A=n_6954 B=n_6911 VSS=VSS VDD=VDD
Xg117630__1881 OR2X1 $PINS Z=n_7123 A=n_6981 B=n_6998 VSS=VSS VDD=VDD
Xg117631__5115 NAND3X1 $PINS Z=n_7122 A=n_6945 B=n_6850 C=n_6907 VSS=VSS
+ VDD=VDD
Xg117632__7482 AND2X1 $PINS Z=n_7121 A=n_6945 B=n_6906 VSS=VSS VDD=VDD
Xg117633__4733 NAND2X1 $PINS Z=n_7120 A=n_6965 B=n_6964 VSS=VSS VDD=VDD
Xg117634__6161 NAND2X1 $PINS Z=n_7119 A=n_6954 B=n_6893 VSS=VSS VDD=VDD
Xg117635__9315 AND2X1 $PINS Z=n_7118 A=n_6958 B=n_6876 VSS=VSS VDD=VDD
Xg117636__9945 NAND3X1 $PINS Z=n_7117 A=n_6881 B=n_6883 C=n_6852 VSS=VSS
+ VDD=VDD
Xg117637__2883 NAND2X1 $PINS Z=n_7116 A=n_6954 B=n_6892 VSS=VSS VDD=VDD
Xg117638__2346 NAND3X1 $PINS Z=n_7115 A=n_6925 B=n_6885 C=n_6916 VSS=VSS
+ VDD=VDD
Xg117639__1666 NAND2X1 $PINS Z=n_7032 A=n_6861 B=n_6928 VSS=VSS VDD=VDD
Xg117640__7410 NAND3X1 $PINS Z=n_7114 A=n_6867 B=n_6849 C=n_6874 VSS=VSS
+ VDD=VDD
Xg117641__6417 NOR2X1 $PINS Z=n_7113 A=n_6985 B=n_7021 VSS=VSS VDD=VDD
Xg117642__5477 XOR2X1 $PINS Z=n_7111 A=n_6889 B=n_6873 VSS=VSS VDD=VDD
Xg117643__2398 AND2X1 $PINS Z=n_7110 A=n_7014 B=n_6856 VSS=VSS VDD=VDD
Xg117644__5107 XOR2X1 $PINS Z=n_7109 A=n_6857 B=n_6899 VSS=VSS VDD=VDD
Xg117645__6260 OR2X1 $PINS Z=n_7107 A=n_6982 B=n_7002 VSS=VSS VDD=VDD
Xg117646__4319 NAND2X1 $PINS Z=n_7106 A=n_6963 B=n_6864 VSS=VSS VDD=VDD
Xg117647__8428 NOR2X1 $PINS Z=n_7105 A=n_6864 B=n_6966 VSS=VSS VDD=VDD
Xg117648__5526 NOR2X1 $PINS Z=n_7104 A=n_6987 B=n_7004 VSS=VSS VDD=VDD
Xg117649__6783 XOR2X1 $PINS Z=n_7102 A=n_6859 B=n_6883 VSS=VSS VDD=VDD
Xg117650__3680 NAND2X1 $PINS Z=n_7101 A=n_6960 B=n_6903 VSS=VSS VDD=VDD
Xg117651__1617 NAND2X1 $PINS Z=n_7100 A=n_6926 B=n_6853 VSS=VSS VDD=VDD
Xg117652__2802 NAND3X1 $PINS Z=n_7099 A=n_6892 B=n_6913 C=n_6871 VSS=VSS
+ VDD=VDD
Xg117653__1705 NAND3X1 $PINS Z=n_7098 A=n_6925 B=n_6884 C=n_6901 VSS=VSS
+ VDD=VDD
Xg117654__5122 NAND2X1 $PINS Z=n_7096 A=n_6950 B=n_6978 VSS=VSS VDD=VDD
Xg117655__8246 NOR2X1 $PINS Z=n_7095 A=n_6908 B=n_6933 VSS=VSS VDD=VDD
Xg117656__7098 NOR2X1 $PINS Z=n_7093 A=n_6909 B=n_6932 VSS=VSS VDD=VDD
Xg117657__6131 NOR2X1 $PINS Z=n_7092 A=n_6869 B=n_6950 VSS=VSS VDD=VDD
Xg117658__1881 XOR2X1 $PINS Z=n_7091 A=n_6846 B=n_6915 VSS=VSS VDD=VDD
Xg117659__5115 AND2X1 $PINS Z=n_7089 A=n_6998 B=n_6856 VSS=VSS VDD=VDD
Xg117660__7482 AND2X1 $PINS Z=n_7088 A=n_6948 B=n_6927 VSS=VSS VDD=VDD
Xg117661__4733 XOR2X1 $PINS Z=n_7086 A=n_6910 B=n_6871 VSS=VSS VDD=VDD
Xg117662__6161 NAND3X1 $PINS Z=n_7085 A=n_6928 B=n_6902 C=n_6878 VSS=VSS
+ VDD=VDD
Xg117663__9315 AND2X1 $PINS Z=n_7083 A=n_6935 B=n_6850 VSS=VSS VDD=VDD
Xg117664__9945 NOR2X1 $PINS Z=n_7082 A=n_6905 B=n_6935 VSS=VSS VDD=VDD
Xg117665__2883 XOR2X1 $PINS Z=n_7081 A=n_6892 B=n_6865 VSS=VSS VDD=VDD
Xg117666__2346 XOR2X1 $PINS Z=n_7079 A=n_6905 B=n_6869 VSS=VSS VDD=VDD
Xg117667__1666 NAND2X1 $PINS Z=n_7077 A=n_6935 B=n_6904 VSS=VSS VDD=VDD
Xg117668__7410 NOR2X1 $PINS Z=n_7075 A=n_6928 B=n_6903 VSS=VSS VDD=VDD
Xg117669__6417 NOR2X1 $PINS Z=n_7073 A=n_6889 B=n_6936 VSS=VSS VDD=VDD
Xg117670__5477 NOR2X1 $PINS Z=n_7071 A=n_6853 B=n_6926 VSS=VSS VDD=VDD
Xg117671__2398 NAND2X1 $PINS Z=n_7069 A=n_6934 B=n_6905 VSS=VSS VDD=VDD
Xg117672 INVX2 $PINS Z=n_7018 A=n_7019 VSS=VSS VDD=VDD
Xg117673 INVX2 $PINS Z=n_7016 A=n_7017 VSS=VSS VDD=VDD
Xg117674 INVX2 $PINS Z=n_7012 A=n_7013 VSS=VSS VDD=VDD
Xg117675 INVX2 $PINS Z=n_7010 A=n_7011 VSS=VSS VDD=VDD
Xg117676 INVX2 $PINS Z=n_7008 A=n_7009 VSS=VSS VDD=VDD
Xg117677 INVX2 $PINS Z=n_7006 A=n_7007 VSS=VSS VDD=VDD
Xg117678 INVX2 $PINS Z=n_7004 A=n_7005 VSS=VSS VDD=VDD
Xg117679 INVX2 $PINS Z=n_6999 A=n_7000 VSS=VSS VDD=VDD
Xg117680 INVX2 $PINS Z=n_6996 A=n_6997 VSS=VSS VDD=VDD
Xg117681 INVX2 $PINS Z=n_6993 A=n_6994 VSS=VSS VDD=VDD
Xg117682__5107 NAND2X1 $PINS Z=n_6992 A=n_6855 B=n_6913 VSS=VSS VDD=VDD
Xg117683__6260 NOR2X1 $PINS Z=n_6991 A=n_6870 B=n_6892 VSS=VSS VDD=VDD
Xg117684__4319 NOR2X1 $PINS Z=n_6990 A=n_6859 B=n_6881 VSS=VSS VDD=VDD
Xg117685__8428 NAND2X1 $PINS Z=n_6989 A=n_6863 B=n_6895 VSS=VSS VDD=VDD
Xg117686__5526 NOR2X1 $PINS Z=n_6988 A=n_6859 B=n_6891 VSS=VSS VDD=VDD
Xg117687__6783 NOR2X1 $PINS Z=n_6987 A=n_6845 B=n_6901 VSS=VSS VDD=VDD
Xg117688__3680 NAND2X1 $PINS Z=n_6986 A=n_6889 B=n_6874 VSS=VSS VDD=VDD
Xg117689__1617 NOR2X1 $PINS Z=n_6985 A=n_6916 B=n_6844 VSS=VSS VDD=VDD
Xg117690__2802 NAND2X1 $PINS Z=n_6984 A=n_6885 B=n_6845 VSS=VSS VDD=VDD
Xg117691__1705 NOR2X1 $PINS Z=n_6983 A=n_6873 B=n_6848 VSS=VSS VDD=VDD
Xg117692__5122 NOR2X1 $PINS Z=n_6982 A=n_6849 B=n_6866 VSS=VSS VDD=VDD
Xg117693__8246 NOR2X1 $PINS Z=n_6981 A=n_6863 B=n_6898 VSS=VSS VDD=VDD
Xg117694__7098 NAND2X1 $PINS Z=n_6980 A=n_6849 B=n_6888 VSS=VSS VDD=VDD
Xg117695__6131 NOR2X1 $PINS Z=n_7031 A=n_6862 B=n_6895 VSS=VSS VDD=VDD
Xg117696__1881 NAND2X1 $PINS Z=n_7030 A=n_6886 B=n_6847 VSS=VSS VDD=VDD
Xg117697__5115 NOR2X1 $PINS Z=n_7029 A=n_6864 B=n_6870 VSS=VSS VDD=VDD
Xg117698__7482 NAND2X1 $PINS Z=n_7028 A=n_6901 B=n_6885 VSS=VSS VDD=VDD
Xg117699__4733 NOR2X1 $PINS Z=n_7027 A=n_6865 B=n_6871 VSS=VSS VDD=VDD
Xg117700__6161 NOR2X1 $PINS Z=n_7026 A=n_6858 B=n_6882 VSS=VSS VDD=VDD
Xg117701__9315 NOR2X1 $PINS Z=n_7025 A=n_6874 B=n_6872 VSS=VSS VDD=VDD
Xg117702__9945 NOR2X1 $PINS Z=n_7024 A=n_6874 B=n_6873 VSS=VSS VDD=VDD
Xg117703__2883 NOR2X1 $PINS Z=n_7023 A=n_6863 B=n_6899 VSS=VSS VDD=VDD
Xg117704__2346 NAND2X1 $PINS Z=n_7022 A=n_6891 B=n_6881 VSS=VSS VDD=VDD
Xg117705__1666 AND2X1 $PINS Z=n_7021 A=n_6844 B=n_6916 VSS=VSS VDD=VDD
Xg117706__7410 NOR2X1 $PINS Z=n_7020 A=n_6849 B=n_6867 VSS=VSS VDD=VDD
Xg117707__6417 NOR2X1 $PINS Z=n_7019 A=n_6913 B=n_6892 VSS=VSS VDD=VDD
Xg117708__5477 NAND2X1 $PINS Z=n_7017 A=n_6883 B=n_6890 VSS=VSS VDD=VDD
Xg117709__2398 NOR2X1 $PINS Z=n_7015 A=n_6863 B=n_6894 VSS=VSS VDD=VDD
Xg117710__5107 NOR2X1 $PINS Z=n_7014 A=n_6898 B=n_6895 VSS=VSS VDD=VDD
Xg117711__6260 NOR2X1 $PINS Z=n_7013 A=n_6890 B=n_6882 VSS=VSS VDD=VDD
Xg117712__4319 NAND2X1 $PINS Z=n_7011 A=n_6880 B=n_6891 VSS=VSS VDD=VDD
Xg117713__8428 NAND2X1 $PINS Z=n_7009 A=n_6872 B=n_6874 VSS=VSS VDD=VDD
Xg117714__5526 NOR2X1 $PINS Z=n_7007 A=n_6909 B=n_6894 VSS=VSS VDD=VDD
Xg117715__6783 NAND2X1 $PINS Z=n_7005 A=n_6901 B=n_6845 VSS=VSS VDD=VDD
Xg117716__3680 NOR2X1 $PINS Z=n_7003 A=n_6874 B=n_6866 VSS=VSS VDD=VDD
Xg117717__1617 NOR2X1 $PINS Z=n_7002 A=n_6848 B=n_6867 VSS=VSS VDD=VDD
Xg117718__2802 NOR2X1 $PINS Z=n_7001 A=n_6858 B=n_6881 VSS=VSS VDD=VDD
Xg117719__1705 NOR2X1 $PINS Z=n_7000 A=n_6912 B=n_6871 VSS=VSS VDD=VDD
Xg117720__5122 NOR2X1 $PINS Z=n_6998 A=n_6862 B=n_6899 VSS=VSS VDD=VDD
Xg117721__8246 NAND2X1 $PINS Z=n_6997 A=n_6893 B=n_6913 VSS=VSS VDD=VDD
Xg117722__7098 NOR2X1 $PINS Z=n_6995 A=n_6913 B=n_6893 VSS=VSS VDD=VDD
Xg117723__6131 NOR2X1 $PINS Z=n_6994 A=n_6891 B=n_6880 VSS=VSS VDD=VDD
Xg117724 INVX2 $PINS Z=n_6975 A=n_6976 VSS=VSS VDD=VDD
Xg117725 INVX2 $PINS Z=n_6970 A=n_6971 VSS=VSS VDD=VDD
Xg117726 INVX2 $PINS Z=n_6968 A=n_6969 VSS=VSS VDD=VDD
Xg117727 INVX2 $PINS Z=n_6962 A=n_6963 VSS=VSS VDD=VDD
Xg117728 INVX2 $PINS Z=n_6959 A=n_6960 VSS=VSS VDD=VDD
Xg117729 INVX2 $PINS Z=n_6956 A=n_6957 VSS=VSS VDD=VDD
Xg117730 INVX2 $PINS Z=n_6953 A=n_6954 VSS=VSS VDD=VDD
Xg117731 INVX2 $PINS Z=n_6951 A=n_6952 VSS=VSS VDD=VDD
Xg117732 INVX2 $PINS Z=n_6949 A=n_6950 VSS=VSS VDD=VDD
Xg117733 INVX2 $PINS Z=n_6946 A=n_6947 VSS=VSS VDD=VDD
Xg117734 INVX2 $PINS Z=n_6943 A=n_6944 VSS=VSS VDD=VDD
Xg117735 INVX2 $PINS Z=n_6940 A=n_6941 VSS=VSS VDD=VDD
Xg117736 INVX2 $PINS Z=n_6938 A=n_6939 VSS=VSS VDD=VDD
Xg117737 INVX2 $PINS Z=n_6936 A=n_6937 VSS=VSS VDD=VDD
Xg117738 INVX2 $PINS Z=n_6934 A=n_6935 VSS=VSS VDD=VDD
Xg117739 INVX2 $PINS Z=n_6932 A=n_6933 VSS=VSS VDD=VDD
Xg117740 INVX2 $PINS Z=n_6930 A=n_6931 VSS=VSS VDD=VDD
Xg117741 INVX2 $PINS Z=n_6928 A=n_6929 VSS=VSS VDD=VDD
Xg117742 INVX2 $PINS Z=n_6926 A=n_6927 VSS=VSS VDD=VDD
Xg117743 INVX2 $PINS Z=n_6924 A=n_6925 VSS=VSS VDD=VDD
Xg117744__1881 NAND2X1 $PINS Z=n_6923 A=n_6861 B=n_6878 VSS=VSS VDD=VDD
Xg117745__5115 NAND2X1 $PINS Z=n_6922 A=n_6851 B=n_6877 VSS=VSS VDD=VDD
Xg117746__7482 NOR2X1 $PINS Z=n_6921 A=n_6859 B=n_6880 VSS=VSS VDD=VDD
Xg117747__4733 NOR2X1 $PINS Z=n_6920 A=n_6897 B=n_6886 VSS=VSS VDD=VDD
Xg117748__6161 NAND2X1 $PINS Z=n_6919 A=n_6880 B=n_6883 VSS=VSS VDD=VDD
Xg117749 NAND2X1 $PINS Z=n_6918 A=n_6866 B=n_6889 VSS=VSS VDD=VDD
Xg117750 NAND2X1 $PINS Z=n_6979 A=n_6881 B=n_6853 VSS=VSS VDD=VDD
Xg117751 NAND2X1 $PINS Z=n_6978 A=n_6907 B=n_6876 VSS=VSS VDD=VDD
Xg117752 NAND2X1 $PINS Z=n_6917 A=n_6898 B=n_6857 VSS=VSS VDD=VDD
Xg117753 NOR2X1 $PINS Z=n_6977 A=n_6878 B=n_6860 VSS=VSS VDD=VDD
Xg117754 NOR2X1 $PINS Z=n_6976 A=n_6896 B=n_6887 VSS=VSS VDD=VDD
Xg117755 NOR2X1 $PINS Z=n_6974 A=n_6878 B=n_6903 VSS=VSS VDD=VDD
Xg117756 NOR2X1 $PINS Z=n_6973 A=n_6847 B=n_6896 VSS=VSS VDD=VDD
Xg117757 NOR2X1 $PINS Z=n_6972 A=n_6853 B=n_6883 VSS=VSS VDD=VDD
Xg117758 NOR2X1 $PINS Z=n_6971 A=n_6896 B=n_6846 VSS=VSS VDD=VDD
Xg117759 NAND2X1 $PINS Z=n_6969 A=n_6846 B=n_6896 VSS=VSS VDD=VDD
Xg117760 NOR2X1 $PINS Z=n_6967 A=n_6906 B=n_6876 VSS=VSS VDD=VDD
Xg117761 NAND2X1 $PINS Z=n_6966 A=n_6855 B=n_6910 VSS=VSS VDD=VDD
Xg117762 NOR2X1 $PINS Z=n_6965 A=n_6851 B=n_6868 VSS=VSS VDD=VDD
Xg117763 NOR2X1 $PINS Z=n_6964 A=n_6907 B=n_6877 VSS=VSS VDD=VDD
Xg117764 NOR2X1 $PINS Z=n_6963 A=n_6911 B=n_6855 VSS=VSS VDD=VDD
Xg117765 NOR2X1 $PINS Z=n_6961 A=n_6884 B=n_6901 VSS=VSS VDD=VDD
Xg117766 NOR2X1 $PINS Z=n_6960 A=n_6878 B=n_6861 VSS=VSS VDD=VDD
Xg117767 NOR2X1 $PINS Z=n_6958 A=n_6906 B=n_6850 VSS=VSS VDD=VDD
Xg117768 NOR2X1 $PINS Z=n_6957 A=n_6910 B=n_6854 VSS=VSS VDD=VDD
Xg117769 NOR2X1 $PINS Z=n_6955 A=n_6897 B=n_6846 VSS=VSS VDD=VDD
Xg117770 NOR2X1 $PINS Z=n_6954 A=n_6870 B=n_6865 VSS=VSS VDD=VDD
Xg117771 NAND2X1 $PINS Z=n_6952 A=n_6903 B=n_6878 VSS=VSS VDD=VDD
Xg117772 NAND2X1 $PINS Z=n_6950 A=n_6906 B=n_6877 VSS=VSS VDD=VDD
Xg117773 NOR2X1 $PINS Z=n_6948 A=n_6852 B=n_6883 VSS=VSS VDD=VDD
Xg117774 NOR2X1 $PINS Z=n_6947 A=n_6910 B=n_6855 VSS=VSS VDD=VDD
Xg117775 NOR2X1 $PINS Z=n_6945 A=n_6877 B=n_6869 VSS=VSS VDD=VDD
Xg117776 XOR2X1 $PINS Z=n_6944 A=csm_inst_right_reg[0] B=n_6772 VSS=VSS VDD=VDD
Xg117777 XOR2X1 $PINS Z=n_6942 A=csm_inst_right_reg[11] B=n_6769 VSS=VSS
+ VDD=VDD
Xg117778 XOR2X1 $PINS Z=n_6941 A=csm_inst_right_reg[12] B=n_6768 VSS=VSS
+ VDD=VDD
Xg117779 XOR2X1 $PINS Z=n_6939 A=csm_inst_right_reg[16] B=n_6776 VSS=VSS
+ VDD=VDD
Xg117780 XOR2X1 $PINS Z=n_6937 A=csm_inst_right_reg[3] B=n_6770 VSS=VSS VDD=VDD
Xg117781 XOR2X1 $PINS Z=n_6935 A=csm_inst_right_reg[28] B=n_6771 VSS=VSS
+ VDD=VDD
Xg117782 XOR2X1 $PINS Z=n_6933 A=csm_inst_right_reg[20] B=n_6766 VSS=VSS
+ VDD=VDD
Xg117783 XOR2X1 $PINS Z=n_6931 A=csm_inst_right_reg[31] B=n_6774 VSS=VSS
+ VDD=VDD
Xg117784 XOR2X1 $PINS Z=n_6929 A=csm_inst_right_reg[2] B=n_6773 VSS=VSS VDD=VDD
Xg117785 XOR2X1 $PINS Z=n_6927 A=csm_inst_right_reg[18] B=n_6775 VSS=VSS
+ VDD=VDD
Xg117786 XOR2X1 $PINS Z=n_6925 A=csm_inst_right_reg[10] B=n_6767 VSS=VSS
+ VDD=VDD
Xg117838 INVX2 $PINS Z=n_6914 A=n_6915 VSS=VSS VDD=VDD
Xg117839 INVX2 $PINS Z=n_6912 A=n_6913 VSS=VSS VDD=VDD
Xg117840 INVX2 $PINS Z=n_6910 A=n_6911 VSS=VSS VDD=VDD
Xg117841 INVX2 $PINS Z=n_6908 A=n_6909 VSS=VSS VDD=VDD
Xg117842 INVX2 $PINS Z=n_6906 A=n_6907 VSS=VSS VDD=VDD
Xg117843 INVX2 $PINS Z=n_6904 A=n_6905 VSS=VSS VDD=VDD
Xg117844 INVX2 $PINS Z=n_6902 A=n_6903 VSS=VSS VDD=VDD
Xg117845 INVX2 $PINS Z=n_6900 A=n_6901 VSS=VSS VDD=VDD
Xg117846 INVX2 $PINS Z=n_6898 A=n_6899 VSS=VSS VDD=VDD
Xg117847 INVX2 $PINS Z=n_6896 A=n_6897 VSS=VSS VDD=VDD
Xg117848 INVX2 $PINS Z=n_6894 A=n_6895 VSS=VSS VDD=VDD
Xg117849 INVX2 $PINS Z=n_6892 A=n_6893 VSS=VSS VDD=VDD
Xg117850 INVX2 $PINS Z=n_6890 A=n_6891 VSS=VSS VDD=VDD
Xg117851 INVX2 $PINS Z=n_6888 A=n_6889 VSS=VSS VDD=VDD
Xg117852 INVX2 $PINS Z=n_6886 A=n_6887 VSS=VSS VDD=VDD
Xg117853 INVX2 $PINS Z=n_6884 A=n_6885 VSS=VSS VDD=VDD
Xg117854 INVX2 $PINS Z=n_6882 A=n_6883 VSS=VSS VDD=VDD
Xg117855 INVX2 $PINS Z=n_6880 A=n_6881 VSS=VSS VDD=VDD
Xg117856 INVX2 $PINS Z=n_6878 A=n_6879 VSS=VSS VDD=VDD
Xg117857 INVX2 $PINS Z=n_6876 A=n_6877 VSS=VSS VDD=VDD
Xg117858 INVX2 $PINS Z=n_6874 A=n_6875 VSS=VSS VDD=VDD
Xg117859 INVX2 $PINS Z=n_6872 A=n_6873 VSS=VSS VDD=VDD
Xg117860 INVX2 $PINS Z=n_6870 A=n_6871 VSS=VSS VDD=VDD
Xg117861 INVX2 $PINS Z=n_6868 A=n_6869 VSS=VSS VDD=VDD
Xg117862 INVX2 $PINS Z=n_6866 A=n_6867 VSS=VSS VDD=VDD
Xg117863 INVX2 $PINS Z=n_6864 A=n_6865 VSS=VSS VDD=VDD
Xg117864 INVX2 $PINS Z=n_6862 A=n_6863 VSS=VSS VDD=VDD
Xg117865 INVX2 $PINS Z=n_6860 A=n_6861 VSS=VSS VDD=VDD
Xg117866 INVX2 $PINS Z=n_6858 A=n_6859 VSS=VSS VDD=VDD
Xg117867 INVX2 $PINS Z=n_6856 A=n_6857 VSS=VSS VDD=VDD
Xg117868 INVX2 $PINS Z=n_6854 A=n_6855 VSS=VSS VDD=VDD
Xg117869 INVX2 $PINS Z=n_6852 A=n_6853 VSS=VSS VDD=VDD
Xg117870 INVX2 $PINS Z=n_6850 A=n_6851 VSS=VSS VDD=VDD
Xg117871 INVX2 $PINS Z=n_6848 A=n_6849 VSS=VSS VDD=VDD
Xg117872 INVX2 $PINS Z=n_6846 A=n_6847 VSS=VSS VDD=VDD
Xg117889 XOR2X1 $PINS Z=n_6916 A=csm_inst_right_reg[9] B=n_6527 VSS=VSS VDD=VDD
Xg117890 XOR2X1 $PINS Z=n_6915 A=csm_inst_right_reg[12] B=n_6546 VSS=VSS
+ VDD=VDD
Xg117891 XOR2X1 $PINS Z=n_6913 A=csm_inst_right_reg[26] B=n_6533 VSS=VSS
+ VDD=VDD
Xg117892 XOR2X1 $PINS Z=n_6911 A=csm_inst_right_reg[25] B=n_6532 VSS=VSS
+ VDD=VDD
Xg117893 XOR2X1 $PINS Z=n_6909 A=csm_inst_right_reg[22] B=n_6550 VSS=VSS
+ VDD=VDD
Xg117894 XOR2X1 $PINS Z=n_6907 A=csm_inst_right_reg[29] B=n_6562 VSS=VSS
+ VDD=VDD
Xg117895 XOR2X1 $PINS Z=n_6905 A=csm_inst_right_reg[27] B=n_6539 VSS=VSS
+ VDD=VDD
Xg117896 XOR2X1 $PINS Z=n_6903 A=csm_inst_right_reg[4] B=n_6538 VSS=VSS VDD=VDD
Xg117897 XOR2X1 $PINS Z=n_6901 A=csm_inst_right_reg[11] B=n_6528 VSS=VSS
+ VDD=VDD
Xg117898 XOR2X1 $PINS Z=n_6899 A=csm_inst_right_reg[23] B=n_6553 VSS=VSS
+ VDD=VDD
Xg117899 XOR2X1 $PINS Z=n_6897 A=csm_inst_right_reg[14] B=n_6549 VSS=VSS
+ VDD=VDD
Xg117900 XOR2X1 $PINS Z=n_6895 A=csm_inst_right_reg[21] B=n_6556 VSS=VSS
+ VDD=VDD
Xg117901 XOR2X1 $PINS Z=n_6893 A=csm_inst_right_reg[24] B=n_6530 VSS=VSS
+ VDD=VDD
Xg117902 XOR2X1 $PINS Z=n_6891 A=csm_inst_right_reg[16] B=n_6559 VSS=VSS
+ VDD=VDD
Xg117903 XOR2X1 $PINS Z=n_6889 A=csm_inst_right_reg[4] B=n_6554 VSS=VSS VDD=VDD
Xg117904 XOR2X1 $PINS Z=n_6887 A=csm_inst_right_reg[15] B=n_6548 VSS=VSS
+ VDD=VDD
Xg117905 XOR2X1 $PINS Z=n_6885 A=csm_inst_right_reg[8] B=n_6555 VSS=VSS VDD=VDD
Xg117906 XOR2X1 $PINS Z=n_6883 A=csm_inst_right_reg[19] B=n_6542 VSS=VSS
+ VDD=VDD
Xg117907 XOR2X1 $PINS Z=n_6881 A=csm_inst_right_reg[15] B=n_6557 VSS=VSS
+ VDD=VDD
Xg117908 XOR2X1 $PINS Z=n_6879 A=csm_inst_right_reg[1] B=n_6537 VSS=VSS VDD=VDD
Xg117909 XOR2X1 $PINS Z=n_6877 A=csm_inst_right_reg[0] B=n_6545 VSS=VSS VDD=VDD
Xg117910 XOR2X1 $PINS Z=n_6875 A=csm_inst_right_reg[7] B=n_6544 VSS=VSS VDD=VDD
Xg117911 XOR2X1 $PINS Z=n_6873 A=csm_inst_right_reg[6] B=n_6541 VSS=VSS VDD=VDD
Xg117912 XOR2X1 $PINS Z=n_6871 A=csm_inst_right_reg[27] B=n_6535 VSS=VSS
+ VDD=VDD
Xg117913 XOR2X1 $PINS Z=n_6869 A=csm_inst_right_reg[31] B=n_6547 VSS=VSS
+ VDD=VDD
Xg117914 XOR2X1 $PINS Z=n_6867 A=csm_inst_right_reg[5] B=n_8063 VSS=VSS VDD=VDD
Xg117915 XOR2X1 $PINS Z=n_6865 A=csm_inst_right_reg[23] B=n_6534 VSS=VSS
+ VDD=VDD
Xg117916 XOR2X1 $PINS Z=n_6863 A=csm_inst_right_reg[19] B=n_6558 VSS=VSS
+ VDD=VDD
Xg117917 XOR2X1 $PINS Z=n_6861 A=csm_inst_right_reg[3] B=n_6536 VSS=VSS VDD=VDD
Xg117918 XOR2X1 $PINS Z=n_6859 A=csm_inst_right_reg[17] B=n_6560 VSS=VSS
+ VDD=VDD
Xg117919 XOR2X1 $PINS Z=n_6857 A=csm_inst_right_reg[24] B=n_6552 VSS=VSS
+ VDD=VDD
Xg117920 XOR2X1 $PINS Z=n_6855 A=csm_inst_right_reg[28] B=n_6531 VSS=VSS
+ VDD=VDD
Xg117921 XOR2X1 $PINS Z=n_6853 A=csm_inst_right_reg[20] B=n_6543 VSS=VSS
+ VDD=VDD
Xg117922 XOR2X1 $PINS Z=n_6851 A=csm_inst_right_reg[30] B=n_6540 VSS=VSS
+ VDD=VDD
Xg117923 XOR2X1 $PINS Z=n_6849 A=csm_inst_right_reg[8] B=n_6561 VSS=VSS VDD=VDD
Xg117924 XOR2X1 $PINS Z=n_6847 A=csm_inst_right_reg[13] B=n_6551 VSS=VSS
+ VDD=VDD
Xg118028 INVX2 $PINS Z=n_6844 A=n_6845 VSS=VSS VDD=VDD
Xg118029 NAND2X1 $PINS Z=n_6843 A=n_6732 B=n_3146 VSS=VSS VDD=VDD
Xg118030 NOR2X1 $PINS Z=n_6842 A=n_6765 B=n_465 VSS=VSS VDD=VDD
Xg118031 NAND2X1 $PINS Z=n_6841 A=n_6712 B=n_3173 VSS=VSS VDD=VDD
Xg118032 NAND2X1 $PINS Z=n_6840 A=n_6719 B=n_3167 VSS=VSS VDD=VDD
Xg118033 NAND2X1 $PINS Z=n_6839 A=n_6750 B=n_3172 VSS=VSS VDD=VDD
Xg118034 NOR2X1 $PINS Z=n_6838 A=n_6765 B=n_187 VSS=VSS VDD=VDD
Xg118035 NAND2X1 $PINS Z=n_6837 A=n_6702 B=n_3188 VSS=VSS VDD=VDD
Xg118036 NAND2X1 $PINS Z=n_6836 A=n_6703 B=n_3251 VSS=VSS VDD=VDD
Xg118037 NAND2X1 $PINS Z=n_6835 A=n_6704 B=n_3170 VSS=VSS VDD=VDD
Xg118038 NAND2X1 $PINS Z=n_6834 A=n_6705 B=n_3253 VSS=VSS VDD=VDD
Xg118039 NAND2X1 $PINS Z=n_6833 A=n_6706 B=n_3270 VSS=VSS VDD=VDD
Xg118040 NAND2X1 $PINS Z=n_6832 A=n_6707 B=n_3020 VSS=VSS VDD=VDD
Xg118041 NAND2X1 $PINS Z=n_6831 A=n_6708 B=n_3024 VSS=VSS VDD=VDD
Xg118042 NAND2X1 $PINS Z=n_6830 A=n_6709 B=n_3033 VSS=VSS VDD=VDD
Xg118043 NAND2X1 $PINS Z=n_6829 A=n_6710 B=n_3249 VSS=VSS VDD=VDD
Xg118044 NAND2X1 $PINS Z=n_6828 A=n_6764 B=n_3241 VSS=VSS VDD=VDD
Xg118045 NAND2X1 $PINS Z=n_6827 A=n_6763 B=n_3147 VSS=VSS VDD=VDD
Xg118046 NAND2X1 $PINS Z=n_6826 A=n_6762 B=n_3144 VSS=VSS VDD=VDD
Xg118047 NAND2X1 $PINS Z=n_6825 A=n_6761 B=n_3237 VSS=VSS VDD=VDD
Xg118048 NAND2X1 $PINS Z=n_6824 A=n_6760 B=n_3156 VSS=VSS VDD=VDD
Xg118049 NAND2X1 $PINS Z=n_6823 A=n_6759 B=n_3139 VSS=VSS VDD=VDD
Xg118050 NAND2X1 $PINS Z=n_6822 A=n_6758 B=n_3134 VSS=VSS VDD=VDD
Xg118051 NAND2X1 $PINS Z=n_6821 A=n_6757 B=n_3006 VSS=VSS VDD=VDD
Xg118052 NAND2X1 $PINS Z=n_6820 A=n_6756 B=n_3025 VSS=VSS VDD=VDD
Xg118053 NAND2X1 $PINS Z=n_6819 A=n_6754 B=n_3198 VSS=VSS VDD=VDD
Xg118054 NAND2X1 $PINS Z=n_6818 A=n_6755 B=n_3177 VSS=VSS VDD=VDD
Xg118055 NAND2X1 $PINS Z=n_6817 A=n_6711 B=n_6014 VSS=VSS VDD=VDD
Xg118056 NAND2X1 $PINS Z=n_6816 A=n_6753 B=n_3143 VSS=VSS VDD=VDD
Xg118057 NAND2X1 $PINS Z=n_6815 A=n_6752 B=n_3201 VSS=VSS VDD=VDD
Xg118058 NAND2X1 $PINS Z=n_6814 A=n_6751 B=n_3159 VSS=VSS VDD=VDD
Xg118059 NAND2X1 $PINS Z=n_6813 A=n_6700 B=n_3240 VSS=VSS VDD=VDD
Xg118060 NAND2X1 $PINS Z=n_6812 A=n_6713 B=n_3254 VSS=VSS VDD=VDD
Xg118061 NAND2X1 $PINS Z=n_6811 A=n_6714 B=n_3230 VSS=VSS VDD=VDD
Xg118062 NAND2X1 $PINS Z=n_6810 A=n_6715 B=n_3256 VSS=VSS VDD=VDD
Xg118063 NAND2X1 $PINS Z=n_6809 A=n_6716 B=n_3189 VSS=VSS VDD=VDD
Xg118064 NAND2X1 $PINS Z=n_6808 A=n_6717 B=n_3123 VSS=VSS VDD=VDD
Xg118065 NAND2X1 $PINS Z=n_6807 A=n_6718 B=n_3233 VSS=VSS VDD=VDD
Xg118066 NAND2X1 $PINS Z=n_6806 A=n_6701 B=n_3130 VSS=VSS VDD=VDD
Xg118067 NAND2X1 $PINS Z=n_6805 A=n_6749 B=n_3231 VSS=VSS VDD=VDD
Xg118068 NAND2X1 $PINS Z=n_6804 A=n_6720 B=n_3125 VSS=VSS VDD=VDD
Xg118069 NAND2X1 $PINS Z=n_6803 A=n_6721 B=n_3105 VSS=VSS VDD=VDD
Xg118070 NAND2X1 $PINS Z=n_6802 A=n_6722 B=n_3148 VSS=VSS VDD=VDD
Xg118071 NAND2X1 $PINS Z=n_6801 A=n_6724 B=n_3219 VSS=VSS VDD=VDD
Xg118072 NAND2X1 $PINS Z=n_6800 A=n_6723 B=n_3126 VSS=VSS VDD=VDD
Xg118073 NAND2X1 $PINS Z=n_6799 A=n_6725 B=n_3228 VSS=VSS VDD=VDD
Xg118074 NAND2X1 $PINS Z=n_6798 A=n_6726 B=n_3206 VSS=VSS VDD=VDD
Xg118075 NAND2X1 $PINS Z=n_6797 A=n_6727 B=n_3129 VSS=VSS VDD=VDD
Xg118076 NAND2X1 $PINS Z=n_6796 A=n_6728 B=n_3018 VSS=VSS VDD=VDD
Xg118077 NAND2X1 $PINS Z=n_6795 A=n_6729 B=n_3250 VSS=VSS VDD=VDD
Xg118078 NAND2X1 $PINS Z=n_6794 A=n_6730 B=n_3257 VSS=VSS VDD=VDD
Xg118079 NAND2X1 $PINS Z=n_6793 A=n_6731 B=n_3246 VSS=VSS VDD=VDD
Xg118080 NAND2X1 $PINS Z=n_6792 A=n_6748 B=n_3180 VSS=VSS VDD=VDD
Xg118081 NAND2X1 $PINS Z=n_6791 A=n_6733 B=n_3236 VSS=VSS VDD=VDD
Xg118082 NAND2X1 $PINS Z=n_6790 A=n_6734 B=n_3191 VSS=VSS VDD=VDD
Xg118083 NAND2X1 $PINS Z=n_6789 A=n_6735 B=n_3021 VSS=VSS VDD=VDD
Xg118084 NAND2X1 $PINS Z=n_6788 A=n_6736 B=n_3117 VSS=VSS VDD=VDD
Xg118085 NAND2X1 $PINS Z=n_6787 A=n_6737 B=n_3255 VSS=VSS VDD=VDD
Xg118086 NAND2X1 $PINS Z=n_6786 A=n_6738 B=n_3215 VSS=VSS VDD=VDD
Xg118087 NAND2X1 $PINS Z=n_6785 A=n_6740 B=n_3211 VSS=VSS VDD=VDD
Xg118088 NAND2X1 $PINS Z=n_6784 A=n_6739 B=n_3252 VSS=VSS VDD=VDD
Xg118089 NAND2X1 $PINS Z=n_6783 A=n_6741 B=n_3015 VSS=VSS VDD=VDD
Xg118090 NAND2X1 $PINS Z=n_6782 A=n_6742 B=n_3245 VSS=VSS VDD=VDD
Xg118091 NAND2X1 $PINS Z=n_6781 A=n_6743 B=n_3179 VSS=VSS VDD=VDD
Xg118092 NAND2X1 $PINS Z=n_6780 A=n_6744 B=n_3239 VSS=VSS VDD=VDD
Xg118093 NAND2X1 $PINS Z=n_6779 A=n_6745 B=n_3174 VSS=VSS VDD=VDD
Xg118094 NAND2X1 $PINS Z=n_6778 A=n_6746 B=n_3034 VSS=VSS VDD=VDD
Xg118095 NAND2X1 $PINS Z=n_6777 A=n_6747 B=n_3244 VSS=VSS VDD=VDD
Xg118097 NOR2X1 $PINS Z=n_6776 A=n_5995 B=n_6594 VSS=VSS VDD=VDD
Xg118098 NAND2X1 $PINS Z=n_6775 A=n_6672 B=n_6086 VSS=VSS VDD=VDD
Xg118099 NOR2X1 $PINS Z=n_6774 A=n_5987 B=n_6652 VSS=VSS VDD=VDD
Xg118100 NOR2X1 $PINS Z=n_6773 A=n_6003 B=n_6679 VSS=VSS VDD=VDD
Xg118101 NOR2X1 $PINS Z=n_6772 A=n_6004 B=n_6683 VSS=VSS VDD=VDD
Xg118102 NOR2X1 $PINS Z=n_6771 A=n_6691 B=n_6340 VSS=VSS VDD=VDD
Xg118103 NAND2X1 $PINS Z=n_6770 A=n_6699 B=n_5934 VSS=VSS VDD=VDD
Xg118122 NOR2X1 $PINS Z=n_6769 A=n_5993 B=n_6593 VSS=VSS VDD=VDD
Xg118126 NAND2X1 $PINS Z=n_6768 A=n_6659 B=n_6022 VSS=VSS VDD=VDD
Xg118127 NOR2X1 $PINS Z=n_6767 A=n_6112 B=n_6584 VSS=VSS VDD=VDD
Xg118128 NAND3X1 $PINS Z=n_6766 A=n_6656 B=n_6015 C=n_5887 VSS=VSS VDD=VDD
Xg118131 XOR2X1 $PINS Z=n_6845 A=csm_inst_right_reg[7] B=n_6401 VSS=VSS VDD=VDD
Xg118132 NAND2X1 $PINS Z=n_6764 A=n_6400 B=spi_tx_data[54] VSS=VSS VDD=VDD
Xg118133 NAND2X1 $PINS Z=n_6763 A=n_6400 B=spi_tx_data[53] VSS=VSS VDD=VDD
Xg118134 NAND2X1 $PINS Z=n_6762 A=n_6400 B=spi_tx_data[52] VSS=VSS VDD=VDD
Xg118135 NAND2X1 $PINS Z=n_6761 A=n_6400 B=spi_tx_data[51] VSS=VSS VDD=VDD
Xg118136 NAND2X1 $PINS Z=n_6760 A=n_6400 B=spi_tx_data[50] VSS=VSS VDD=VDD
Xg118137 NAND2X1 $PINS Z=n_6759 A=n_6400 B=spi_tx_data[49] VSS=VSS VDD=VDD
Xg118138 NAND2X1 $PINS Z=n_6758 A=n_6400 B=spi_tx_data[48] VSS=VSS VDD=VDD
Xg118139 NAND2X1 $PINS Z=n_6757 A=n_6400 B=spi_tx_data[47] VSS=VSS VDD=VDD
Xg118140 NAND2X1 $PINS Z=n_6756 A=n_6400 B=spi_tx_data[46] VSS=VSS VDD=VDD
Xg118141 NAND2X1 $PINS Z=n_6755 A=n_6400 B=spi_tx_data[44] VSS=VSS VDD=VDD
Xg118142 NAND2X1 $PINS Z=n_6754 A=n_6400 B=spi_tx_data[45] VSS=VSS VDD=VDD
Xg118143 NAND2X1 $PINS Z=n_6753 A=n_6400 B=spi_tx_data[43] VSS=VSS VDD=VDD
Xg118144 NAND2X1 $PINS Z=n_6752 A=n_6400 B=spi_tx_data[42] VSS=VSS VDD=VDD
Xg118145 NAND2X1 $PINS Z=n_6751 A=n_6400 B=spi_tx_data[41] VSS=VSS VDD=VDD
Xg118146 NAND2X1 $PINS Z=n_6750 A=n_6400 B=spi_tx_data[40] VSS=VSS VDD=VDD
Xg118147 NAND2X1 $PINS Z=n_6749 A=n_6400 B=spi_tx_data[38] VSS=VSS VDD=VDD
Xg118148 NAND2X1 $PINS Z=n_6748 A=n_6400 B=spi_tx_data[37] VSS=VSS VDD=VDD
Xg118149 NAND2X1 $PINS Z=n_6747 A=n_6400 B=spi_tx_data[36] VSS=VSS VDD=VDD
Xg118150 NAND2X1 $PINS Z=n_6746 A=n_6400 B=spi_tx_data[35] VSS=VSS VDD=VDD
Xg118151 NAND2X1 $PINS Z=n_6745 A=n_6400 B=spi_tx_data[34] VSS=VSS VDD=VDD
Xg118152 NAND2X1 $PINS Z=n_6744 A=n_6400 B=spi_tx_data[33] VSS=VSS VDD=VDD
Xg118153 NAND2X1 $PINS Z=n_6743 A=n_6400 B=spi_tx_data[32] VSS=VSS VDD=VDD
Xg118154 NAND2X1 $PINS Z=n_6742 A=n_6400 B=spi_tx_data[31] VSS=VSS VDD=VDD
Xg118155 NAND2X1 $PINS Z=n_6741 A=n_6400 B=spi_tx_data[30] VSS=VSS VDD=VDD
Xg118156 NAND2X1 $PINS Z=n_6740 A=n_6400 B=spi_tx_data[28] VSS=VSS VDD=VDD
Xg118157 NAND2X1 $PINS Z=n_6739 A=n_6400 B=spi_tx_data[29] VSS=VSS VDD=VDD
Xg118158 NAND2X1 $PINS Z=n_6738 A=n_6400 B=spi_tx_data[27] VSS=VSS VDD=VDD
Xg118159 NAND2X1 $PINS Z=n_6737 A=n_6400 B=spi_tx_data[26] VSS=VSS VDD=VDD
Xg118160 NAND2X1 $PINS Z=n_6736 A=n_6400 B=spi_tx_data[25] VSS=VSS VDD=VDD
Xg118161 NAND2X1 $PINS Z=n_6735 A=n_6400 B=spi_tx_data[24] VSS=VSS VDD=VDD
Xg118162 NAND2X1 $PINS Z=n_6734 A=n_6400 B=spi_tx_data[23] VSS=VSS VDD=VDD
Xg118163 NAND2X1 $PINS Z=n_6733 A=n_6400 B=spi_tx_data[22] VSS=VSS VDD=VDD
Xg118164 NAND2X1 $PINS Z=n_6732 A=n_6400 B=spi_tx_data[21] VSS=VSS VDD=VDD
Xg118165 NAND2X1 $PINS Z=n_6731 A=n_6400 B=spi_tx_data[20] VSS=VSS VDD=VDD
Xg118166 NAND2X1 $PINS Z=n_6730 A=n_6400 B=spi_tx_data[19] VSS=VSS VDD=VDD
Xg118167 NAND2X1 $PINS Z=n_6729 A=n_6400 B=spi_tx_data[18] VSS=VSS VDD=VDD
Xg118168 NAND2X1 $PINS Z=n_6728 A=n_6400 B=spi_tx_data[17] VSS=VSS VDD=VDD
Xg118169 NAND2X1 $PINS Z=n_6727 A=n_6400 B=spi_tx_data[16] VSS=VSS VDD=VDD
Xg118170 NAND2X1 $PINS Z=n_6726 A=n_6400 B=spi_tx_data[15] VSS=VSS VDD=VDD
Xg118171 NAND2X1 $PINS Z=n_6725 A=n_6400 B=spi_tx_data[14] VSS=VSS VDD=VDD
Xg118172 NAND2X1 $PINS Z=n_6724 A=n_6400 B=spi_tx_data[12] VSS=VSS VDD=VDD
Xg118173 NAND2X1 $PINS Z=n_6723 A=n_6400 B=spi_tx_data[13] VSS=VSS VDD=VDD
Xg118174 NAND2X1 $PINS Z=n_6722 A=n_6400 B=spi_tx_data[11] VSS=VSS VDD=VDD
Xg118175 NAND2X1 $PINS Z=n_6721 A=n_6400 B=spi_tx_data[10] VSS=VSS VDD=VDD
Xg118176 NAND2X1 $PINS Z=n_6720 A=n_6400 B=spi_tx_data[9] VSS=VSS VDD=VDD
Xg118177 NAND2X1 $PINS Z=n_6719 A=n_6400 B=spi_tx_data[8] VSS=VSS VDD=VDD
Xg118178 NAND2X1 $PINS Z=n_6718 A=n_6400 B=spi_tx_data[6] VSS=VSS VDD=VDD
Xg118179 NAND2X1 $PINS Z=n_6717 A=n_6400 B=spi_tx_data[5] VSS=VSS VDD=VDD
Xg118180 NAND2X1 $PINS Z=n_6716 A=n_6400 B=spi_tx_data[4] VSS=VSS VDD=VDD
Xg118181 NAND2X1 $PINS Z=n_6715 A=n_6400 B=spi_tx_data[3] VSS=VSS VDD=VDD
Xg118182 NAND2X1 $PINS Z=n_6714 A=n_6400 B=spi_tx_data[2] VSS=VSS VDD=VDD
Xg118183 NAND2X1 $PINS Z=n_6713 A=n_6400 B=spi_tx_data[1] VSS=VSS VDD=VDD
Xg118184 NAND2X1 $PINS Z=n_6712 A=n_6400 B=spi_tx_data[0] VSS=VSS VDD=VDD
Xg118185 NAND2X1 $PINS Z=n_6711 A=n_6502 B=spi_inst_bit_count[6] VSS=VSS
+ VDD=VDD
Xg118197 NAND2X1 $PINS Z=n_6765 A=n_161 B=trigger_operation VSS=VSS VDD=VDD
Xg118317 NAND2X1 $PINS Z=n_6710 A=n_6400 B=spi_tx_data[55] VSS=VSS VDD=VDD
Xg118318 NAND2X1 $PINS Z=n_6709 A=n_6400 B=spi_tx_data[56] VSS=VSS VDD=VDD
Xg118319 NAND2X1 $PINS Z=n_6708 A=n_6400 B=spi_tx_data[57] VSS=VSS VDD=VDD
Xg118320 NAND2X1 $PINS Z=n_6707 A=n_6400 B=spi_tx_data[58] VSS=VSS VDD=VDD
Xg118321 NAND2X1 $PINS Z=n_6706 A=n_6400 B=spi_tx_data[59] VSS=VSS VDD=VDD
Xg118322 NAND2X1 $PINS Z=n_6705 A=n_6400 B=spi_tx_data[60] VSS=VSS VDD=VDD
Xg118323 NAND2X1 $PINS Z=n_6704 A=n_6400 B=spi_tx_data[61] VSS=VSS VDD=VDD
Xg118324 NAND2X1 $PINS Z=n_6703 A=n_6400 B=spi_tx_data[62] VSS=VSS VDD=VDD
Xg118325 NAND2X1 $PINS Z=n_6702 A=n_6400 B=spi_tx_data[63] VSS=VSS VDD=VDD
Xg118326 NAND2X1 $PINS Z=n_6701 A=n_6400 B=spi_tx_data[7] VSS=VSS VDD=VDD
Xg118327 NAND2X1 $PINS Z=n_6700 A=n_6400 B=spi_tx_data[39] VSS=VSS VDD=VDD
Xg118328 NOR2X1 $PINS Z=n_6699 A=n_5943 B=n_6342 VSS=VSS VDD=VDD
Xg118330 MUX2X1 $PINS Z=n_6698 A=key_reg[63] B=spi_rx_data[63]
+ S=FE_DBTN0_n_6155 VSS=VSS VDD=VDD
Xg118331 MUX2X1 $PINS Z=n_6697 A=key_reg[62] B=spi_rx_data[62]
+ S=FE_DBTN0_n_6155 VSS=VSS VDD=VDD
Xg118332 MUX2X1 $PINS Z=n_6696 A=key_reg[61] B=spi_rx_data[61]
+ S=FE_DBTN0_n_6155 VSS=VSS VDD=VDD
Xg118333 MUX2X1 $PINS Z=n_6695 A=key_reg[60] B=spi_rx_data[60]
+ S=FE_DBTN0_n_6155 VSS=VSS VDD=VDD
Xg118334 MUX2X1 $PINS Z=n_6694 A=key_reg[59] B=spi_rx_data[59]
+ S=FE_DBTN0_n_6155 VSS=VSS VDD=VDD
Xg118335 MUX2X1 $PINS Z=n_6693 A=key_reg[58] B=spi_rx_data[58]
+ S=FE_DBTN0_n_6155 VSS=VSS VDD=VDD
Xg118336 MUX2X1 $PINS Z=n_6692 A=key_reg[57] B=spi_rx_data[57]
+ S=FE_DBTN0_n_6155 VSS=VSS VDD=VDD
Xg118337 NOR2X1 $PINS Z=n_6691 A=csm_inst_mode B=n_6508 VSS=VSS VDD=VDD
Xg118338 NAND2X1 $PINS Z=n_6690 A=n_6525 B=n_6115 VSS=VSS VDD=VDD
Xg118339 NAND2X1 $PINS Z=n_6689 A=n_6008 B=n_6507 VSS=VSS VDD=VDD
Xg118340 MUX2X1 $PINS Z=n_6688 A=key_reg[55] B=spi_rx_data[55]
+ S=FE_DBTN0_n_6155 VSS=VSS VDD=VDD
Xg118341 NAND2X1 $PINS Z=n_6687 A=n_6075 B=n_6506 VSS=VSS VDD=VDD
Xg118342 NAND2X1 $PINS Z=n_6686 A=n_6505 B=n_6006 VSS=VSS VDD=VDD
Xg118343 NAND2X1 $PINS Z=n_6685 A=n_6503 B=n_6111 VSS=VSS VDD=VDD
Xg118344 MUX2X1 $PINS Z=n_6684 A=key_reg[54] B=spi_rx_data[54]
+ S=FE_DBTN0_n_6155 VSS=VSS VDD=VDD
Xg118345 NAND3X1 $PINS Z=n_6683 A=n_5917 B=n_5916 C=n_6107 VSS=VSS VDD=VDD
Xg118346 MUX2X1 $PINS Z=n_6682 A=key_reg[53] B=spi_rx_data[53]
+ S=FE_DBTN0_n_6155 VSS=VSS VDD=VDD
Xg118347 MUX2X1 $PINS Z=n_6681 A=key_reg[52] B=spi_rx_data[52]
+ S=FE_DBTN0_n_6155 VSS=VSS VDD=VDD
Xg118348 MUX2X1 $PINS Z=n_6680 A=key_reg[51] B=spi_rx_data[51]
+ S=FE_DBTN0_n_6155 VSS=VSS VDD=VDD
Xg118349 NOR2X1 $PINS Z=n_6679 A=n_5913 B=n_6471 VSS=VSS VDD=VDD
Xg118350 MUX2X1 $PINS Z=n_6678 A=key_reg[50] B=spi_rx_data[50]
+ S=FE_DBTN0_n_6155 VSS=VSS VDD=VDD
Xg118351 MUX2X1 $PINS Z=n_6677 A=key_reg[49] B=spi_rx_data[49]
+ S=FE_DBTN0_n_6155 VSS=VSS VDD=VDD
Xg118352 NAND2X1 $PINS Z=n_6676 A=n_6357 B=n_5644 VSS=VSS VDD=VDD
Xg118353 MUX2X1 $PINS Z=n_6675 A=key_reg[47] B=spi_rx_data[47]
+ S=FE_DBTN0_n_6155 VSS=VSS VDD=VDD
Xg118354 MUX2X1 $PINS Z=n_6674 A=key_reg[46] B=spi_rx_data[46]
+ S=FE_DBTN0_n_6155 VSS=VSS VDD=VDD
Xg118355 MUX2X1 $PINS Z=n_6673 A=key_reg[45] B=spi_rx_data[45]
+ S=FE_DBTN0_n_6155 VSS=VSS VDD=VDD
Xg118356 NAND2X1 $PINS Z=n_6672 A=n_6410 B=csm_inst_mode VSS=VSS VDD=VDD
Xg118357 MUX2X1 $PINS Z=n_6671 A=key_reg[44] B=spi_rx_data[44]
+ S=FE_DBTN0_n_6155 VSS=VSS VDD=VDD
Xg118358 MUX2X1 $PINS Z=n_6670 A=key_reg[43] B=spi_rx_data[43]
+ S=FE_DBTN0_n_6155 VSS=VSS VDD=VDD
Xg118359 MUX2X1 $PINS Z=n_6669 A=key_reg[42] B=spi_rx_data[42]
+ S=FE_DBTN0_n_6155 VSS=VSS VDD=VDD
Xg118360 MUX2X1 $PINS Z=n_6668 A=key_reg[39] B=spi_rx_data[39]
+ S=FE_DBTN0_n_6155 VSS=VSS VDD=VDD
Xg118361 NAND2X1 $PINS Z=n_6667 A=n_6396 B=n_5973 VSS=VSS VDD=VDD
Xg118362 MUX2X1 $PINS Z=n_6666 A=key_reg[38] B=spi_rx_data[38]
+ S=FE_DBTN0_n_6155 VSS=VSS VDD=VDD
Xg118363 MUX2X1 $PINS Z=n_6665 A=key_reg[37] B=spi_rx_data[37]
+ S=FE_DBTN0_n_6155 VSS=VSS VDD=VDD
Xg118364 MUX2X1 $PINS Z=n_6664 A=key_reg[36] B=spi_rx_data[36]
+ S=FE_DBTN0_n_6155 VSS=VSS VDD=VDD
Xg118365 MUX2X1 $PINS Z=n_6663 A=key_reg[35] B=spi_rx_data[35]
+ S=FE_DBTN0_n_6155 VSS=VSS VDD=VDD
Xg118366 MUX2X1 $PINS Z=n_6662 A=key_reg[34] B=spi_rx_data[34]
+ S=FE_DBTN0_n_6155 VSS=VSS VDD=VDD
Xg118367 MUX2X1 $PINS Z=n_6661 A=key_reg[33] B=spi_rx_data[33]
+ S=FE_DBTN0_n_6155 VSS=VSS VDD=VDD
Xg118368 MUX2X1 $PINS Z=n_6660 A=key_reg[31] B=spi_rx_data[31]
+ S=FE_DBTN0_n_6155 VSS=VSS VDD=VDD
Xg118369 NAND2X1 $PINS Z=n_6659 A=n_6353 B=csm_inst_mode VSS=VSS VDD=VDD
Xg118370 MUX2X1 $PINS Z=n_6658 A=key_reg[30] B=spi_rx_data[30]
+ S=FE_DBTN0_n_6155 VSS=VSS VDD=VDD
Xg118371 MUX2X1 $PINS Z=n_6657 A=key_reg[29] B=spi_rx_data[29]
+ S=FE_DBTN0_n_6155 VSS=VSS VDD=VDD
Xg118372 NAND2X1 $PINS Z=n_6656 A=n_6383 B=FE_DBTN1_csm_inst_mode VSS=VSS
+ VDD=VDD
Xg118373 MUX2X1 $PINS Z=n_6655 A=key_reg[28] B=spi_rx_data[28]
+ S=FE_DBTN0_n_6155 VSS=VSS VDD=VDD
Xg118374 NAND3X1 $PINS Z=n_6654 A=n_6523 B=n_6201 C=n_5646 VSS=VSS VDD=VDD
Xg118375 NAND3X1 $PINS Z=n_6653 A=n_6498 B=n_6202 C=n_5645 VSS=VSS VDD=VDD
Xg118376 NAND3X1 $PINS Z=n_6652 A=n_6454 B=n_5661 C=n_5675 VSS=VSS VDD=VDD
Xg118377 NAND3X1 $PINS Z=n_6651 A=n_6433 B=n_6220 C=n_5730 VSS=VSS VDD=VDD
Xg118378 NAND3X1 $PINS Z=n_6650 A=n_6429 B=n_6214 C=n_5643 VSS=VSS VDD=VDD
Xg118379 NAND3X1 $PINS Z=n_6649 A=n_6428 B=n_6211 C=n_5642 VSS=VSS VDD=VDD
Xg118380 NAND3X1 $PINS Z=n_6648 A=n_6355 B=n_6199 C=n_5641 VSS=VSS VDD=VDD
Xg118381 NAND3X1 $PINS Z=n_6647 A=n_6427 B=n_6198 C=n_5640 VSS=VSS VDD=VDD
Xg118382 NAND3X1 $PINS Z=n_6646 A=n_6426 B=n_6197 C=n_5639 VSS=VSS VDD=VDD
Xg118383 NAND3X1 $PINS Z=n_6645 A=n_6425 B=n_6196 C=n_5638 VSS=VSS VDD=VDD
Xg118384 NAND3X1 $PINS Z=n_6644 A=n_6424 B=n_6195 C=n_5637 VSS=VSS VDD=VDD
Xg118385 NAND3X1 $PINS Z=n_6643 A=n_6423 B=n_6194 C=n_5636 VSS=VSS VDD=VDD
Xg118386 NAND3X1 $PINS Z=n_6642 A=n_6512 B=n_6165 C=n_5635 VSS=VSS VDD=VDD
Xg118387 NAND3X1 $PINS Z=n_6641 A=n_6421 B=n_6193 C=n_5634 VSS=VSS VDD=VDD
Xg118388 NAND3X1 $PINS Z=n_6640 A=n_6387 B=n_6221 C=n_5633 VSS=VSS VDD=VDD
Xg118389 NAND3X1 $PINS Z=n_6639 A=n_6420 B=n_6192 C=n_5632 VSS=VSS VDD=VDD
Xg118390 NAND3X1 $PINS Z=n_6638 A=n_6520 B=n_6191 C=n_5631 VSS=VSS VDD=VDD
Xg118391 NAND3X1 $PINS Z=n_6637 A=n_6363 B=n_6215 C=n_5630 VSS=VSS VDD=VDD
Xg118392 MUX2X1 $PINS Z=n_6636 A=key_reg[27] B=spi_rx_data[27]
+ S=FE_DBTN0_n_6155 VSS=VSS VDD=VDD
Xg118393 NAND3X1 $PINS Z=n_6635 A=n_6368 B=n_6223 C=n_5629 VSS=VSS VDD=VDD
Xg118394 NAND3X1 $PINS Z=n_6634 A=n_6418 B=n_6190 C=n_5628 VSS=VSS VDD=VDD
Xg118395 NAND3X1 $PINS Z=n_6633 A=n_6377 B=n_6225 C=n_5627 VSS=VSS VDD=VDD
Xg118396 NAND3X1 $PINS Z=n_6632 A=n_6417 B=n_6188 C=n_5626 VSS=VSS VDD=VDD
Xg118397 NAND3X1 $PINS Z=n_6631 A=n_6389 B=n_6217 C=n_5625 VSS=VSS VDD=VDD
Xg118398 NAND3X1 $PINS Z=n_6630 A=n_6416 B=n_6187 C=n_5692 VSS=VSS VDD=VDD
Xg118399 NAND3X1 $PINS Z=n_6629 A=n_6402 B=n_6186 C=n_5693 VSS=VSS VDD=VDD
Xg118400 NAND3X1 $PINS Z=n_6628 A=n_6510 B=n_6209 C=n_5694 VSS=VSS VDD=VDD
Xg118401 NAND3X1 $PINS Z=n_6627 A=n_6522 B=n_6200 C=n_5695 VSS=VSS VDD=VDD
Xg118402 NAND3X1 $PINS Z=n_6626 A=n_6414 B=n_6185 C=n_5696 VSS=VSS VDD=VDD
Xg118403 NAND3X1 $PINS Z=n_6625 A=n_6369 B=n_6184 C=n_5697 VSS=VSS VDD=VDD
Xg118404 NAND3X1 $PINS Z=n_6624 A=n_6413 B=n_6183 C=n_5698 VSS=VSS VDD=VDD
Xg118405 NAND3X1 $PINS Z=n_6623 A=n_6382 B=n_6205 C=n_5699 VSS=VSS VDD=VDD
Xg118406 NAND3X1 $PINS Z=n_6622 A=n_6412 B=n_6182 C=n_5700 VSS=VSS VDD=VDD
Xg118407 NAND3X1 $PINS Z=n_6621 A=n_6388 B=n_6162 C=n_5701 VSS=VSS VDD=VDD
Xg118408 NAND3X1 $PINS Z=n_6620 A=n_6391 B=n_6210 C=n_5733 VSS=VSS VDD=VDD
Xg118409 NAND3X1 $PINS Z=n_6619 A=n_6359 B=n_6180 C=n_5703 VSS=VSS VDD=VDD
Xg118410 NAND3X1 $PINS Z=n_6618 A=n_6365 B=n_6227 C=n_5704 VSS=VSS VDD=VDD
Xg118411 NAND3X1 $PINS Z=n_6617 A=n_6409 B=n_6179 C=n_5705 VSS=VSS VDD=VDD
Xg118412 NAND3X1 $PINS Z=n_6616 A=n_6385 B=n_6204 C=n_5706 VSS=VSS VDD=VDD
Xg118413 NAND3X1 $PINS Z=n_6615 A=n_6408 B=n_6178 C=n_5707 VSS=VSS VDD=VDD
Xg118414 NAND3X1 $PINS Z=n_6614 A=n_6349 B=n_6177 C=n_5708 VSS=VSS VDD=VDD
Xg118415 NAND3X1 $PINS Z=n_6613 A=n_6354 B=n_6176 C=n_5709 VSS=VSS VDD=VDD
Xg118416 MUX2X1 $PINS Z=n_6612 A=key_reg[41] B=spi_rx_data[41]
+ S=FE_DBTN0_n_6155 VSS=VSS VDD=VDD
Xg118417 NAND3X1 $PINS Z=n_6611 A=n_6370 B=n_6175 C=n_5710 VSS=VSS VDD=VDD
Xg118418 NAND3X1 $PINS Z=n_6610 A=n_6378 B=n_6174 C=n_5711 VSS=VSS VDD=VDD
Xg118419 NAND3X1 $PINS Z=n_6609 A=n_6393 B=n_6189 C=n_5712 VSS=VSS VDD=VDD
Xg118420 NAND3X1 $PINS Z=n_6608 A=n_6406 B=n_6173 C=n_5713 VSS=VSS VDD=VDD
Xg118421 NAND3X1 $PINS Z=n_6607 A=n_6390 B=n_6172 C=n_5714 VSS=VSS VDD=VDD
Xg118422 NAND3X1 $PINS Z=n_6606 A=n_6376 B=n_6212 C=n_5715 VSS=VSS VDD=VDD
Xg118423 NAND3X1 $PINS Z=n_6605 A=n_6379 B=n_6170 C=n_5717 VSS=VSS VDD=VDD
Xg118424 NAND3X1 $PINS Z=n_6604 A=n_6524 B=n_6222 C=n_5718 VSS=VSS VDD=VDD
Xg118425 NAND3X1 $PINS Z=n_6603 A=n_6404 B=n_6169 C=n_5719 VSS=VSS VDD=VDD
Xg118426 NAND3X1 $PINS Z=n_6602 A=n_6519 B=n_6213 C=n_5720 VSS=VSS VDD=VDD
Xg118427 NAND3X1 $PINS Z=n_6601 A=n_6403 B=n_6168 C=n_5721 VSS=VSS VDD=VDD
Xg118428 NAND3X1 $PINS Z=n_6600 A=n_6367 B=n_6167 C=n_5722 VSS=VSS VDD=VDD
Xg118429 NAND3X1 $PINS Z=n_6599 A=n_6347 B=n_6224 C=n_5724 VSS=VSS VDD=VDD
Xg118430 NAND3X1 $PINS Z=n_6598 A=n_6346 B=n_6219 C=n_5734 VSS=VSS VDD=VDD
Xg118431 NAND3X1 $PINS Z=n_6597 A=n_6384 B=n_6226 C=n_5728 VSS=VSS VDD=VDD
Xg118432 NAND3X1 $PINS Z=n_6596 A=n_6515 B=n_6164 C=n_5731 VSS=VSS VDD=VDD
Xg118433 NAND3X1 $PINS Z=n_6595 A=n_6360 B=n_6163 C=n_5735 VSS=VSS VDD=VDD
Xg118434 NAND3X1 $PINS Z=n_6594 A=n_6521 B=n_5555 C=n_5543 VSS=VSS VDD=VDD
Xg118435 NAND3X1 $PINS Z=n_6593 A=n_6394 B=n_5676 C=n_5655 VSS=VSS VDD=VDD
Xg118436 MUX2X1 $PINS Z=n_6592 A=key_reg[26] B=spi_rx_data[26]
+ S=FE_DBTN0_n_6155 VSS=VSS VDD=VDD
Xg118437 NAND3X1 $PINS Z=n_6591 A=n_6374 B=n_6216 C=n_5726 VSS=VSS VDD=VDD
Xg118438 NAND3X1 $PINS Z=n_6590 A=n_6392 B=n_6203 C=n_5727 VSS=VSS VDD=VDD
Xg118439 NAND3X1 $PINS Z=n_6589 A=n_6386 B=n_6181 C=n_5702 VSS=VSS VDD=VDD
Xg118440 NAND3X1 $PINS Z=n_6588 A=n_6380 B=n_6166 C=n_5729 VSS=VSS VDD=VDD
Xg118441 NAND3X1 $PINS Z=n_6587 A=n_6361 B=n_6218 C=n_5725 VSS=VSS VDD=VDD
Xg118442 NAND3X1 $PINS Z=n_6586 A=n_6372 B=n_6171 C=n_5716 VSS=VSS VDD=VDD
Xg118443 MUX2X1 $PINS Z=n_6585 A=key_reg[25] B=spi_rx_data[25]
+ S=FE_DBTN0_n_6155 VSS=VSS VDD=VDD
Xg118444 NAND3X1 $PINS Z=n_6584 A=n_6348 B=n_5501 C=n_5500 VSS=VSS VDD=VDD
Xg118445 MUX2X1 $PINS Z=n_6583 A=key_reg[1] B=spi_rx_data[1] S=FE_DBTN0_n_6155
+ VSS=VSS VDD=VDD
Xg118446 MUX2X1 $PINS Z=n_6582 A=key_reg[2] B=spi_rx_data[2] S=FE_DBTN0_n_6155
+ VSS=VSS VDD=VDD
Xg118447 MUX2X1 $PINS Z=n_6581 A=key_reg[3] B=spi_rx_data[3] S=FE_DBTN0_n_6155
+ VSS=VSS VDD=VDD
Xg118448 MUX2X1 $PINS Z=n_6580 A=key_reg[4] B=spi_rx_data[4] S=FE_DBTN0_n_6155
+ VSS=VSS VDD=VDD
Xg118449 MUX2X1 $PINS Z=n_6579 A=key_reg[5] B=spi_rx_data[5] S=FE_DBTN0_n_6155
+ VSS=VSS VDD=VDD
Xg118450 MUX2X1 $PINS Z=n_6578 A=key_reg[6] B=spi_rx_data[6] S=FE_DBTN0_n_6155
+ VSS=VSS VDD=VDD
Xg118451 MUX2X1 $PINS Z=n_6577 A=key_reg[7] B=spi_rx_data[7] S=FE_DBTN0_n_6155
+ VSS=VSS VDD=VDD
Xg118452 MUX2X1 $PINS Z=n_6576 A=key_reg[9] B=spi_rx_data[9] S=FE_DBTN0_n_6155
+ VSS=VSS VDD=VDD
Xg118453 MUX2X1 $PINS Z=n_6575 A=key_reg[10] B=spi_rx_data[10]
+ S=FE_DBTN0_n_6155 VSS=VSS VDD=VDD
Xg118454 MUX2X1 $PINS Z=n_6574 A=key_reg[11] B=spi_rx_data[11]
+ S=FE_DBTN0_n_6155 VSS=VSS VDD=VDD
Xg118455 MUX2X1 $PINS Z=n_6573 A=key_reg[12] B=spi_rx_data[12]
+ S=FE_DBTN0_n_6155 VSS=VSS VDD=VDD
Xg118456 MUX2X1 $PINS Z=n_6572 A=key_reg[13] B=spi_rx_data[13]
+ S=FE_DBTN0_n_6155 VSS=VSS VDD=VDD
Xg118457 MUX2X1 $PINS Z=n_6571 A=key_reg[14] B=spi_rx_data[14]
+ S=FE_DBTN0_n_6155 VSS=VSS VDD=VDD
Xg118458 MUX2X1 $PINS Z=n_6570 A=key_reg[15] B=spi_rx_data[15]
+ S=FE_DBTN0_n_6155 VSS=VSS VDD=VDD
Xg118459 MUX2X1 $PINS Z=n_6569 A=key_reg[17] B=spi_rx_data[17]
+ S=FE_DBTN0_n_6155 VSS=VSS VDD=VDD
Xg118460 MUX2X1 $PINS Z=n_6568 A=key_reg[18] B=spi_rx_data[18]
+ S=FE_DBTN0_n_6155 VSS=VSS VDD=VDD
Xg118461 MUX2X1 $PINS Z=n_6567 A=key_reg[19] B=spi_rx_data[19]
+ S=FE_DBTN0_n_6155 VSS=VSS VDD=VDD
Xg118462 MUX2X1 $PINS Z=n_6566 A=key_reg[20] B=spi_rx_data[20]
+ S=FE_DBTN0_n_6155 VSS=VSS VDD=VDD
Xg118463 MUX2X1 $PINS Z=n_6565 A=key_reg[21] B=spi_rx_data[21]
+ S=FE_DBTN0_n_6155 VSS=VSS VDD=VDD
Xg118464 MUX2X1 $PINS Z=n_6564 A=key_reg[22] B=spi_rx_data[22]
+ S=FE_DBTN0_n_6155 VSS=VSS VDD=VDD
Xg118465 MUX2X1 $PINS Z=n_6563 A=key_reg[23] B=spi_rx_data[23]
+ S=FE_DBTN0_n_6155 VSS=VSS VDD=VDD
Xg118466 NAND2X1 $PINS Z=n_6562 A=n_6411 B=n_6085 VSS=VSS VDD=VDD
Xg118467 NAND3X1 $PINS Z=n_6561 A=n_6344 B=n_6050 C=n_6056 VSS=VSS VDD=VDD
Xg118468 NAND3X1 $PINS Z=n_6560 A=n_6407 B=n_5997 C=n_5569 VSS=VSS VDD=VDD
Xg118469 NAND3X1 $PINS Z=n_6559 A=n_6419 B=n_5999 C=n_5575 VSS=VSS VDD=VDD
Xg118470 NAND3X1 $PINS Z=n_6558 A=n_5983 B=n_5893 C=n_5939 VSS=VSS VDD=VDD
Xg118471 NOR2X1 $PINS Z=n_6557 A=n_5996 B=n_6405 VSS=VSS VDD=VDD
Xg118472 NAND3X1 $PINS Z=n_6556 A=n_6364 B=n_5429 C=n_5489 VSS=VSS VDD=VDD
Xg118473 NAND2X1 $PINS Z=n_6555 A=n_6356 B=n_6033 VSS=VSS VDD=VDD
Xg118474 NAND2X1 $PINS Z=n_6554 A=n_6338 B=n_6366 VSS=VSS VDD=VDD
Xg118475 NOR2X1 $PINS Z=n_6553 A=n_5986 B=n_6373 VSS=VSS VDD=VDD
Xg118476 NOR2X1 $PINS Z=n_6552 A=n_5899 B=n_6339 VSS=VSS VDD=VDD
Xg118477 AND2X1 $PINS Z=n_6551 A=n_6358 B=n_6028 VSS=VSS VDD=VDD
Xg118478 NAND2X1 $PINS Z=n_6550 A=n_6381 B=n_6054 VSS=VSS VDD=VDD
Xg118479 NAND2X1 $PINS Z=n_6549 A=n_6395 B=n_6070 VSS=VSS VDD=VDD
Xg118480 NOR2X1 $PINS Z=n_6548 A=n_5982 B=n_6398 VSS=VSS VDD=VDD
Xg118481 NOR2X1 $PINS Z=n_6547 A=n_5992 B=n_6371 VSS=VSS VDD=VDD
Xg118482 NAND2X1 $PINS Z=n_6546 A=n_6336 B=n_6074 VSS=VSS VDD=VDD
Xg118483 NOR2X1 $PINS Z=n_6545 A=n_6018 B=n_6351 VSS=VSS VDD=VDD
Xg118484 NAND3X1 $PINS Z=n_6544 A=n_6352 B=n_5419 C=n_5508 VSS=VSS VDD=VDD
Xg118485 NAND2X1 $PINS Z=n_6543 A=n_6415 B=n_6025 VSS=VSS VDD=VDD
Xg118486 NAND2X1 $PINS Z=n_6542 A=n_6422 B=n_6345 VSS=VSS VDD=VDD
Xg118487 NAND3X1 $PINS Z=n_6541 A=n_6430 B=n_6207 C=n_5862 VSS=VSS VDD=VDD
Xg118488 NAND2X1 $PINS Z=n_6540 A=n_6438 B=n_6089 VSS=VSS VDD=VDD
Xg118489 NAND2X1 $PINS Z=n_6539 A=n_6481 B=n_6493 VSS=VSS VDD=VDD
Xg118490 NOR2X1 $PINS Z=n_6538 A=n_5990 B=n_6497 VSS=VSS VDD=VDD
Xg118491 NAND2X1 $PINS Z=n_6537 A=n_6499 B=n_6105 VSS=VSS VDD=VDD
Xg118492 NAND2X1 $PINS Z=n_6536 A=n_6500 B=n_6108 VSS=VSS VDD=VDD
Xg118493 NOR2X1 $PINS Z=n_6535 A=n_5957 B=n_6504 VSS=VSS VDD=VDD
Xg118494 NAND2X1 $PINS Z=n_6534 A=n_6501 B=n_6116 VSS=VSS VDD=VDD
Xg118495 NOR2X1 $PINS Z=n_6533 A=n_5998 B=n_6509 VSS=VSS VDD=VDD
Xg118496 NAND2X1 $PINS Z=n_6532 A=n_6511 B=n_6117 VSS=VSS VDD=VDD
Xg118497 NAND2X1 $PINS Z=n_6531 A=n_6513 B=n_6119 VSS=VSS VDD=VDD
Xg118498 NAND2X1 $PINS Z=n_6530 A=n_6514 B=n_6121 VSS=VSS VDD=VDD
Xg118500 NOR2X1 $PINS Z=n_6528 A=n_6009 B=n_6517 VSS=VSS VDD=VDD
Xg118501 OR2X1 $PINS Z=n_6527 A=n_6010 B=n_6518 VSS=VSS VDD=VDD
Xg118502 NAND2X1 $PINS Z=n_6526 A=n_6042 B=n_6262 VSS=VSS VDD=VDD
Xg118503 NAND2X1 $PINS Z=n_6525 A=n_6114 B=spi_inst_bit_count[1] VSS=VSS
+ VDD=VDD
Xg118504 NAND2X1 $PINS Z=n_6524 A=n_6157 B=spi_inst_shift_out[47] VSS=VSS
+ VDD=VDD
Xg118505 NAND2X1 $PINS Z=n_6523 A=n_6157 B=spi_inst_shift_out[56] VSS=VSS
+ VDD=VDD
Xg118506 NAND2X1 $PINS Z=n_6522 A=n_6157 B=spi_inst_shift_out[23] VSS=VSS
+ VDD=VDD
Xg118507 OR2X1 $PINS Z=n_6521 A=FE_DBTN1_csm_inst_mode B=n_6076 VSS=VSS VDD=VDD
Xg118508 NAND2X1 $PINS Z=n_6520 A=n_6157 B=spi_inst_shift_out[13] VSS=VSS
+ VDD=VDD
Xg118509 NAND2X1 $PINS Z=n_6519 A=n_6157 B=spi_inst_shift_out[49] VSS=VSS
+ VDD=VDD
Xg118510 NOR2X1 $PINS Z=n_6518 A=FE_DBTN1_csm_inst_mode B=n_6128 VSS=VSS
+ VDD=VDD
Xg118511 NOR2X1 $PINS Z=n_6517 A=FE_DBTN1_csm_inst_mode B=n_6073 VSS=VSS
+ VDD=VDD
Xg118512 NAND2X1 $PINS Z=n_6516 A=n_6002 B=csm_inst_mode VSS=VSS VDD=VDD
Xg118513 NAND2X1 $PINS Z=n_6515 A=n_6157 B=spi_inst_shift_out[61] VSS=VSS
+ VDD=VDD
Xg118514 OR2X1 $PINS Z=n_6514 A=FE_DBTN1_csm_inst_mode B=n_6122 VSS=VSS VDD=VDD
Xg118515 OR2X1 $PINS Z=n_6513 A=csm_inst_mode B=n_6045 VSS=VSS VDD=VDD
Xg118516 NAND2X1 $PINS Z=n_6512 A=n_6157 B=spi_inst_shift_out[9] VSS=VSS
+ VDD=VDD
Xg118517 OR2X1 $PINS Z=n_6511 A=FE_DBTN1_csm_inst_mode B=n_6118 VSS=VSS VDD=VDD
Xg118518 NAND2X1 $PINS Z=n_6510 A=n_6157 B=spi_inst_shift_out[22] VSS=VSS
+ VDD=VDD
Xg118519 NAND3X1 $PINS Z=n_6509 A=n_5892 B=n_5908 C=n_5923 VSS=VSS VDD=VDD
Xg118520 NOR2X1 $PINS Z=n_6508 A=n_5469 B=n_6005 VSS=VSS VDD=VDD
Xg118521 NAND2X1 $PINS Z=n_6507 A=n_6160 B=spi_inst_bit_count[2] VSS=VSS
+ VDD=VDD
Xg118522 NAND2X1 $PINS Z=n_6506 A=n_6160 B=spi_inst_bit_count[3] VSS=VSS
+ VDD=VDD
Xg118523 NAND2X1 $PINS Z=n_6505 A=n_6159 B=spi_inst_bit_count[4] VSS=VSS
+ VDD=VDD
Xg118524 NAND3X1 $PINS Z=n_6504 A=n_5921 B=n_5920 C=n_5919 VSS=VSS VDD=VDD
Xg118525 NAND2X1 $PINS Z=n_6503 A=n_6159 B=spi_inst_bit_count[5] VSS=VSS
+ VDD=VDD
Xg118526 OR2X1 $PINS Z=n_6502 A=n_5723 B=n_6159 VSS=VSS VDD=VDD
Xg118527 OR2X1 $PINS Z=n_6501 A=FE_DBTN1_csm_inst_mode B=n_6083 VSS=VSS VDD=VDD
Xg118528 OR2X1 $PINS Z=n_6500 A=csm_inst_mode B=n_6109 VSS=VSS VDD=VDD
Xg118529 OR2X1 $PINS Z=n_6499 A=csm_inst_mode B=n_6106 VSS=VSS VDD=VDD
Xg118530 NAND2X1 $PINS Z=n_6498 A=n_6157 B=miso VSS=VSS VDD=VDD
Xg118531 NOR2X1 $PINS Z=n_6497 A=csm_inst_mode B=n_6103 VSS=VSS VDD=VDD
Xg118532 NAND2X1 $PINS Z=n_6496 A=n_6048 B=n_6232 VSS=VSS VDD=VDD
Xg118533 NAND2X1 $PINS Z=n_6495 A=n_6063 B=n_6233 VSS=VSS VDD=VDD
Xg118534 NAND2X1 $PINS Z=n_6494 A=n_6088 B=n_6234 VSS=VSS VDD=VDD
Xg118535 OR2X1 $PINS Z=n_6493 A=csm_inst_mode B=n_6068 VSS=VSS VDD=VDD
Xg118536 NAND2X1 $PINS Z=n_6492 A=n_6129 B=n_6235 VSS=VSS VDD=VDD
Xg118537 NAND2X1 $PINS Z=n_6491 A=n_6130 B=n_6236 VSS=VSS VDD=VDD
Xg118538 NAND2X1 $PINS Z=n_6490 A=n_6131 B=n_6237 VSS=VSS VDD=VDD
Xg118539 NAND2X1 $PINS Z=n_6489 A=n_6101 B=n_6238 VSS=VSS VDD=VDD
Xg118540 NAND2X1 $PINS Z=n_6488 A=n_6061 B=n_6239 VSS=VSS VDD=VDD
Xg118541 NAND2X1 $PINS Z=n_6487 A=n_6059 B=n_6240 VSS=VSS VDD=VDD
Xg118542 NAND2X1 $PINS Z=n_6486 A=n_6126 B=n_6241 VSS=VSS VDD=VDD
Xg118543 NAND2X1 $PINS Z=n_6485 A=n_6100 B=n_6242 VSS=VSS VDD=VDD
Xg118544 NAND2X1 $PINS Z=n_6484 A=n_6031 B=n_6243 VSS=VSS VDD=VDD
Xg118545 NAND2X1 $PINS Z=n_6483 A=n_6067 B=n_6244 VSS=VSS VDD=VDD
Xg118546 NAND2X1 $PINS Z=n_6482 A=n_6133 B=n_6245 VSS=VSS VDD=VDD
Xg118547 NOR2X1 $PINS Z=n_6481 A=n_5422 B=n_6001 VSS=VSS VDD=VDD
Xg118548 NAND2X1 $PINS Z=n_6480 A=n_6136 B=n_6246 VSS=VSS VDD=VDD
Xg118549 NAND2X1 $PINS Z=n_6479 A=n_6043 B=n_6247 VSS=VSS VDD=VDD
Xg118550 NAND2X1 $PINS Z=n_6478 A=n_6046 B=n_6248 VSS=VSS VDD=VDD
Xg118551 NAND2X1 $PINS Z=n_6477 A=n_6035 B=n_6249 VSS=VSS VDD=VDD
Xg118552 NAND2X1 $PINS Z=n_6476 A=n_6099 B=n_6250 VSS=VSS VDD=VDD
Xg118553 NAND2X1 $PINS Z=n_6475 A=n_6062 B=n_6251 VSS=VSS VDD=VDD
Xg118554 NAND2X1 $PINS Z=n_6474 A=n_6044 B=n_6252 VSS=VSS VDD=VDD
Xg118555 NAND2X1 $PINS Z=n_6473 A=n_6030 B=n_6253 VSS=VSS VDD=VDD
Xg118556 NAND2X1 $PINS Z=n_6472 A=n_6135 B=n_6254 VSS=VSS VDD=VDD
Xg118557 NOR2X1 $PINS Z=n_6471 A=n_5438 B=n_6120 VSS=VSS VDD=VDD
Xg118558 NAND2X1 $PINS Z=n_6470 A=n_6021 B=n_6255 VSS=VSS VDD=VDD
Xg118559 NAND2X1 $PINS Z=n_6469 A=n_6110 B=n_6256 VSS=VSS VDD=VDD
Xg118560 NAND2X1 $PINS Z=n_6468 A=n_6026 B=n_6257 VSS=VSS VDD=VDD
Xg118561 NAND2X1 $PINS Z=n_6467 A=n_6098 B=n_6258 VSS=VSS VDD=VDD
Xg118562 NAND2X1 $PINS Z=n_6466 A=n_6029 B=n_6259 VSS=VSS VDD=VDD
Xg118563 NAND2X1 $PINS Z=n_6465 A=n_6094 B=n_6260 VSS=VSS VDD=VDD
Xg118564 NAND2X1 $PINS Z=n_6464 A=n_6039 B=n_6261 VSS=VSS VDD=VDD
Xg118566 NAND2X1 $PINS Z=n_6463 A=n_6091 B=n_6263 VSS=VSS VDD=VDD
Xg118567 NAND2X1 $PINS Z=n_6462 A=n_6097 B=n_6264 VSS=VSS VDD=VDD
Xg118568 NAND2X1 $PINS Z=n_6461 A=n_6060 B=n_6265 VSS=VSS VDD=VDD
Xg118569 NAND2X1 $PINS Z=n_6460 A=n_6096 B=n_6266 VSS=VSS VDD=VDD
Xg118570 NAND2X1 $PINS Z=n_6459 A=n_6124 B=n_6267 VSS=VSS VDD=VDD
Xg118571 NAND2X1 $PINS Z=n_6458 A=n_6034 B=n_6268 VSS=VSS VDD=VDD
Xg118572 NAND2X1 $PINS Z=n_6457 A=n_6019 B=n_6269 VSS=VSS VDD=VDD
Xg118573 NAND2X1 $PINS Z=n_6456 A=n_6077 B=n_6270 VSS=VSS VDD=VDD
Xg118574 NAND2X1 $PINS Z=n_6455 A=n_6040 B=n_6271 VSS=VSS VDD=VDD
Xg118575 OR2X1 $PINS Z=n_6454 A=csm_inst_mode B=n_6057 VSS=VSS VDD=VDD
Xg118576 NAND2X1 $PINS Z=n_6453 A=n_6125 B=n_6272 VSS=VSS VDD=VDD
Xg118577 NAND2X1 $PINS Z=n_6452 A=n_6082 B=n_6273 VSS=VSS VDD=VDD
Xg118578 NAND2X1 $PINS Z=n_6451 A=n_6095 B=n_6065 VSS=VSS VDD=VDD
Xg118579 NAND2X1 $PINS Z=n_6450 A=n_6080 B=n_6153 VSS=VSS VDD=VDD
Xg118580 NAND2X1 $PINS Z=n_6449 A=n_6020 B=n_6152 VSS=VSS VDD=VDD
Xg118581 NAND2X1 $PINS Z=n_6448 A=n_6038 B=n_6151 VSS=VSS VDD=VDD
Xg118582 NAND2X1 $PINS Z=n_6447 A=n_6027 B=n_6150 VSS=VSS VDD=VDD
Xg118583 NAND2X1 $PINS Z=n_6446 A=n_6154 B=n_6149 VSS=VSS VDD=VDD
Xg118584 NAND2X1 $PINS Z=n_6445 A=n_6041 B=n_6229 VSS=VSS VDD=VDD
Xg118585 NAND2X1 $PINS Z=n_6444 A=n_6093 B=n_6143 VSS=VSS VDD=VDD
Xg118586 NAND2X1 $PINS Z=n_6443 A=n_6064 B=n_6231 VSS=VSS VDD=VDD
Xg118587 NAND2X1 $PINS Z=n_6442 A=n_6092 B=n_6139 VSS=VSS VDD=VDD
Xg118588 NAND2X1 $PINS Z=n_6441 A=n_6053 B=n_6145 VSS=VSS VDD=VDD
Xg118589 NAND2X1 $PINS Z=n_6440 A=n_6037 B=n_6142 VSS=VSS VDD=VDD
Xg118590 NAND2X1 $PINS Z=n_6439 A=n_6078 B=n_6146 VSS=VSS VDD=VDD
Xg118591 OR2X1 $PINS Z=n_6438 A=FE_DBTN1_csm_inst_mode B=n_6134 VSS=VSS VDD=VDD
Xg118592 NAND2X1 $PINS Z=n_6437 A=n_6052 B=n_6148 VSS=VSS VDD=VDD
Xg118593 NAND2X1 $PINS Z=n_6436 A=n_6051 B=n_6228 VSS=VSS VDD=VDD
Xg118594 NAND2X1 $PINS Z=n_6435 A=n_6132 B=n_6230 VSS=VSS VDD=VDD
Xg118595 NAND2X1 $PINS Z=n_6434 A=n_6090 B=n_6140 VSS=VSS VDD=VDD
Xg118596 NAND2X1 $PINS Z=n_6433 A=n_6157 B=spi_inst_shift_out[60] VSS=VSS
+ VDD=VDD
Xg118597 NAND2X1 $PINS Z=n_6432 A=n_6024 B=n_6147 VSS=VSS VDD=VDD
Xg118598 NAND2X1 $PINS Z=n_6431 A=n_6016 B=n_6137 VSS=VSS VDD=VDD
Xg118599 NOR2X1 $PINS Z=n_6430 A=n_5463 B=n_5994 VSS=VSS VDD=VDD
Xg118600 NAND2X1 $PINS Z=n_6429 A=n_6157 B=spi_inst_shift_out[1] VSS=VSS
+ VDD=VDD
Xg118601 NAND2X1 $PINS Z=n_6428 A=n_6157 B=spi_inst_shift_out[2] VSS=VSS
+ VDD=VDD
Xg118602 NAND2X1 $PINS Z=n_6427 A=n_6157 B=spi_inst_shift_out[4] VSS=VSS
+ VDD=VDD
Xg118603 NAND2X1 $PINS Z=n_6426 A=n_6157 B=spi_inst_shift_out[5] VSS=VSS
+ VDD=VDD
Xg118604 NAND2X1 $PINS Z=n_6425 A=n_6157 B=spi_inst_shift_out[6] VSS=VSS
+ VDD=VDD
Xg118605 NAND2X1 $PINS Z=n_6424 A=n_6157 B=spi_inst_shift_out[7] VSS=VSS
+ VDD=VDD
Xg118606 NAND2X1 $PINS Z=n_6423 A=n_6157 B=spi_inst_shift_out[8] VSS=VSS
+ VDD=VDD
Xg118607 NOR2X1 $PINS Z=n_6422 A=n_5433 B=n_6000 VSS=VSS VDD=VDD
Xg118608 NAND2X1 $PINS Z=n_6421 A=n_6157 B=spi_inst_shift_out[10] VSS=VSS
+ VDD=VDD
Xg118609 NAND2X1 $PINS Z=n_6420 A=n_6157 B=spi_inst_shift_out[12] VSS=VSS
+ VDD=VDD
Xg118610 NAND2X1 $PINS Z=n_6419 A=n_6113 B=csm_inst_mode VSS=VSS VDD=VDD
Xg118611 NAND2X1 $PINS Z=n_6418 A=n_6157 B=spi_inst_shift_out[16] VSS=VSS
+ VDD=VDD
Xg118612 NAND2X1 $PINS Z=n_6417 A=n_6157 B=spi_inst_shift_out[18] VSS=VSS
+ VDD=VDD
Xg118613 NAND2X1 $PINS Z=n_6416 A=n_6157 B=spi_inst_shift_out[20] VSS=VSS
+ VDD=VDD
Xg118614 OR2X1 $PINS Z=n_6415 A=FE_DBTN1_csm_inst_mode B=n_6058 VSS=VSS VDD=VDD
Xg118615 NAND2X1 $PINS Z=n_6414 A=n_6157 B=spi_inst_shift_out[24] VSS=VSS
+ VDD=VDD
Xg118616 NAND2X1 $PINS Z=n_6413 A=n_6157 B=spi_inst_shift_out[26] VSS=VSS
+ VDD=VDD
Xg118617 NAND2X1 $PINS Z=n_6412 A=n_6157 B=spi_inst_shift_out[28] VSS=VSS
+ VDD=VDD
Xg118618 OR2X1 $PINS Z=n_6411 A=FE_DBTN1_csm_inst_mode B=n_6087 VSS=VSS VDD=VDD
Xg118619 NAND3X1 $PINS Z=n_6410 A=n_5885 B=n_5486 C=n_5756 VSS=VSS VDD=VDD
Xg118620 NAND2X1 $PINS Z=n_6409 A=n_6157 B=spi_inst_shift_out[34] VSS=VSS
+ VDD=VDD
Xg118621 NAND2X1 $PINS Z=n_6408 A=n_6157 B=spi_inst_shift_out[36] VSS=VSS
+ VDD=VDD
Xg118622 OR2X1 $PINS Z=n_6407 A=FE_DBTN1_csm_inst_mode B=n_6084 VSS=VSS VDD=VDD
Xg118623 NAND2X1 $PINS Z=n_6406 A=n_6157 B=spi_inst_shift_out[42] VSS=VSS
+ VDD=VDD
Xg118624 NOR2X1 $PINS Z=n_6405 A=FE_DBTN1_csm_inst_mode B=n_6081 VSS=VSS
+ VDD=VDD
Xg118625 NAND2X1 $PINS Z=n_6404 A=n_6157 B=spi_inst_shift_out[48] VSS=VSS
+ VDD=VDD
Xg118626 NAND2X1 $PINS Z=n_6403 A=n_6157 B=spi_inst_shift_out[50] VSS=VSS
+ VDD=VDD
Xg118627 NAND2X1 $PINS Z=n_6402 A=n_6157 B=spi_inst_shift_out[21] VSS=VSS
+ VDD=VDD
Xg118628 NOR2X1 $PINS Z=n_6401 A=n_6012 B=n_6013 VSS=VSS VDD=VDD
Xg118629 MUX2X1 $PINS Z=n_6399 A=spi_rx_data[1] B=data_reg[1] S=n_5973 VSS=VSS
+ VDD=VDD
Xg118630 NAND3X1 $PINS Z=n_6398 A=n_5922 B=n_5906 C=n_5905 VSS=VSS VDD=VDD
Xg118631 NAND2X1 $PINS Z=n_6397 A=n_6049 B=n_5976 VSS=VSS VDD=VDD
Xg118632 NAND2X1 $PINS Z=n_6396 A=n_6208 B=transaction_state[1] VSS=VSS VDD=VDD
Xg118633 OR2X1 $PINS Z=n_6395 A=csm_inst_mode B=n_6071 VSS=VSS VDD=VDD
Xg118634 OR2X1 $PINS Z=n_6394 A=csm_inst_mode B=n_6069 VSS=VSS VDD=VDD
Xg118635 NAND2X1 $PINS Z=n_6393 A=n_6157 B=spi_inst_shift_out[41] VSS=VSS
+ VDD=VDD
Xg118636 NAND2X1 $PINS Z=n_6392 A=n_6157 B=spi_inst_shift_out[55] VSS=VSS
+ VDD=VDD
Xg118637 NAND2X1 $PINS Z=n_6391 A=n_6157 B=spi_inst_shift_out[30] VSS=VSS
+ VDD=VDD
Xg118638 NAND2X1 $PINS Z=n_6390 A=n_6157 B=spi_inst_shift_out[43] VSS=VSS
+ VDD=VDD
Xg118639 NAND2X1 $PINS Z=n_6389 A=n_6157 B=spi_inst_shift_out[19] VSS=VSS
+ VDD=VDD
Xg118640 NAND2X1 $PINS Z=n_6388 A=n_6157 B=spi_inst_shift_out[29] VSS=VSS
+ VDD=VDD
Xg118641 NAND2X1 $PINS Z=n_6387 A=n_6157 B=spi_inst_shift_out[11] VSS=VSS
+ VDD=VDD
Xg118642 NAND2X1 $PINS Z=n_6386 A=n_6157 B=spi_inst_shift_out[31] VSS=VSS
+ VDD=VDD
Xg118643 NAND2X1 $PINS Z=n_6385 A=n_6157 B=spi_inst_shift_out[35] VSS=VSS
+ VDD=VDD
Xg118644 NAND2X1 $PINS Z=n_6384 A=n_6157 B=spi_inst_shift_out[57] VSS=VSS
+ VDD=VDD
Xg118645 NAND3X1 $PINS Z=n_6383 A=n_6206 B=n_5753 C=n_5304 VSS=VSS VDD=VDD
Xg118646 NAND2X1 $PINS Z=n_6382 A=n_6157 B=spi_inst_shift_out[27] VSS=VSS
+ VDD=VDD
Xg118647 OR2X1 $PINS Z=n_6381 A=FE_DBTN1_csm_inst_mode B=n_6055 VSS=VSS VDD=VDD
Xg118648 NAND2X1 $PINS Z=n_6380 A=n_6157 B=spi_inst_shift_out[59] VSS=VSS
+ VDD=VDD
Xg118649 NAND2X1 $PINS Z=n_6379 A=n_6157 B=spi_inst_shift_out[46] VSS=VSS
+ VDD=VDD
Xg118650 NAND2X1 $PINS Z=n_6378 A=n_6157 B=spi_inst_shift_out[40] VSS=VSS
+ VDD=VDD
Xg118651 NAND2X1 $PINS Z=n_6377 A=n_6157 B=spi_inst_shift_out[17] VSS=VSS
+ VDD=VDD
Xg118652 NAND2X1 $PINS Z=n_6376 A=n_6157 B=spi_inst_shift_out[44] VSS=VSS
+ VDD=VDD
Xg118653 NAND2X1 $PINS Z=n_6375 A=n_6047 B=n_6144 VSS=VSS VDD=VDD
Xg118654 NAND2X1 $PINS Z=n_6374 A=n_6157 B=spi_inst_shift_out[54] VSS=VSS
+ VDD=VDD
Xg118655 NAND3X1 $PINS Z=n_6373 A=n_5895 B=n_5896 C=n_5894 VSS=VSS VDD=VDD
Xg118656 NAND2X1 $PINS Z=n_6372 A=n_6157 B=spi_inst_shift_out[45] VSS=VSS
+ VDD=VDD
Xg118657 NOR2X1 $PINS Z=n_6371 A=csm_inst_mode B=n_6072 VSS=VSS VDD=VDD
Xg118658 NAND2X1 $PINS Z=n_6370 A=n_6157 B=spi_inst_shift_out[39] VSS=VSS
+ VDD=VDD
Xg118659 NAND2X1 $PINS Z=n_6369 A=n_6157 B=spi_inst_shift_out[25] VSS=VSS
+ VDD=VDD
Xg118660 NAND2X1 $PINS Z=n_6368 A=n_6157 B=spi_inst_shift_out[15] VSS=VSS
+ VDD=VDD
Xg118661 NAND2X1 $PINS Z=n_6367 A=n_6157 B=spi_inst_shift_out[51] VSS=VSS
+ VDD=VDD
Xg118662 NAND3X1 $PINS Z=n_6366 A=n_6032 B=n_5914 C=n_5623 VSS=VSS VDD=VDD
Xg118663 NAND2X1 $PINS Z=n_6365 A=n_6157 B=spi_inst_shift_out[33] VSS=VSS
+ VDD=VDD
Xg118664 NOR2X1 $PINS Z=n_6364 A=n_5910 B=n_5981 VSS=VSS VDD=VDD
Xg118665 NAND2X1 $PINS Z=n_6363 A=n_6157 B=spi_inst_shift_out[14] VSS=VSS
+ VDD=VDD
Xg118666 NAND2X1 $PINS Z=n_6362 A=n_6066 B=n_6141 VSS=VSS VDD=VDD
Xg118667 NAND2X1 $PINS Z=n_6361 A=n_6157 B=spi_inst_shift_out[53] VSS=VSS
+ VDD=VDD
Xg118668 NAND2X1 $PINS Z=n_6360 A=n_6157 B=spi_inst_shift_out[62] VSS=VSS
+ VDD=VDD
Xg118669 NAND2X1 $PINS Z=n_6359 A=n_6157 B=spi_inst_shift_out[32] VSS=VSS
+ VDD=VDD
Xg118670 NAND2X1 $PINS Z=n_6358 A=n_5989 B=csm_inst_mode VSS=VSS VDD=VDD
Xg118671 NAND2X1 $PINS Z=n_6357 A=n_6157 B=spi_inst_shift_out[0] VSS=VSS
+ VDD=VDD
Xg118672 OR2X1 $PINS Z=n_6356 A=FE_DBTN1_csm_inst_mode B=n_6036 VSS=VSS VDD=VDD
Xg118673 NAND2X1 $PINS Z=n_6355 A=n_6157 B=spi_inst_shift_out[3] VSS=VSS
+ VDD=VDD
Xg118674 NAND2X1 $PINS Z=n_6354 A=n_6157 B=spi_inst_shift_out[38] VSS=VSS
+ VDD=VDD
Xg118675 OR2X1 $PINS Z=n_6353 A=n_5417 B=n_6102 VSS=VSS VDD=VDD
Xg118676 NOR2X1 $PINS Z=n_6352 A=n_5937 B=n_6104 VSS=VSS VDD=VDD
Xg118677 NOR2X1 $PINS Z=n_6351 A=csm_inst_mode B=n_6079 VSS=VSS VDD=VDD
Xg118678 NAND2X1 $PINS Z=n_6350 A=n_6023 B=n_6138 VSS=VSS VDD=VDD
Xg118679 NAND2X1 $PINS Z=n_6349 A=n_6157 B=spi_inst_shift_out[37] VSS=VSS
+ VDD=VDD
Xg118680 OR2X1 $PINS Z=n_6348 A=FE_DBTN1_csm_inst_mode B=n_6017 VSS=VSS VDD=VDD
Xg118681 NAND2X1 $PINS Z=n_6347 A=n_6157 B=spi_inst_shift_out[52] VSS=VSS
+ VDD=VDD
Xg118682 NAND2X1 $PINS Z=n_6346 A=n_6157 B=spi_inst_shift_out[58] VSS=VSS
+ VDD=VDD
Xg118683 NAND2X1 $PINS Z=n_6345 A=n_5985 B=FE_DBTN1_csm_inst_mode VSS=VSS
+ VDD=VDD
Xg118684 NAND2X1 $PINS Z=n_6344 A=n_5991 B=FE_DBTN1_csm_inst_mode VSS=VSS
+ VDD=VDD
Xg118685 MUX2X1 $PINS Z=n_6343 A=n_5974 B=n_144 S=spi_inst_bit_count[0] VSS=VSS
+ VDD=VDD
Xg118686 NAND3X1 $PINS Z=n_6342 A=n_6127 B=n_5602 C=n_5665 VSS=VSS VDD=VDD
Xg118688 NAND3X1 $PINS Z=n_6340 A=n_5940 B=n_5682 C=n_5624 VSS=VSS VDD=VDD
Xg118689 NAND3X1 $PINS Z=n_6339 A=n_5988 B=n_5654 C=n_5672 VSS=VSS VDD=VDD
Xg118690 NAND3X1 $PINS Z=n_6338 A=n_6161 B=n_5688 C=n_5930 VSS=VSS VDD=VDD
Xg118691 MUX2X1 $PINS Z=n_6337 A=spi_rx_data[0] B=data_reg[0] S=n_5973 VSS=VSS
+ VDD=VDD
Xg118692 NAND2X1 $PINS Z=n_6336 A=n_6011 B=csm_inst_mode VSS=VSS VDD=VDD
Xg118693 MUX2X1 $PINS Z=n_6335 A=spi_rx_data[2] B=data_reg[2] S=n_5973 VSS=VSS
+ VDD=VDD
Xg118694 MUX2X1 $PINS Z=n_6334 A=spi_rx_data[3] B=data_reg[3] S=n_5973 VSS=VSS
+ VDD=VDD
Xg118695 MUX2X1 $PINS Z=n_6333 A=spi_rx_data[4] B=data_reg[4] S=n_5973 VSS=VSS
+ VDD=VDD
Xg118696 MUX2X1 $PINS Z=n_6332 A=spi_rx_data[5] B=data_reg[5] S=n_5973 VSS=VSS
+ VDD=VDD
Xg118697 MUX2X1 $PINS Z=n_6331 A=spi_rx_data[6] B=data_reg[6] S=n_5973 VSS=VSS
+ VDD=VDD
Xg118698 MUX2X1 $PINS Z=n_6330 A=spi_rx_data[7] B=data_reg[7] S=n_5973 VSS=VSS
+ VDD=VDD
Xg118699 MUX2X1 $PINS Z=n_6329 A=spi_rx_data[8] B=data_reg[8] S=n_5973 VSS=VSS
+ VDD=VDD
Xg118700 MUX2X1 $PINS Z=n_6328 A=spi_rx_data[9] B=data_reg[9] S=n_5973 VSS=VSS
+ VDD=VDD
Xg118701 MUX2X1 $PINS Z=n_6327 A=spi_rx_data[10] B=data_reg[10] S=n_5973
+ VSS=VSS VDD=VDD
Xg118702 MUX2X1 $PINS Z=n_6326 A=spi_rx_data[11] B=data_reg[11] S=n_5973
+ VSS=VSS VDD=VDD
Xg118703 MUX2X1 $PINS Z=n_6325 A=spi_rx_data[12] B=data_reg[12] S=n_5973
+ VSS=VSS VDD=VDD
Xg118704 MUX2X1 $PINS Z=n_6324 A=spi_rx_data[13] B=data_reg[13] S=n_5973
+ VSS=VSS VDD=VDD
Xg118705 MUX2X1 $PINS Z=n_6323 A=spi_rx_data[14] B=data_reg[14] S=n_5973
+ VSS=VSS VDD=VDD
Xg118706 MUX2X1 $PINS Z=n_6322 A=spi_rx_data[15] B=data_reg[15] S=n_5973
+ VSS=VSS VDD=VDD
Xg118707 MUX2X1 $PINS Z=n_6321 A=spi_rx_data[16] B=data_reg[16] S=n_5973
+ VSS=VSS VDD=VDD
Xg118708 MUX2X1 $PINS Z=n_6320 A=spi_rx_data[17] B=data_reg[17] S=n_5973
+ VSS=VSS VDD=VDD
Xg118709 MUX2X1 $PINS Z=n_6319 A=spi_rx_data[18] B=data_reg[18] S=n_5973
+ VSS=VSS VDD=VDD
Xg118710 MUX2X1 $PINS Z=n_6318 A=spi_rx_data[19] B=data_reg[19] S=n_5973
+ VSS=VSS VDD=VDD
Xg118711 MUX2X1 $PINS Z=n_6317 A=spi_rx_data[20] B=data_reg[20] S=n_5973
+ VSS=VSS VDD=VDD
Xg118712 MUX2X1 $PINS Z=n_6316 A=spi_rx_data[21] B=data_reg[21] S=n_5973
+ VSS=VSS VDD=VDD
Xg118713 MUX2X1 $PINS Z=n_6315 A=spi_rx_data[22] B=data_reg[22] S=n_5973
+ VSS=VSS VDD=VDD
Xg118714 MUX2X1 $PINS Z=n_6314 A=spi_rx_data[23] B=data_reg[23] S=n_5973
+ VSS=VSS VDD=VDD
Xg118715 MUX2X1 $PINS Z=n_6313 A=spi_rx_data[24] B=data_reg[24] S=n_5973
+ VSS=VSS VDD=VDD
Xg118716 MUX2X1 $PINS Z=n_6312 A=spi_rx_data[25] B=data_reg[25] S=n_5973
+ VSS=VSS VDD=VDD
Xg118717 MUX2X1 $PINS Z=n_6311 A=spi_rx_data[26] B=data_reg[26] S=n_5973
+ VSS=VSS VDD=VDD
Xg118718 MUX2X1 $PINS Z=n_6310 A=spi_rx_data[27] B=data_reg[27] S=n_5973
+ VSS=VSS VDD=VDD
Xg118719 MUX2X1 $PINS Z=n_6309 A=spi_rx_data[28] B=data_reg[28] S=n_5973
+ VSS=VSS VDD=VDD
Xg118720 MUX2X1 $PINS Z=n_6308 A=spi_rx_data[29] B=data_reg[29] S=n_5973
+ VSS=VSS VDD=VDD
Xg118721 MUX2X1 $PINS Z=n_6307 A=spi_rx_data[30] B=data_reg[30] S=n_5973
+ VSS=VSS VDD=VDD
Xg118722 MUX2X1 $PINS Z=n_6306 A=spi_rx_data[31] B=data_reg[31] S=n_5973
+ VSS=VSS VDD=VDD
Xg118723 MUX2X1 $PINS Z=n_6305 A=spi_rx_data[32] B=data_reg[32] S=n_5973
+ VSS=VSS VDD=VDD
Xg118724 MUX2X1 $PINS Z=n_6304 A=spi_rx_data[33] B=data_reg[33] S=n_5973
+ VSS=VSS VDD=VDD
Xg118725 MUX2X1 $PINS Z=n_6303 A=spi_rx_data[34] B=data_reg[34] S=n_5973
+ VSS=VSS VDD=VDD
Xg118726 MUX2X1 $PINS Z=n_6302 A=spi_rx_data[35] B=data_reg[35] S=n_5973
+ VSS=VSS VDD=VDD
Xg118727 MUX2X1 $PINS Z=n_6301 A=spi_rx_data[36] B=data_reg[36] S=n_5973
+ VSS=VSS VDD=VDD
Xg118728 MUX2X1 $PINS Z=n_6300 A=spi_rx_data[37] B=data_reg[37] S=n_5973
+ VSS=VSS VDD=VDD
Xg118729 MUX2X1 $PINS Z=n_6299 A=spi_rx_data[38] B=data_reg[38] S=n_5973
+ VSS=VSS VDD=VDD
Xg118730 MUX2X1 $PINS Z=n_6298 A=spi_rx_data[39] B=data_reg[39] S=n_5973
+ VSS=VSS VDD=VDD
Xg118731 MUX2X1 $PINS Z=n_6297 A=spi_rx_data[40] B=data_reg[40] S=n_5973
+ VSS=VSS VDD=VDD
Xg118732 MUX2X1 $PINS Z=n_6296 A=spi_rx_data[41] B=data_reg[41] S=n_5973
+ VSS=VSS VDD=VDD
Xg118733 MUX2X1 $PINS Z=n_6295 A=spi_rx_data[42] B=data_reg[42] S=n_5973
+ VSS=VSS VDD=VDD
Xg118734 MUX2X1 $PINS Z=n_6294 A=spi_rx_data[43] B=data_reg[43] S=n_5973
+ VSS=VSS VDD=VDD
Xg118735 MUX2X1 $PINS Z=n_6293 A=spi_rx_data[44] B=data_reg[44] S=n_5973
+ VSS=VSS VDD=VDD
Xg118736 MUX2X1 $PINS Z=n_6292 A=spi_rx_data[45] B=data_reg[45] S=n_5973
+ VSS=VSS VDD=VDD
Xg118737 MUX2X1 $PINS Z=n_6291 A=spi_rx_data[46] B=data_reg[46] S=n_5973
+ VSS=VSS VDD=VDD
Xg118738 MUX2X1 $PINS Z=n_6290 A=spi_rx_data[47] B=data_reg[47] S=n_5973
+ VSS=VSS VDD=VDD
Xg118739 MUX2X1 $PINS Z=n_6289 A=spi_rx_data[48] B=data_reg[48] S=n_5973
+ VSS=VSS VDD=VDD
Xg118740 MUX2X1 $PINS Z=n_6288 A=spi_rx_data[49] B=data_reg[49] S=n_5973
+ VSS=VSS VDD=VDD
Xg118741 MUX2X1 $PINS Z=n_6287 A=spi_rx_data[50] B=data_reg[50] S=n_5973
+ VSS=VSS VDD=VDD
Xg118742 MUX2X1 $PINS Z=n_6286 A=spi_rx_data[51] B=data_reg[51] S=n_5973
+ VSS=VSS VDD=VDD
Xg118743 MUX2X1 $PINS Z=n_6285 A=spi_rx_data[52] B=data_reg[52] S=n_5973
+ VSS=VSS VDD=VDD
Xg118744 MUX2X1 $PINS Z=n_6284 A=spi_rx_data[53] B=data_reg[53] S=n_5973
+ VSS=VSS VDD=VDD
Xg118745 MUX2X1 $PINS Z=n_6283 A=spi_rx_data[54] B=data_reg[54] S=n_5973
+ VSS=VSS VDD=VDD
Xg118746 MUX2X1 $PINS Z=n_6282 A=spi_rx_data[55] B=data_reg[55] S=n_5973
+ VSS=VSS VDD=VDD
Xg118747 MUX2X1 $PINS Z=n_6281 A=spi_rx_data[56] B=data_reg[56] S=n_5973
+ VSS=VSS VDD=VDD
Xg118748 MUX2X1 $PINS Z=n_6280 A=spi_rx_data[57] B=data_reg[57] S=n_5973
+ VSS=VSS VDD=VDD
Xg118749 MUX2X1 $PINS Z=n_6279 A=spi_rx_data[58] B=data_reg[58] S=n_5973
+ VSS=VSS VDD=VDD
Xg118750 MUX2X1 $PINS Z=n_6278 A=spi_rx_data[59] B=data_reg[59] S=n_5973
+ VSS=VSS VDD=VDD
Xg118751 MUX2X1 $PINS Z=n_6277 A=spi_rx_data[60] B=data_reg[60] S=n_5973
+ VSS=VSS VDD=VDD
Xg118752 MUX2X1 $PINS Z=n_6276 A=spi_rx_data[61] B=data_reg[61] S=n_5973
+ VSS=VSS VDD=VDD
Xg118753 MUX2X1 $PINS Z=n_6275 A=spi_rx_data[62] B=data_reg[62] S=n_5973
+ VSS=VSS VDD=VDD
Xg118754 MUX2X1 $PINS Z=n_6274 A=spi_rx_data[63] B=data_reg[63] S=n_5973
+ VSS=VSS VDD=VDD
Xg118755 NOR2X1 $PINS Z=n_6400 A=n_79 B=FE_DBTN0_n_6155 VSS=VSS VDD=VDD
Xg118756 NAND2X1 $PINS Z=n_6273 A=n_144 B=spi_inst_shift_in[41] VSS=VSS VDD=VDD
Xg118757 NAND2X1 $PINS Z=n_6272 A=n_144 B=spi_inst_shift_in[40] VSS=VSS VDD=VDD
Xg118758 NAND2X1 $PINS Z=n_6271 A=n_144 B=spi_inst_shift_in[39] VSS=VSS VDD=VDD
Xg118759 NAND2X1 $PINS Z=n_6270 A=n_144 B=spi_inst_shift_in[38] VSS=VSS VDD=VDD
Xg118760 NAND2X1 $PINS Z=n_6269 A=n_144 B=spi_inst_shift_in[37] VSS=VSS VDD=VDD
Xg118761 NAND2X1 $PINS Z=n_6268 A=n_144 B=spi_inst_shift_in[36] VSS=VSS VDD=VDD
Xg118762 NAND2X1 $PINS Z=n_6267 A=n_144 B=spi_inst_shift_in[35] VSS=VSS VDD=VDD
Xg118763 NAND2X1 $PINS Z=n_6266 A=n_144 B=spi_inst_shift_in[34] VSS=VSS VDD=VDD
Xg118764 NAND2X1 $PINS Z=n_6265 A=n_144 B=spi_inst_shift_in[33] VSS=VSS VDD=VDD
Xg118765 NAND2X1 $PINS Z=n_6264 A=n_144 B=spi_inst_shift_in[32] VSS=VSS VDD=VDD
Xg118766 NAND2X1 $PINS Z=n_6263 A=n_144 B=spi_inst_shift_in[31] VSS=VSS VDD=VDD
Xg118767 NAND2X1 $PINS Z=n_6262 A=n_144 B=spi_inst_shift_in[30] VSS=VSS VDD=VDD
Xg118768 NAND2X1 $PINS Z=n_6261 A=n_144 B=spi_inst_shift_in[29] VSS=VSS VDD=VDD
Xg118769 NAND2X1 $PINS Z=n_6260 A=n_144 B=spi_inst_shift_in[28] VSS=VSS VDD=VDD
Xg118770 NAND2X1 $PINS Z=n_6259 A=n_144 B=spi_inst_shift_in[27] VSS=VSS VDD=VDD
Xg118771 NAND2X1 $PINS Z=n_6258 A=n_144 B=spi_inst_shift_in[26] VSS=VSS VDD=VDD
Xg118772 NAND2X1 $PINS Z=n_6257 A=n_144 B=spi_inst_shift_in[25] VSS=VSS VDD=VDD
Xg118773 NAND2X1 $PINS Z=n_6256 A=n_144 B=spi_inst_shift_in[24] VSS=VSS VDD=VDD
Xg118774 NAND2X1 $PINS Z=n_6255 A=n_144 B=spi_inst_shift_in[23] VSS=VSS VDD=VDD
Xg118775 NAND2X1 $PINS Z=n_6254 A=n_144 B=spi_inst_shift_in[22] VSS=VSS VDD=VDD
Xg118776 NAND2X1 $PINS Z=n_6253 A=n_144 B=spi_inst_shift_in[21] VSS=VSS VDD=VDD
Xg118777 NAND2X1 $PINS Z=n_6252 A=n_144 B=spi_inst_shift_in[20] VSS=VSS VDD=VDD
Xg118778 NAND2X1 $PINS Z=n_6251 A=n_144 B=spi_inst_shift_in[19] VSS=VSS VDD=VDD
Xg118779 NAND2X1 $PINS Z=n_6250 A=n_144 B=spi_inst_shift_in[18] VSS=VSS VDD=VDD
Xg118780 NAND2X1 $PINS Z=n_6249 A=n_144 B=spi_inst_shift_in[17] VSS=VSS VDD=VDD
Xg118781 NAND2X1 $PINS Z=n_6248 A=n_144 B=spi_inst_shift_in[16] VSS=VSS VDD=VDD
Xg118782 NAND2X1 $PINS Z=n_6247 A=n_144 B=spi_inst_shift_in[15] VSS=VSS VDD=VDD
Xg118783 NAND2X1 $PINS Z=n_6246 A=n_144 B=spi_inst_shift_in[14] VSS=VSS VDD=VDD
Xg118784 NAND2X1 $PINS Z=n_6245 A=n_144 B=spi_inst_shift_in[13] VSS=VSS VDD=VDD
Xg118785 NAND2X1 $PINS Z=n_6244 A=n_144 B=spi_inst_shift_in[12] VSS=VSS VDD=VDD
Xg118786 NAND2X1 $PINS Z=n_6243 A=n_144 B=spi_inst_shift_in[11] VSS=VSS VDD=VDD
Xg118787 NAND2X1 $PINS Z=n_6242 A=n_144 B=spi_inst_shift_in[10] VSS=VSS VDD=VDD
Xg118788 NAND2X1 $PINS Z=n_6241 A=n_144 B=spi_inst_shift_in[9] VSS=VSS VDD=VDD
Xg118789 NAND2X1 $PINS Z=n_6240 A=n_144 B=spi_inst_shift_in[8] VSS=VSS VDD=VDD
Xg118790 NAND2X1 $PINS Z=n_6239 A=n_144 B=spi_inst_shift_in[7] VSS=VSS VDD=VDD
Xg118791 NAND2X1 $PINS Z=n_6238 A=n_144 B=spi_inst_shift_in[6] VSS=VSS VDD=VDD
Xg118792 NAND2X1 $PINS Z=n_6237 A=n_144 B=spi_inst_shift_in[5] VSS=VSS VDD=VDD
Xg118793 NAND2X1 $PINS Z=n_6236 A=n_144 B=spi_inst_shift_in[4] VSS=VSS VDD=VDD
Xg118794 NAND2X1 $PINS Z=n_6235 A=n_144 B=spi_inst_shift_in[3] VSS=VSS VDD=VDD
Xg118795 NAND2X1 $PINS Z=n_6234 A=n_144 B=spi_inst_shift_in[2] VSS=VSS VDD=VDD
Xg118796 NAND2X1 $PINS Z=n_6233 A=n_144 B=spi_inst_shift_in[1] VSS=VSS VDD=VDD
Xg118797 NAND2X1 $PINS Z=n_6232 A=n_144 B=spi_inst_shift_in[0] VSS=VSS VDD=VDD
Xg118798 NAND2X1 $PINS Z=n_6231 A=n_144 B=spi_inst_shift_in[50] VSS=VSS VDD=VDD
Xg118799 NAND2X1 $PINS Z=n_6230 A=n_144 B=spi_inst_shift_in[60] VSS=VSS VDD=VDD
Xg118800 NAND2X1 $PINS Z=n_6229 A=n_144 B=spi_inst_shift_in[48] VSS=VSS VDD=VDD
Xg118801 NAND2X1 $PINS Z=n_6228 A=n_144 B=spi_inst_shift_in[59] VSS=VSS VDD=VDD
Xg118802 NAND2X1 $PINS Z=n_6227 A=n_5975 B=spi_inst_shift_out[32] VSS=VSS
+ VDD=VDD
Xg118803 NAND2X1 $PINS Z=n_6226 A=n_5975 B=spi_inst_shift_out[56] VSS=VSS
+ VDD=VDD
Xg118804 NAND2X1 $PINS Z=n_6225 A=n_5975 B=spi_inst_shift_out[16] VSS=VSS
+ VDD=VDD
Xg118805 NAND2X1 $PINS Z=n_6224 A=n_5975 B=spi_inst_shift_out[51] VSS=VSS
+ VDD=VDD
Xg118806 NAND2X1 $PINS Z=n_6223 A=n_5975 B=spi_inst_shift_out[14] VSS=VSS
+ VDD=VDD
Xg118807 NAND2X1 $PINS Z=n_6222 A=n_5975 B=spi_inst_shift_out[46] VSS=VSS
+ VDD=VDD
Xg118808 NAND2X1 $PINS Z=n_6221 A=n_5975 B=spi_inst_shift_out[10] VSS=VSS
+ VDD=VDD
Xg118809 NAND2X1 $PINS Z=n_6220 A=n_5975 B=spi_inst_shift_out[59] VSS=VSS
+ VDD=VDD
Xg118810 NAND2X1 $PINS Z=n_6219 A=n_5975 B=spi_inst_shift_out[57] VSS=VSS
+ VDD=VDD
Xg118811 NAND2X1 $PINS Z=n_6218 A=n_5975 B=spi_inst_shift_out[52] VSS=VSS
+ VDD=VDD
Xg118812 NAND2X1 $PINS Z=n_6217 A=n_5975 B=spi_inst_shift_out[18] VSS=VSS
+ VDD=VDD
Xg118813 NAND2X1 $PINS Z=n_6216 A=n_5975 B=spi_inst_shift_out[53] VSS=VSS
+ VDD=VDD
Xg118814 NAND2X1 $PINS Z=n_6215 A=n_5975 B=spi_inst_shift_out[13] VSS=VSS
+ VDD=VDD
Xg118815 NAND2X1 $PINS Z=n_6214 A=n_5975 B=spi_inst_shift_out[0] VSS=VSS
+ VDD=VDD
Xg118816 NAND2X1 $PINS Z=n_6213 A=n_5975 B=spi_inst_shift_out[48] VSS=VSS
+ VDD=VDD
Xg118817 NAND2X1 $PINS Z=n_6212 A=n_5975 B=spi_inst_shift_out[43] VSS=VSS
+ VDD=VDD
Xg118818 NAND2X1 $PINS Z=n_6211 A=n_5975 B=spi_inst_shift_out[1] VSS=VSS
+ VDD=VDD
Xg118819 NAND2X1 $PINS Z=n_6210 A=n_5975 B=spi_inst_shift_out[29] VSS=VSS
+ VDD=VDD
Xg118820 NAND2X1 $PINS Z=n_6209 A=n_5975 B=spi_inst_shift_out[21] VSS=VSS
+ VDD=VDD
Xg118821 NAND2X1 $PINS Z=n_6208 A=n_5978 B=transaction_state[0] VSS=VSS VDD=VDD
Xg118822 NAND2X1 $PINS Z=n_6207 A=n_5838 B=n_193 VSS=VSS VDD=VDD
Xg118823 NAND2X1 $PINS Z=n_6206 A=n_5903 B=csm_inst_round_counter[1] VSS=VSS
+ VDD=VDD
Xg118824 NAND2X1 $PINS Z=n_6205 A=n_5975 B=spi_inst_shift_out[26] VSS=VSS
+ VDD=VDD
Xg118825 NAND2X1 $PINS Z=n_6204 A=n_5975 B=spi_inst_shift_out[34] VSS=VSS
+ VDD=VDD
Xg118826 NAND2X1 $PINS Z=n_6203 A=n_5975 B=spi_inst_shift_out[54] VSS=VSS
+ VDD=VDD
Xg118827 NAND2X1 $PINS Z=n_6202 A=n_5975 B=spi_inst_shift_out[62] VSS=VSS
+ VDD=VDD
Xg118828 NAND2X1 $PINS Z=n_6201 A=n_5975 B=spi_inst_shift_out[55] VSS=VSS
+ VDD=VDD
Xg118829 NAND2X1 $PINS Z=n_6200 A=n_5975 B=spi_inst_shift_out[22] VSS=VSS
+ VDD=VDD
Xg118830 NAND2X1 $PINS Z=n_6199 A=n_5975 B=spi_inst_shift_out[2] VSS=VSS
+ VDD=VDD
Xg118831 NAND2X1 $PINS Z=n_6198 A=n_5975 B=spi_inst_shift_out[3] VSS=VSS
+ VDD=VDD
Xg118832 NAND2X1 $PINS Z=n_6197 A=n_5975 B=spi_inst_shift_out[4] VSS=VSS
+ VDD=VDD
Xg118833 NAND2X1 $PINS Z=n_6196 A=n_5975 B=spi_inst_shift_out[5] VSS=VSS
+ VDD=VDD
Xg118834 NAND2X1 $PINS Z=n_6195 A=n_5975 B=spi_inst_shift_out[6] VSS=VSS
+ VDD=VDD
Xg118835 NAND2X1 $PINS Z=n_6194 A=n_5975 B=spi_inst_shift_out[7] VSS=VSS
+ VDD=VDD
Xg118836 NAND2X1 $PINS Z=n_6193 A=n_5975 B=spi_inst_shift_out[9] VSS=VSS
+ VDD=VDD
Xg118837 NAND2X1 $PINS Z=n_6192 A=n_5975 B=spi_inst_shift_out[11] VSS=VSS
+ VDD=VDD
Xg118838 NAND2X1 $PINS Z=n_6191 A=n_5975 B=spi_inst_shift_out[12] VSS=VSS
+ VDD=VDD
Xg118839 NAND2X1 $PINS Z=n_6190 A=n_5975 B=spi_inst_shift_out[15] VSS=VSS
+ VDD=VDD
Xg118840 NAND2X1 $PINS Z=n_6189 A=n_5975 B=spi_inst_shift_out[40] VSS=VSS
+ VDD=VDD
Xg118841 NAND2X1 $PINS Z=n_6188 A=n_5975 B=spi_inst_shift_out[17] VSS=VSS
+ VDD=VDD
Xg118842 NAND2X1 $PINS Z=n_6187 A=n_5975 B=spi_inst_shift_out[19] VSS=VSS
+ VDD=VDD
Xg118843 NAND2X1 $PINS Z=n_6186 A=n_5975 B=spi_inst_shift_out[20] VSS=VSS
+ VDD=VDD
Xg118844 NAND2X1 $PINS Z=n_6185 A=n_5975 B=spi_inst_shift_out[23] VSS=VSS
+ VDD=VDD
Xg118845 NAND2X1 $PINS Z=n_6184 A=n_5975 B=spi_inst_shift_out[24] VSS=VSS
+ VDD=VDD
Xg118846 NAND2X1 $PINS Z=n_6183 A=n_5975 B=spi_inst_shift_out[25] VSS=VSS
+ VDD=VDD
Xg118847 NAND2X1 $PINS Z=n_6182 A=n_5975 B=spi_inst_shift_out[27] VSS=VSS
+ VDD=VDD
Xg118848 NAND2X1 $PINS Z=n_6181 A=n_5975 B=spi_inst_shift_out[30] VSS=VSS
+ VDD=VDD
Xg118849 NAND2X1 $PINS Z=n_6180 A=n_5975 B=spi_inst_shift_out[31] VSS=VSS
+ VDD=VDD
Xg118850 NAND2X1 $PINS Z=n_6179 A=n_5975 B=spi_inst_shift_out[33] VSS=VSS
+ VDD=VDD
Xg118851 NAND2X1 $PINS Z=n_6178 A=n_5975 B=spi_inst_shift_out[35] VSS=VSS
+ VDD=VDD
Xg118852 NAND2X1 $PINS Z=n_6177 A=n_5975 B=spi_inst_shift_out[36] VSS=VSS
+ VDD=VDD
Xg118853 NAND2X1 $PINS Z=n_6176 A=n_5975 B=spi_inst_shift_out[37] VSS=VSS
+ VDD=VDD
Xg118854 NAND2X1 $PINS Z=n_6175 A=n_5975 B=spi_inst_shift_out[38] VSS=VSS
+ VDD=VDD
Xg118855 NAND2X1 $PINS Z=n_6174 A=n_5975 B=spi_inst_shift_out[39] VSS=VSS
+ VDD=VDD
Xg118856 NAND2X1 $PINS Z=n_6173 A=n_5975 B=spi_inst_shift_out[41] VSS=VSS
+ VDD=VDD
Xg118857 NAND2X1 $PINS Z=n_6172 A=n_5975 B=spi_inst_shift_out[42] VSS=VSS
+ VDD=VDD
Xg118858 NAND2X1 $PINS Z=n_6171 A=n_5975 B=spi_inst_shift_out[44] VSS=VSS
+ VDD=VDD
Xg118859 NAND2X1 $PINS Z=n_6170 A=n_5975 B=spi_inst_shift_out[45] VSS=VSS
+ VDD=VDD
Xg118860 NAND2X1 $PINS Z=n_6169 A=n_5975 B=spi_inst_shift_out[47] VSS=VSS
+ VDD=VDD
Xg118861 NAND2X1 $PINS Z=n_6168 A=n_5975 B=spi_inst_shift_out[49] VSS=VSS
+ VDD=VDD
Xg118862 NAND2X1 $PINS Z=n_6167 A=n_5975 B=spi_inst_shift_out[50] VSS=VSS
+ VDD=VDD
Xg118863 NAND2X1 $PINS Z=n_6166 A=n_5975 B=spi_inst_shift_out[58] VSS=VSS
+ VDD=VDD
Xg118864 NAND2X1 $PINS Z=n_6165 A=n_5975 B=spi_inst_shift_out[8] VSS=VSS
+ VDD=VDD
Xg118865 NAND2X1 $PINS Z=n_6164 A=n_5975 B=spi_inst_shift_out[60] VSS=VSS
+ VDD=VDD
Xg118866 NAND2X1 $PINS Z=n_6163 A=n_5975 B=spi_inst_shift_out[61] VSS=VSS
+ VDD=VDD
Xg118867 NAND2X1 $PINS Z=n_6162 A=n_5975 B=spi_inst_shift_out[28] VSS=VSS
+ VDD=VDD
Xg118934 INVX2 $PINS Z=n_6161 A=n_5984 VSS=VSS VDD=VDD
Xg118938 NAND2X1 $PINS Z=n_6154 A=n_5974 B=spi_inst_shift_in[46] VSS=VSS
+ VDD=VDD
Xg118939 NAND2X1 $PINS Z=n_6153 A=n_144 B=spi_inst_shift_in[43] VSS=VSS VDD=VDD
Xg118940 NAND2X1 $PINS Z=n_6152 A=n_144 B=spi_inst_shift_in[44] VSS=VSS VDD=VDD
Xg118941 NAND2X1 $PINS Z=n_6151 A=n_144 B=spi_inst_shift_in[45] VSS=VSS VDD=VDD
Xg118942 NAND2X1 $PINS Z=n_6150 A=n_144 B=spi_inst_shift_in[46] VSS=VSS VDD=VDD
Xg118943 NAND2X1 $PINS Z=n_6149 A=n_144 B=spi_inst_shift_in[47] VSS=VSS VDD=VDD
Xg118944 NAND2X1 $PINS Z=n_6148 A=n_144 B=spi_inst_shift_in[58] VSS=VSS VDD=VDD
Xg118945 NAND2X1 $PINS Z=n_6147 A=n_144 B=spi_inst_shift_in[62] VSS=VSS VDD=VDD
Xg118946 NAND2X1 $PINS Z=n_6146 A=n_144 B=spi_inst_shift_in[57] VSS=VSS VDD=VDD
Xg118947 NAND2X1 $PINS Z=n_6145 A=n_144 B=spi_inst_shift_in[52] VSS=VSS VDD=VDD
Xg118948 NAND2X1 $PINS Z=n_6144 A=n_144 B=spi_inst_shift_in[56] VSS=VSS VDD=VDD
Xg118949 NAND2X1 $PINS Z=n_6143 A=n_144 B=spi_inst_shift_in[49] VSS=VSS VDD=VDD
Xg118950 NAND2X1 $PINS Z=n_6142 A=n_144 B=spi_inst_shift_in[54] VSS=VSS VDD=VDD
Xg118951 NAND2X1 $PINS Z=n_6141 A=n_144 B=spi_inst_shift_in[55] VSS=VSS VDD=VDD
Xg118952 NAND2X1 $PINS Z=n_6140 A=n_144 B=spi_inst_shift_in[61] VSS=VSS VDD=VDD
Xg118953 NAND2X1 $PINS Z=n_6139 A=n_144 B=spi_inst_shift_in[51] VSS=VSS VDD=VDD
Xg118954 NAND2X1 $PINS Z=n_6138 A=n_144 B=spi_inst_shift_in[53] VSS=VSS VDD=VDD
Xg118955 NAND2X1 $PINS Z=n_6137 A=n_144 B=spi_inst_shift_in[63] VSS=VSS VDD=VDD
Xg118956 NAND2X1 $PINS Z=n_6136 A=n_5974 B=spi_inst_shift_in[13] VSS=VSS
+ VDD=VDD
Xg118957 NAND2X1 $PINS Z=n_6135 A=n_5974 B=spi_inst_shift_in[21] VSS=VSS
+ VDD=VDD
Xg118958 NOR2X1 $PINS Z=n_6134 A=n_5840 B=n_5966 VSS=VSS VDD=VDD
Xg118959 NAND2X1 $PINS Z=n_6133 A=n_5974 B=spi_inst_shift_in[12] VSS=VSS
+ VDD=VDD
Xg118960 NAND2X1 $PINS Z=n_6132 A=n_5974 B=spi_inst_shift_in[59] VSS=VSS
+ VDD=VDD
Xg118961 NAND2X1 $PINS Z=n_6131 A=n_5974 B=spi_inst_shift_in[4] VSS=VSS VDD=VDD
Xg118962 NAND2X1 $PINS Z=n_6130 A=n_5974 B=spi_inst_shift_in[3] VSS=VSS VDD=VDD
Xg118963 NAND2X1 $PINS Z=n_6129 A=n_5974 B=spi_inst_shift_in[2] VSS=VSS VDD=VDD
Xg118964 NOR2X1 $PINS Z=n_6128 A=n_5944 B=n_5945 VSS=VSS VDD=VDD
Xg118965 AND2X1 $PINS Z=n_6127 A=n_5925 B=n_5933 VSS=VSS VDD=VDD
Xg118966 NAND2X1 $PINS Z=n_6126 A=n_5974 B=spi_inst_shift_in[8] VSS=VSS VDD=VDD
Xg118967 NAND2X1 $PINS Z=n_6125 A=n_5974 B=spi_inst_shift_in[39] VSS=VSS
+ VDD=VDD
Xg118968 NAND2X1 $PINS Z=n_6124 A=n_5974 B=spi_inst_shift_in[34] VSS=VSS
+ VDD=VDD
Xg118970 NOR2X1 $PINS Z=n_6122 A=n_5473 B=n_5948 VSS=VSS VDD=VDD
Xg118971 NOR2X1 $PINS Z=n_6121 A=n_5950 B=n_5949 VSS=VSS VDD=VDD
Xg118972 NAND3X1 $PINS Z=n_6120 A=n_5582 B=n_5742 C=n_1074 VSS=VSS VDD=VDD
Xg118973 NOR2X1 $PINS Z=n_6119 A=n_5839 B=n_5872 VSS=VSS VDD=VDD
Xg118974 NOR2X1 $PINS Z=n_6118 A=n_5953 B=n_5882 VSS=VSS VDD=VDD
Xg118975 NOR2X1 $PINS Z=n_6117 A=n_5955 B=n_5954 VSS=VSS VDD=VDD
Xg118976 NOR2X1 $PINS Z=n_6116 A=n_5863 B=n_5956 VSS=VSS VDD=VDD
Xg118977 NAND3X1 $PINS Z=n_6115 A=n_5974 B=n_175 C=spi_inst_bit_count[0]
+ VSS=VSS VDD=VDD
Xg118978 OR2X1 $PINS Z=n_6114 A=n_5732 B=n_144 VSS=VSS VDD=VDD
Xg118979 NAND3X1 $PINS Z=n_6113 A=n_5969 B=n_5503 C=n_4968 VSS=VSS VDD=VDD
Xg118980 NAND3X1 $PINS Z=n_6112 A=n_5938 B=n_4935 C=n_3626 VSS=VSS VDD=VDD
Xg118981 NAND3X1 $PINS Z=n_6111 A=n_5974 B=n_5413 C=n_159 VSS=VSS VDD=VDD
Xg118982 NAND2X1 $PINS Z=n_6110 A=n_5974 B=spi_inst_shift_in[23] VSS=VSS
+ VDD=VDD
Xg118983 NOR2X1 $PINS Z=n_6109 A=n_5466 B=n_5851 VSS=VSS VDD=VDD
Xg118984 NOR2X1 $PINS Z=n_6108 A=n_5959 B=n_5958 VSS=VSS VDD=VDD
Xg118985 AND2X1 $PINS Z=n_6107 A=n_5915 B=n_5932 VSS=VSS VDD=VDD
Xg118986 NOR2X1 $PINS Z=n_6106 A=n_5962 B=n_5961 VSS=VSS VDD=VDD
Xg118987 NOR2X1 $PINS Z=n_6105 A=n_5963 B=n_5964 VSS=VSS VDD=VDD
Xg118988 NAND3X1 $PINS Z=n_6104 A=n_5499 B=n_5687 C=n_5647 VSS=VSS VDD=VDD
Xg118989 NOR2X1 $PINS Z=n_6103 A=n_5854 B=n_5853 VSS=VSS VDD=VDD
Xg118990 NAND3X1 $PINS Z=n_6102 A=n_5936 B=n_4801 C=n_4944 VSS=VSS VDD=VDD
Xg118991 NAND2X1 $PINS Z=n_6101 A=n_5974 B=spi_inst_shift_in[5] VSS=VSS VDD=VDD
Xg118992 NAND2X1 $PINS Z=n_6100 A=n_5974 B=spi_inst_shift_in[9] VSS=VSS VDD=VDD
Xg118993 NAND2X1 $PINS Z=n_6099 A=n_5974 B=spi_inst_shift_in[17] VSS=VSS
+ VDD=VDD
Xg118994 NAND2X1 $PINS Z=n_6098 A=n_5974 B=spi_inst_shift_in[25] VSS=VSS
+ VDD=VDD
Xg118995 NAND2X1 $PINS Z=n_6097 A=n_5974 B=spi_inst_shift_in[31] VSS=VSS
+ VDD=VDD
Xg118996 NAND2X1 $PINS Z=n_6096 A=n_5974 B=spi_inst_shift_in[33] VSS=VSS
+ VDD=VDD
Xg118997 NAND2X1 $PINS Z=n_6095 A=n_5974 B=spi_inst_shift_in[41] VSS=VSS
+ VDD=VDD
Xg118998 NAND2X1 $PINS Z=n_6094 A=n_5974 B=spi_inst_shift_in[27] VSS=VSS
+ VDD=VDD
Xg118999 NAND2X1 $PINS Z=n_6093 A=n_5974 B=spi_inst_shift_in[48] VSS=VSS
+ VDD=VDD
Xg119000 NAND2X1 $PINS Z=n_6092 A=n_5974 B=spi_inst_shift_in[50] VSS=VSS
+ VDD=VDD
Xg119001 NAND2X1 $PINS Z=n_6091 A=n_5974 B=spi_inst_shift_in[30] VSS=VSS
+ VDD=VDD
Xg119002 NAND2X1 $PINS Z=n_6090 A=n_5974 B=spi_inst_shift_in[60] VSS=VSS
+ VDD=VDD
Xg119003 NOR2X1 $PINS Z=n_6089 A=n_5968 B=n_5881 VSS=VSS VDD=VDD
Xg119004 NAND2X1 $PINS Z=n_6088 A=n_5974 B=spi_inst_shift_in[1] VSS=VSS VDD=VDD
Xg119005 NOR2X1 $PINS Z=n_6087 A=n_5874 B=n_5879 VSS=VSS VDD=VDD
Xg119006 NOR2X1 $PINS Z=n_6086 A=n_5878 B=n_5877 VSS=VSS VDD=VDD
Xg119007 NOR2X1 $PINS Z=n_6085 A=n_5850 B=n_5835 VSS=VSS VDD=VDD
Xg119008 NOR2X1 $PINS Z=n_6084 A=n_5875 B=n_5876 VSS=VSS VDD=VDD
Xg119009 NOR2X1 $PINS Z=n_6083 A=n_5861 B=n_5832 VSS=VSS VDD=VDD
Xg119010 NAND2X1 $PINS Z=n_6082 A=n_5974 B=spi_inst_shift_in[40] VSS=VSS
+ VDD=VDD
Xg119011 NOR2X1 $PINS Z=n_6081 A=n_5833 B=n_5834 VSS=VSS VDD=VDD
Xg119012 NAND2X1 $PINS Z=n_6080 A=n_5974 B=spi_inst_shift_in[42] VSS=VSS
+ VDD=VDD
Xg119013 NOR2X1 $PINS Z=n_6079 A=n_5443 B=n_5871 VSS=VSS VDD=VDD
Xg119014 NAND2X1 $PINS Z=n_6078 A=n_5974 B=spi_inst_shift_in[56] VSS=VSS
+ VDD=VDD
Xg119015 NAND2X1 $PINS Z=n_6077 A=n_5974 B=spi_inst_shift_in[37] VSS=VSS
+ VDD=VDD
Xg119016 NOR2X1 $PINS Z=n_6076 A=n_5870 B=n_5869 VSS=VSS VDD=VDD
Xg119017 NAND2X1 $PINS Z=n_6075 A=n_5974 B=n_4916 VSS=VSS VDD=VDD
Xg119018 NOR2X1 $PINS Z=n_6074 A=n_5867 B=n_5866 VSS=VSS VDD=VDD
Xg119019 NOR2X1 $PINS Z=n_6073 A=n_5477 B=n_5947 VSS=VSS VDD=VDD
Xg119020 NOR2X1 $PINS Z=n_6072 A=n_5860 B=n_5827 VSS=VSS VDD=VDD
Xg119021 NOR2X1 $PINS Z=n_6071 A=n_5451 B=n_5859 VSS=VSS VDD=VDD
Xg119022 NOR2X1 $PINS Z=n_6070 A=n_5449 B=n_5858 VSS=VSS VDD=VDD
Xg119023 NOR2X1 $PINS Z=n_6069 A=n_5856 B=n_5855 VSS=VSS VDD=VDD
Xg119024 NOR2X1 $PINS Z=n_6068 A=n_5418 B=n_5901 VSS=VSS VDD=VDD
Xg119025 NAND2X1 $PINS Z=n_6067 A=n_5974 B=spi_inst_shift_in[11] VSS=VSS
+ VDD=VDD
Xg119026 NAND2X1 $PINS Z=n_6066 A=n_5974 B=spi_inst_shift_in[54] VSS=VSS
+ VDD=VDD
Xg119027 NAND2X1 $PINS Z=n_6065 A=n_144 B=spi_inst_shift_in[42] VSS=VSS VDD=VDD
Xg119028 NAND2X1 $PINS Z=n_6064 A=n_5974 B=spi_inst_shift_in[49] VSS=VSS
+ VDD=VDD
Xg119029 NAND2X1 $PINS Z=n_6063 A=n_5974 B=spi_inst_shift_in[0] VSS=VSS VDD=VDD
Xg119030 NAND2X1 $PINS Z=n_6062 A=n_5974 B=spi_inst_shift_in[18] VSS=VSS
+ VDD=VDD
Xg119031 NAND2X1 $PINS Z=n_6061 A=n_5974 B=spi_inst_shift_in[6] VSS=VSS VDD=VDD
Xg119032 NAND2X1 $PINS Z=n_6060 A=n_5974 B=spi_inst_shift_in[32] VSS=VSS
+ VDD=VDD
Xg119033 NAND2X1 $PINS Z=n_6059 A=n_5974 B=spi_inst_shift_in[7] VSS=VSS VDD=VDD
Xg119034 NOR2X1 $PINS Z=n_6058 A=n_5822 B=n_5971 VSS=VSS VDD=VDD
Xg119035 NOR2X1 $PINS Z=n_6057 A=n_5436 B=n_5965 VSS=VSS VDD=VDD
Xg119036 NAND2X1 $PINS Z=n_6056 A=n_5845 B=n_477 VSS=VSS VDD=VDD
Xg119037 NOR2X1 $PINS Z=n_6055 A=n_5848 B=n_5846 VSS=VSS VDD=VDD
Xg119038 NOR2X1 $PINS Z=n_6054 A=n_5842 B=n_5844 VSS=VSS VDD=VDD
Xg119039 NAND2X1 $PINS Z=n_6053 A=n_5974 B=spi_inst_shift_in[51] VSS=VSS
+ VDD=VDD
Xg119040 NAND2X1 $PINS Z=n_6052 A=n_5974 B=spi_inst_shift_in[57] VSS=VSS
+ VDD=VDD
Xg119041 NAND2X1 $PINS Z=n_6051 A=n_5974 B=spi_inst_shift_in[58] VSS=VSS
+ VDD=VDD
Xg119042 NOR2X1 $PINS Z=n_6050 A=n_5534 B=n_5841 VSS=VSS VDD=VDD
Xg119043 NAND2X1 $PINS Z=n_6049 A=n_5977 B=transaction_state[0] VSS=VSS VDD=VDD
Xg119044 NAND2X1 $PINS Z=n_6048 A=n_5974 B=mosi VSS=VSS VDD=VDD
Xg119045 NAND2X1 $PINS Z=n_6047 A=n_5974 B=spi_inst_shift_in[55] VSS=VSS
+ VDD=VDD
Xg119046 NAND2X1 $PINS Z=n_6046 A=n_5974 B=spi_inst_shift_in[15] VSS=VSS
+ VDD=VDD
Xg119047 NOR2X1 $PINS Z=n_6045 A=n_5960 B=n_5951 VSS=VSS VDD=VDD
Xg119048 NAND2X1 $PINS Z=n_6044 A=n_5974 B=spi_inst_shift_in[19] VSS=VSS
+ VDD=VDD
Xg119049 NAND2X1 $PINS Z=n_6043 A=n_5974 B=spi_inst_shift_in[14] VSS=VSS
+ VDD=VDD
Xg119050 NAND2X1 $PINS Z=n_6042 A=n_5974 B=spi_inst_shift_in[29] VSS=VSS
+ VDD=VDD
Xg119051 NAND2X1 $PINS Z=n_6041 A=n_5974 B=spi_inst_shift_in[47] VSS=VSS
+ VDD=VDD
Xg119052 NAND2X1 $PINS Z=n_6040 A=n_5974 B=spi_inst_shift_in[38] VSS=VSS
+ VDD=VDD
Xg119053 NAND2X1 $PINS Z=n_6039 A=n_5974 B=spi_inst_shift_in[28] VSS=VSS
+ VDD=VDD
Xg119054 NAND2X1 $PINS Z=n_6038 A=n_5974 B=spi_inst_shift_in[44] VSS=VSS
+ VDD=VDD
Xg119055 NAND2X1 $PINS Z=n_6037 A=n_5974 B=spi_inst_shift_in[53] VSS=VSS
+ VDD=VDD
Xg119056 NOR2X1 $PINS Z=n_6036 A=n_5831 B=n_5830 VSS=VSS VDD=VDD
Xg119057 NAND2X1 $PINS Z=n_6035 A=n_5974 B=spi_inst_shift_in[16] VSS=VSS
+ VDD=VDD
Xg119058 NAND2X1 $PINS Z=n_6034 A=n_5974 B=spi_inst_shift_in[35] VSS=VSS
+ VDD=VDD
Xg119059 NOR2X1 $PINS Z=n_6033 A=n_5829 B=n_5828 VSS=VSS VDD=VDD
Xg119060 NAND2X1 $PINS Z=n_6032 A=n_5928 B=n_5691 VSS=VSS VDD=VDD
Xg119061 NAND2X1 $PINS Z=n_6031 A=n_5974 B=spi_inst_shift_in[10] VSS=VSS
+ VDD=VDD
Xg119062 NAND2X1 $PINS Z=n_6030 A=n_5974 B=spi_inst_shift_in[20] VSS=VSS
+ VDD=VDD
Xg119063 NAND2X1 $PINS Z=n_6029 A=n_5974 B=spi_inst_shift_in[26] VSS=VSS
+ VDD=VDD
Xg119064 NOR2X1 $PINS Z=n_6028 A=n_5864 B=n_5865 VSS=VSS VDD=VDD
Xg119065 NAND2X1 $PINS Z=n_6027 A=n_5974 B=spi_inst_shift_in[45] VSS=VSS
+ VDD=VDD
Xg119066 NAND2X1 $PINS Z=n_6026 A=n_5974 B=spi_inst_shift_in[24] VSS=VSS
+ VDD=VDD
Xg119067 NOR2X1 $PINS Z=n_6025 A=n_5883 B=n_5880 VSS=VSS VDD=VDD
Xg119068 NAND2X1 $PINS Z=n_6024 A=n_5974 B=spi_inst_shift_in[61] VSS=VSS
+ VDD=VDD
Xg119069 NAND2X1 $PINS Z=n_6023 A=n_5974 B=spi_inst_shift_in[52] VSS=VSS
+ VDD=VDD
Xg119070 NOR2X1 $PINS Z=n_6022 A=n_5952 B=n_5826 VSS=VSS VDD=VDD
Xg119071 NAND2X1 $PINS Z=n_6021 A=n_5974 B=spi_inst_shift_in[22] VSS=VSS
+ VDD=VDD
Xg119072 NAND2X1 $PINS Z=n_6020 A=n_5974 B=spi_inst_shift_in[43] VSS=VSS
+ VDD=VDD
Xg119073 NAND2X1 $PINS Z=n_6019 A=n_5974 B=spi_inst_shift_in[36] VSS=VSS
+ VDD=VDD
Xg119074 OR2X1 $PINS Z=n_6018 A=n_5453 B=n_5847 VSS=VSS VDD=VDD
Xg119075 NOR2X1 $PINS Z=n_6017 A=n_5825 B=n_5941 VSS=VSS VDD=VDD
Xg119076 NAND2X1 $PINS Z=n_6016 A=n_5974 B=spi_inst_shift_in[62] VSS=VSS
+ VDD=VDD
Xg119077 NAND2X1 $PINS Z=n_6015 A=n_5902 B=n_477 VSS=VSS VDD=VDD
Xg119078 NAND3X1 $PINS Z=n_6014 A=n_5974 B=n_5413 C=n_467 VSS=VSS VDD=VDD
Xg119079 NAND3X1 $PINS Z=n_6013 A=n_5929 B=n_5616 C=n_5615 VSS=VSS VDD=VDD
Xg119080 NAND3X1 $PINS Z=n_6012 A=n_5979 B=n_5686 C=n_5613 VSS=VSS VDD=VDD
Xg119081 NAND3X1 $PINS Z=n_6011 A=n_5868 B=n_5513 C=n_5006 VSS=VSS VDD=VDD
Xg119082 NAND3X1 $PINS Z=n_6010 A=n_5927 B=n_5605 C=n_5604 VSS=VSS VDD=VDD
Xg119083 NAND3X1 $PINS Z=n_6009 A=n_5926 B=n_5601 C=n_5563 VSS=VSS VDD=VDD
Xg119084 NAND3X1 $PINS Z=n_6008 A=n_5974 B=n_3314 C=n_463 VSS=VSS VDD=VDD
Xg119085 NAND3X1 $PINS Z=n_6007 A=n_5562 B=n_5596 C=n_4487 VSS=VSS VDD=VDD
Xg119086 NAND3X1 $PINS Z=n_6006 A=n_5974 B=n_5414 C=n_5117 VSS=VSS VDD=VDD
Xg119087 NAND3X1 $PINS Z=n_6005 A=n_5293 B=n_5739 C=n_5113 VSS=VSS VDD=VDD
Xg119088 NAND3X1 $PINS Z=n_6004 A=n_5918 B=n_4891 C=n_4973 VSS=VSS VDD=VDD
Xg119089 NAND3X1 $PINS Z=n_6003 A=n_5578 B=n_5583 C=n_5584 VSS=VSS VDD=VDD
Xg119090 NAND3X1 $PINS Z=n_6002 A=n_5737 B=n_5599 C=n_5475 VSS=VSS VDD=VDD
Xg119091 NAND3X1 $PINS Z=n_6001 A=n_5545 B=n_5659 C=n_4984 VSS=VSS VDD=VDD
Xg119092 NAND3X1 $PINS Z=n_6000 A=n_5658 B=n_5597 C=n_5670 VSS=VSS VDD=VDD
Xg119093 NOR2X1 $PINS Z=n_5999 A=n_5322 B=n_5970 VSS=VSS VDD=VDD
Xg119094 NAND3X1 $PINS Z=n_5998 A=n_5911 B=n_4904 C=n_4846 VSS=VSS VDD=VDD
Xg119095 NOR2X1 $PINS Z=n_5997 A=n_5320 B=n_5972 VSS=VSS VDD=VDD
Xg119096 NAND3X1 $PINS Z=n_5996 A=n_5890 B=n_5566 C=n_5523 VSS=VSS VDD=VDD
Xg119097 NAND3X1 $PINS Z=n_5995 A=n_5909 B=n_4946 C=n_3521 VSS=VSS VDD=VDD
Xg119098 NAND3X1 $PINS Z=n_5994 A=n_5931 B=n_4725 C=n_4979 VSS=VSS VDD=VDD
Xg119099 NAND3X1 $PINS Z=n_5993 A=n_5904 B=n_3760 C=n_3987 VSS=VSS VDD=VDD
Xg119100 NAND3X1 $PINS Z=n_5992 A=n_5889 B=n_5677 C=n_5657 VSS=VSS VDD=VDD
Xg119101 NAND3X1 $PINS Z=n_5991 A=n_5888 B=n_4484 C=n_5120 VSS=VSS VDD=VDD
Xg119102 NAND3X1 $PINS Z=n_5990 A=n_5886 B=n_5650 C=n_5680 VSS=VSS VDD=VDD
Xg119103 NAND3X1 $PINS Z=n_5989 A=n_5836 B=n_5526 C=n_4723 VSS=VSS VDD=VDD
Xg119104 NOR2X1 $PINS Z=n_5988 A=n_5437 B=n_5898 VSS=VSS VDD=VDD
Xg119105 NAND3X1 $PINS Z=n_5987 A=n_5912 B=n_5004 C=n_4863 VSS=VSS VDD=VDD
Xg119106 NAND3X1 $PINS Z=n_5986 A=n_5897 B=n_4989 C=n_4993 VSS=VSS VDD=VDD
Xg119107 NAND3X1 $PINS Z=n_5985 A=n_5980 B=n_5125 C=n_5119 VSS=VSS VDD=VDD
Xg119108 NAND3X1 $PINS Z=n_5984 A=n_5525 B=n_5527 C=csm_inst_mode VSS=VSS
+ VDD=VDD
Xg119109 NOR2X1 $PINS Z=n_5983 A=n_5430 B=n_5891 VSS=VSS VDD=VDD
Xg119110 NAND3X1 $PINS Z=n_5982 A=n_5907 B=n_4109 C=n_4983 VSS=VSS VDD=VDD
Xg119111 NAND3X1 $PINS Z=n_5981 A=n_5667 B=n_5522 C=n_5649 VSS=VSS VDD=VDD
Xg119112 NAND2X1 $PINS Z=n_6160 A=n_146 B=n_5592 VSS=VSS VDD=VDD
Xg119113 NAND2X1 $PINS Z=n_6159 A=n_5590 B=n_146 VSS=VSS VDD=VDD
Xg119114 NOR2X1 $PINS Z=n_6158 A=n_158 B=n_5976 VSS=VSS VDD=VDD
Xg119115 NOR2X1 $PINS Z=n_6157 A=n_137 B=n_5935 VSS=VSS VDD=VDD
Xg119116 OR2X1 $PINS Z=n_6155 A=transaction_state[1] B=n_5976 VSS=VSS VDD=VDD
Xg119117 INVX2 $PINS Z=n_5980 A=n_5967 VSS=VSS VDD=VDD
Xg119118 INVX2 $PINS Z=n_5979 A=n_5942 VSS=VSS VDD=VDD
Xg119119 INVX2 $PINS Z=n_5978 A=n_5977 VSS=VSS VDD=VDD
Xg119129 INVX2 $PINS Z=n_146 A=n_144 VSS=VSS VDD=VDD
Xg119130 NAND2X1 $PINS Z=n_5972 A=n_5594 B=n_5547 VSS=VSS VDD=VDD
Xg119131 NAND3X1 $PINS Z=n_5971 A=n_5744 B=n_5124 C=n_4934 VSS=VSS VDD=VDD
Xg119132 NAND3X1 $PINS Z=n_5970 A=n_5574 B=n_4743 C=n_3695 VSS=VSS VDD=VDD
Xg119133 NOR2X1 $PINS Z=n_5969 A=n_5278 B=n_5462 VSS=VSS VDD=VDD
Xg119134 NAND3X1 $PINS Z=n_5968 A=n_5509 B=n_3790 C=n_4978 VSS=VSS VDD=VDD
Xg119135 NAND3X1 $PINS Z=n_5967 A=n_5577 B=n_3755 C=n_5034 VSS=VSS VDD=VDD
Xg119136 NAND3X1 $PINS Z=n_5966 A=n_5743 B=n_4756 C=n_5111 VSS=VSS VDD=VDD
Xg119137 NAND3X1 $PINS Z=n_5965 A=n_5581 B=n_4795 C=n_3563 VSS=VSS VDD=VDD
Xg119138 NAND3X1 $PINS Z=n_5964 A=n_5681 B=n_4886 C=n_3936 VSS=VSS VDD=VDD
Xg119139 NAND3X1 $PINS Z=n_5963 A=n_5662 B=n_3439 C=n_5021 VSS=VSS VDD=VDD
Xg119140 NAND3X1 $PINS Z=n_5962 A=n_5485 B=n_4883 C=n_3999 VSS=VSS VDD=VDD
Xg119141 NAND3X1 $PINS Z=n_5961 A=n_5741 B=n_5118 C=n_4976 VSS=VSS VDD=VDD
Xg119142 NAND3X1 $PINS Z=n_5960 A=n_5738 B=n_4804 C=n_3545 VSS=VSS VDD=VDD
Xg119143 NAND3X1 $PINS Z=n_5959 A=n_5588 B=n_3574 C=n_3740 VSS=VSS VDD=VDD
Xg119144 NAND3X1 $PINS Z=n_5958 A=n_5683 B=n_4962 C=n_4787 VSS=VSS VDD=VDD
Xg119145 NAND3X1 $PINS Z=n_5957 A=n_5591 B=n_4918 C=n_4744 VSS=VSS VDD=VDD
Xg119146 NAND3X1 $PINS Z=n_5956 A=n_5487 B=n_4921 C=n_4733 VSS=VSS VDD=VDD
Xg119147 NAND3X1 $PINS Z=n_5955 A=n_5490 B=n_4933 C=n_4932 VSS=VSS VDD=VDD
Xg119148 NAND3X1 $PINS Z=n_5954 A=n_5589 B=n_4938 C=n_3476 VSS=VSS VDD=VDD
Xg119149 NAND3X1 $PINS Z=n_5953 A=n_5576 B=n_5125 C=n_4799 VSS=VSS VDD=VDD
Xg119150 NAND3X1 $PINS Z=n_5952 A=n_5504 B=n_3526 C=n_4951 VSS=VSS VDD=VDD
Xg119151 NAND3X1 $PINS Z=n_5951 A=n_5567 B=n_5126 C=n_3746 VSS=VSS VDD=VDD
Xg119152 NAND3X1 $PINS Z=n_5950 A=n_5595 B=n_4740 C=n_4782 VSS=VSS VDD=VDD
Xg119153 NAND3X1 $PINS Z=n_5949 A=n_5564 B=n_4958 C=n_4746 VSS=VSS VDD=VDD
Xg119154 NAND3X1 $PINS Z=n_5948 A=n_5750 B=n_4735 C=n_4734 VSS=VSS VDD=VDD
Xg119155 NAND3X1 $PINS Z=n_5947 A=n_5749 B=n_5000 C=n_3627 VSS=VSS VDD=VDD
Xg119156 NAND3X1 $PINS Z=n_5946 A=n_4777 B=n_5403 C=n_983 VSS=VSS VDD=VDD
Xg119157 NAND3X1 $PINS Z=n_5945 A=n_5736 B=n_5121 C=n_5120 VSS=VSS VDD=VDD
Xg119158 NAND3X1 $PINS Z=n_5944 A=n_5611 B=n_3741 C=n_4040 VSS=VSS VDD=VDD
Xg119159 NAND3X1 $PINS Z=n_5943 A=n_5607 B=n_4779 C=n_5018 VSS=VSS VDD=VDD
Xg119160 NAND3X1 $PINS Z=n_5942 A=n_5612 B=n_4769 C=n_4786 VSS=VSS VDD=VDD
Xg119161 NAND3X1 $PINS Z=n_5941 A=n_5617 B=n_5037 C=n_5036 VSS=VSS VDD=VDD
Xg119162 NAND2X1 $PINS Z=n_5940 A=n_8065 B=n_477 VSS=VSS VDD=VDD
Xg119163 NOR2X1 $PINS Z=n_5939 A=n_5313 B=n_5431 VSS=VSS VDD=VDD
Xg119164 NAND2X1 $PINS Z=n_5938 A=n_5496 B=n_3517 VSS=VSS VDD=VDD
Xg119165 AND2X1 $PINS Z=n_5937 A=n_5476 B=csm_inst_mode VSS=VSS VDD=VDD
Xg119166 NAND2X1 $PINS Z=n_5936 A=n_5620 B=n_81 VSS=VSS VDD=VDD
Xg119167 NOR2X1 $PINS Z=n_5935 A=spi_inst_cs_sync2 B=n_8067 VSS=VSS VDD=VDD
Xg119168 NAND2X1 $PINS Z=n_5934 A=n_5482 B=FE_DBTN1_csm_inst_mode VSS=VSS
+ VDD=VDD
Xg119169 NAND2X1 $PINS Z=n_5933 A=n_5619 B=n_1085 VSS=VSS VDD=VDD
Xg119170 NAND2X1 $PINS Z=n_5932 A=n_5619 B=n_1101 VSS=VSS VDD=VDD
Xg119171 NAND2X1 $PINS Z=n_5931 A=n_5586 B=n_477 VSS=VSS VDD=VDD
Xg119172 NAND2X1 $PINS Z=n_5930 A=n_5620 B=n_82 VSS=VSS VDD=VDD
Xg119173 AND2X1 $PINS Z=n_5929 A=n_5666 B=n_5614 VSS=VSS VDD=VDD
Xg119174 NAND2X1 $PINS Z=n_5928 A=n_5517 B=n_218 VSS=VSS VDD=VDD
Xg119175 AND2X1 $PINS Z=n_5927 A=n_5514 B=n_5603 VSS=VSS VDD=VDD
Xg119176 AND2X1 $PINS Z=n_5926 A=n_5600 B=n_5579 VSS=VSS VDD=VDD
Xg119177 NAND2X1 $PINS Z=n_5925 A=n_5622 B=n_126 VSS=VSS VDD=VDD
Xg119178 NAND2X1 $PINS Z=n_5924 A=n_5553 B=n_126 VSS=VSS VDD=VDD
Xg119179 AND2X1 $PINS Z=n_5923 A=n_5663 B=n_5685 VSS=VSS VDD=VDD
Xg119180 AND2X1 $PINS Z=n_5922 A=n_5678 B=n_5653 VSS=VSS VDD=VDD
Xg119181 NAND2X1 $PINS Z=n_5921 A=n_5458 B=csm_inst_mode VSS=VSS VDD=VDD
Xg119182 AND2X1 $PINS Z=n_5920 A=n_5533 B=n_5505 VSS=VSS VDD=VDD
Xg119183 AND2X1 $PINS Z=n_5919 A=n_5684 B=n_5664 VSS=VSS VDD=VDD
Xg119184 NAND2X1 $PINS Z=n_5918 A=n_5495 B=n_4775 VSS=VSS VDD=VDD
Xg119185 NAND2X1 $PINS Z=n_5917 A=n_5420 B=csm_inst_mode VSS=VSS VDD=VDD
Xg119186 AND2X1 $PINS Z=n_5916 A=n_5598 B=n_5674 VSS=VSS VDD=VDD
Xg119187 NAND2X1 $PINS Z=n_5915 A=n_5622 B=n_131 VSS=VSS VDD=VDD
Xg119188 NAND2X1 $PINS Z=n_5914 A=n_5521 B=n_196 VSS=VSS VDD=VDD
Xg119189 AND2X1 $PINS Z=n_5913 A=n_5512 B=FE_DBTN1_csm_inst_mode VSS=VSS
+ VDD=VDD
Xg119190 NAND2X1 $PINS Z=n_5912 A=n_5520 B=n_4888 VSS=VSS VDD=VDD
Xg119191 NAND2X1 $PINS Z=n_5911 A=n_5494 B=n_3566 VSS=VSS VDD=VDD
Xg119192 AND2X1 $PINS Z=n_5910 A=n_5425 B=csm_inst_mode VSS=VSS VDD=VDD
Xg119193 NAND2X1 $PINS Z=n_5909 A=n_5492 B=n_4384 VSS=VSS VDD=VDD
Xg119194 AND2X1 $PINS Z=n_5908 A=n_5559 B=n_5540 VSS=VSS VDD=VDD
Xg119195 NAND2X1 $PINS Z=n_5907 A=n_5493 B=n_4964 VSS=VSS VDD=VDD
Xg119196 AND2X1 $PINS Z=n_5906 A=n_5609 B=n_5554 VSS=VSS VDD=VDD
Xg119197 NAND2X1 $PINS Z=n_5905 A=n_5452 B=csm_inst_mode VSS=VSS VDD=VDD
Xg119198 NAND2X1 $PINS Z=n_5904 A=n_5549 B=n_3758 VSS=VSS VDD=VDD
Xg119199 NAND3X1 $PINS Z=n_5903 A=n_4956 B=n_5305 C=n_4952 VSS=VSS VDD=VDD
Xg119200 NAND3X1 $PINS Z=n_5902 A=n_5303 B=n_5040 C=n_5029 VSS=VSS VDD=VDD
Xg119201 NAND3X1 $PINS Z=n_5901 A=n_5544 B=n_5288 C=n_4800 VSS=VSS VDD=VDD
Xg119202 OR2X1 $PINS Z=n_5900 A=n_3442 B=n_5690 VSS=VSS VDD=VDD
Xg119203 AND2X1 $PINS Z=n_5899 A=n_5439 B=csm_inst_mode VSS=VSS VDD=VDD
Xg119204 NAND2X1 $PINS Z=n_5898 A=n_5532 B=n_5531 VSS=VSS VDD=VDD
Xg119205 NAND2X1 $PINS Z=n_5897 A=n_5491 B=n_3763 VSS=VSS VDD=VDD
Xg119206 NAND2X1 $PINS Z=n_5896 A=n_5435 B=csm_inst_mode VSS=VSS VDD=VDD
Xg119207 AND2X1 $PINS Z=n_5895 A=n_5669 B=n_5652 VSS=VSS VDD=VDD
Xg119208 AND2X1 $PINS Z=n_5894 A=n_5528 B=n_5529 VSS=VSS VDD=VDD
Xg119209 NAND2X1 $PINS Z=n_5893 A=n_5432 B=csm_inst_mode VSS=VSS VDD=VDD
Xg119210 NAND2X1 $PINS Z=n_5892 A=n_5459 B=csm_inst_mode VSS=VSS VDD=VDD
Xg119211 NAND2X1 $PINS Z=n_5891 A=n_5651 B=n_5668 VSS=VSS VDD=VDD
Xg119212 NAND2X1 $PINS Z=n_5977 A=n_184 B=cs_rise_delayed VSS=VSS VDD=VDD
Xg119214 NAND2X1 $PINS Z=n_5976 A=n_173 B=cs_rise_delayed VSS=VSS VDD=VDD
Xg119249 NOR2X1 $PINS Z=n_5975 A=n_5287 B=n_8067 VSS=VSS VDD=VDD
Xg119250 AND2X1 $PINS Z=n_144 A=n_5621 B=n_136 VSS=VSS VDD=VDD
Xg119251 NOR2X1 $PINS Z=n_5974 A=n_137 B=n_5621 VSS=VSS VDD=VDD
Xg119253 NAND3X1 $PINS Z=n_5973 A=n_158 B=transaction_state[0]
+ C=cs_rise_delayed VSS=VSS VDD=VDD
Xg119254 INVX2 $PINS Z=n_5890 A=n_5873 VSS=VSS VDD=VDD
Xg119255 INVX2 $PINS Z=n_5889 A=n_5857 VSS=VSS VDD=VDD
Xg119256 INVX2 $PINS Z=n_5888 A=n_5852 VSS=VSS VDD=VDD
Xg119257 INVX2 $PINS Z=n_5887 A=n_5849 VSS=VSS VDD=VDD
Xg119258 INVX2 $PINS Z=n_5886 A=n_5843 VSS=VSS VDD=VDD
Xg119259 INVX2 $PINS Z=n_5885 A=n_5837 VSS=VSS VDD=VDD
Xg119260 MUX2X1 $PINS Z=n_5884 A=spi_rx_data[2] B=spi_inst_shift_in[2] S=n_5409
+ VSS=VSS VDD=VDD
Xg119261 NAND3X1 $PINS Z=n_5883 A=n_5518 B=n_4721 C=n_4880 VSS=VSS VDD=VDD
Xg119262 NAND3X1 $PINS Z=n_5882 A=n_5745 B=n_4785 C=n_4911 VSS=VSS VDD=VDD
Xg119263 NAND3X1 $PINS Z=n_5881 A=n_5573 B=n_4872 C=n_4759 VSS=VSS VDD=VDD
Xg119264 NAND3X1 $PINS Z=n_5880 A=n_5507 B=n_3433 C=n_4773 VSS=VSS VDD=VDD
Xg119265 NAND3X1 $PINS Z=n_5879 A=n_5524 B=n_5023 C=n_4770 VSS=VSS VDD=VDD
Xg119266 NAND3X1 $PINS Z=n_5878 A=n_5516 B=n_3671 C=n_5026 VSS=VSS VDD=VDD
Xg119267 NAND3X1 $PINS Z=n_5877 A=n_5570 B=n_3590 C=n_4890 VSS=VSS VDD=VDD
Xg119268 NAND3X1 $PINS Z=n_5876 A=n_5519 B=n_4767 C=n_3748 VSS=VSS VDD=VDD
Xg119269 NAND3X1 $PINS Z=n_5875 A=n_5746 B=n_4912 C=n_4996 VSS=VSS VDD=VDD
Xg119270 NAND3X1 $PINS Z=n_5874 A=n_5759 B=n_5015 C=n_4923 VSS=VSS VDD=VDD
Xg119271 NAND3X1 $PINS Z=n_5873 A=n_5565 B=n_4927 C=n_4713 VSS=VSS VDD=VDD
Xg119272 NAND3X1 $PINS Z=n_5872 A=n_5679 B=n_4896 C=n_4898 VSS=VSS VDD=VDD
Xg119273 NAND3X1 $PINS Z=n_5871 A=n_5506 B=n_4802 C=n_4768 VSS=VSS VDD=VDD
Xg119274 NAND3X1 $PINS Z=n_5870 A=n_5610 B=n_4807 C=n_5008 VSS=VSS VDD=VDD
Xg119275 NAND3X1 $PINS Z=n_5869 A=n_5757 B=n_3462 C=n_4757 VSS=VSS VDD=VDD
Xg119276 NOR2X1 $PINS Z=n_5868 A=n_5276 B=n_5456 VSS=VSS VDD=VDD
Xg119277 NAND3X1 $PINS Z=n_5867 A=n_5561 B=n_4942 C=n_3974 VSS=VSS VDD=VDD
Xg119278 NAND3X1 $PINS Z=n_5866 A=n_5560 B=n_4722 C=n_4672 VSS=VSS VDD=VDD
Xg119279 NAND3X1 $PINS Z=n_5865 A=n_5558 B=n_4966 C=n_4710 VSS=VSS VDD=VDD
Xg119280 NAND3X1 $PINS Z=n_5864 A=n_5515 B=n_4790 C=n_4902 VSS=VSS VDD=VDD
Xg119281 NAND3X1 $PINS Z=n_5863 A=n_5557 B=n_4828 C=n_4884 VSS=VSS VDD=VDD
Xg119282 NOR2X1 $PINS Z=n_5862 A=n_5311 B=n_5550 VSS=VSS VDD=VDD
Xg119283 NAND3X1 $PINS Z=n_5861 A=n_5541 B=n_4726 C=n_4728 VSS=VSS VDD=VDD
Xg119284 NAND3X1 $PINS Z=n_5860 A=n_5556 B=n_4892 C=n_3548 VSS=VSS VDD=VDD
Xg119285 NAND3X1 $PINS Z=n_5859 A=n_5552 B=n_4739 C=n_4783 VSS=VSS VDD=VDD
Xg119286 NAND3X1 $PINS Z=n_5858 A=n_5656 B=n_3498 C=n_4719 VSS=VSS VDD=VDD
Xg119287 NAND3X1 $PINS Z=n_5857 A=n_5551 B=n_4717 C=n_4718 VSS=VSS VDD=VDD
Xg119288 NAND3X1 $PINS Z=n_5856 A=n_5752 B=n_5112 C=n_4709 VSS=VSS VDD=VDD
Xg119289 NAND3X1 $PINS Z=n_5855 A=n_5548 B=n_4798 C=n_4708 VSS=VSS VDD=VDD
Xg119290 NAND3X1 $PINS Z=n_5854 A=n_5754 B=n_4677 C=n_3607 VSS=VSS VDD=VDD
Xg119291 NAND3X1 $PINS Z=n_5853 A=n_5580 B=n_5122 C=n_5121 VSS=VSS VDD=VDD
Xg119292 NAND3X1 $PINS Z=n_5852 A=n_5542 B=n_4999 C=n_4010 VSS=VSS VDD=VDD
Xg119293 NAND3X1 $PINS Z=n_5851 A=n_5740 B=n_4807 C=n_3614 VSS=VSS VDD=VDD
Xg119294 NAND3X1 $PINS Z=n_5850 A=n_5568 B=n_5020 C=n_5017 VSS=VSS VDD=VDD
Xg119295 NAND3X1 $PINS Z=n_5849 A=n_5673 B=n_4089 C=n_4086 VSS=VSS VDD=VDD
Xg119296 NAND3X1 $PINS Z=n_5848 A=n_5538 B=n_3978 C=n_4834 VSS=VSS VDD=VDD
Xg119297 NAND3X1 $PINS Z=n_5847 A=n_5648 B=n_4895 C=n_4867 VSS=VSS VDD=VDD
Xg119298 NAND3X1 $PINS Z=n_5846 A=n_5755 B=n_3962 C=n_3945 VSS=VSS VDD=VDD
Xg119299 NAND3X1 $PINS Z=n_5845 A=n_5536 B=n_3434 C=n_4865 VSS=VSS VDD=VDD
Xg119300 NAND3X1 $PINS Z=n_5844 A=n_5535 B=n_4913 C=n_4784 VSS=VSS VDD=VDD
Xg119301 NAND3X1 $PINS Z=n_5843 A=n_5585 B=n_4163 C=n_3508 VSS=VSS VDD=VDD
Xg119302 NAND3X1 $PINS Z=n_5842 A=n_5488 B=n_4736 C=n_3891 VSS=VSS VDD=VDD
Xg119303 NAND3X1 $PINS Z=n_5841 A=n_5671 B=n_4987 C=n_3799 VSS=VSS VDD=VDD
Xg119304 NAND3X1 $PINS Z=n_5840 A=n_5537 B=n_4215 C=n_3567 VSS=VSS VDD=VDD
Xg119305 NAND3X1 $PINS Z=n_5839 A=n_5660 B=n_4712 C=n_3747 VSS=VSS VDD=VDD
Xg119306 NAND3X1 $PINS Z=n_5838 A=n_5497 B=n_4876 C=n_4975 VSS=VSS VDD=VDD
Xg119307 NAND3X1 $PINS Z=n_5837 A=n_5571 B=n_3535 C=n_4778 VSS=VSS VDD=VDD
Xg119308 NOR2X1 $PINS Z=n_5836 A=n_5314 B=n_5454 VSS=VSS VDD=VDD
Xg119309 NAND3X1 $PINS Z=n_5835 A=n_5530 B=n_4906 C=n_4126 VSS=VSS VDD=VDD
Xg119310 NAND3X1 $PINS Z=n_5834 A=n_5546 B=n_4804 C=n_4803 VSS=VSS VDD=VDD
Xg119311 NAND3X1 $PINS Z=n_5833 A=n_5747 B=n_4763 C=n_4963 VSS=VSS VDD=VDD
Xg119312 NAND3X1 $PINS Z=n_5832 A=n_5748 B=n_4881 C=n_4711 VSS=VSS VDD=VDD
Xg119313 NAND3X1 $PINS Z=n_5831 A=n_5758 B=n_4812 C=n_3742 VSS=VSS VDD=VDD
Xg119314 NAND3X1 $PINS Z=n_5830 A=n_5498 B=n_4835 C=n_3447 VSS=VSS VDD=VDD
Xg119315 NAND3X1 $PINS Z=n_5829 A=n_5511 B=n_3547 C=n_4868 VSS=VSS VDD=VDD
Xg119316 NAND3X1 $PINS Z=n_5828 A=n_5510 B=n_3544 C=n_3543 VSS=VSS VDD=VDD
Xg119317 NAND3X1 $PINS Z=n_5827 A=n_5751 B=n_5124 C=n_4766 VSS=VSS VDD=VDD
Xg119318 NAND3X1 $PINS Z=n_5826 A=n_5502 B=n_5001 C=n_5019 VSS=VSS VDD=VDD
Xg119319 NAND3X1 $PINS Z=n_5825 A=n_5760 B=n_5041 C=n_4931 VSS=VSS VDD=VDD
Xg119320 MUX2X1 $PINS Z=n_5824 A=spi_rx_data[0] B=spi_inst_shift_in[0] S=n_5409
+ VSS=VSS VDD=VDD
Xg119321 MUX2X1 $PINS Z=n_5823 A=spi_rx_data[1] B=spi_inst_shift_in[1] S=n_5409
+ VSS=VSS VDD=VDD
Xg119322 NAND3X1 $PINS Z=n_5822 A=n_5572 B=n_3518 C=n_4954 VSS=VSS VDD=VDD
Xg119323 MUX2X1 $PINS Z=n_5821 A=spi_rx_data[3] B=spi_inst_shift_in[3] S=n_5409
+ VSS=VSS VDD=VDD
Xg119324 MUX2X1 $PINS Z=n_5820 A=spi_rx_data[4] B=spi_inst_shift_in[4] S=n_5409
+ VSS=VSS VDD=VDD
Xg119325 MUX2X1 $PINS Z=n_5819 A=spi_rx_data[5] B=spi_inst_shift_in[5] S=n_5409
+ VSS=VSS VDD=VDD
Xg119326 MUX2X1 $PINS Z=n_5818 A=spi_rx_data[6] B=spi_inst_shift_in[6] S=n_5409
+ VSS=VSS VDD=VDD
Xg119327 MUX2X1 $PINS Z=n_5817 A=spi_rx_data[7] B=spi_inst_shift_in[7] S=n_5409
+ VSS=VSS VDD=VDD
Xg119328 MUX2X1 $PINS Z=n_5816 A=spi_rx_data[8] B=spi_inst_shift_in[8] S=n_5409
+ VSS=VSS VDD=VDD
Xg119329 MUX2X1 $PINS Z=n_5815 A=spi_rx_data[9] B=spi_inst_shift_in[9] S=n_5409
+ VSS=VSS VDD=VDD
Xg119330 MUX2X1 $PINS Z=n_5814 A=spi_rx_data[10] B=spi_inst_shift_in[10]
+ S=n_5409 VSS=VSS VDD=VDD
Xg119331 MUX2X1 $PINS Z=n_5813 A=spi_rx_data[11] B=spi_inst_shift_in[11]
+ S=n_5409 VSS=VSS VDD=VDD
Xg119332 MUX2X1 $PINS Z=n_5812 A=spi_rx_data[12] B=spi_inst_shift_in[12]
+ S=n_5409 VSS=VSS VDD=VDD
Xg119333 MUX2X1 $PINS Z=n_5811 A=spi_rx_data[13] B=spi_inst_shift_in[13]
+ S=n_5409 VSS=VSS VDD=VDD
Xg119334 MUX2X1 $PINS Z=n_5810 A=spi_rx_data[14] B=spi_inst_shift_in[14]
+ S=n_5409 VSS=VSS VDD=VDD
Xg119335 MUX2X1 $PINS Z=n_5809 A=spi_rx_data[15] B=spi_inst_shift_in[15]
+ S=n_5409 VSS=VSS VDD=VDD
Xg119336 MUX2X1 $PINS Z=n_5808 A=spi_rx_data[16] B=spi_inst_shift_in[16]
+ S=n_5409 VSS=VSS VDD=VDD
Xg119337 MUX2X1 $PINS Z=n_5807 A=spi_rx_data[17] B=spi_inst_shift_in[17]
+ S=n_5409 VSS=VSS VDD=VDD
Xg119338 MUX2X1 $PINS Z=n_5806 A=spi_rx_data[18] B=spi_inst_shift_in[18]
+ S=n_5409 VSS=VSS VDD=VDD
Xg119339 MUX2X1 $PINS Z=n_5805 A=spi_rx_data[19] B=spi_inst_shift_in[19]
+ S=n_5409 VSS=VSS VDD=VDD
Xg119340 MUX2X1 $PINS Z=n_5804 A=spi_rx_data[20] B=spi_inst_shift_in[20]
+ S=n_5409 VSS=VSS VDD=VDD
Xg119341 MUX2X1 $PINS Z=n_5803 A=spi_rx_data[21] B=spi_inst_shift_in[21]
+ S=n_5409 VSS=VSS VDD=VDD
Xg119342 MUX2X1 $PINS Z=n_5802 A=spi_rx_data[22] B=spi_inst_shift_in[22]
+ S=n_5409 VSS=VSS VDD=VDD
Xg119343 MUX2X1 $PINS Z=n_5801 A=spi_rx_data[23] B=spi_inst_shift_in[23]
+ S=n_5409 VSS=VSS VDD=VDD
Xg119344 MUX2X1 $PINS Z=n_5800 A=spi_rx_data[24] B=spi_inst_shift_in[24]
+ S=n_5409 VSS=VSS VDD=VDD
Xg119345 MUX2X1 $PINS Z=n_5799 A=spi_rx_data[26] B=spi_inst_shift_in[26]
+ S=n_5409 VSS=VSS VDD=VDD
Xg119346 MUX2X1 $PINS Z=n_5798 A=spi_rx_data[28] B=spi_inst_shift_in[28]
+ S=n_5409 VSS=VSS VDD=VDD
Xg119347 MUX2X1 $PINS Z=n_5797 A=spi_rx_data[29] B=spi_inst_shift_in[29]
+ S=n_5409 VSS=VSS VDD=VDD
Xg119348 MUX2X1 $PINS Z=n_5796 A=spi_rx_data[30] B=spi_inst_shift_in[30]
+ S=n_5409 VSS=VSS VDD=VDD
Xg119349 MUX2X1 $PINS Z=n_5795 A=spi_rx_data[31] B=spi_inst_shift_in[31]
+ S=n_5409 VSS=VSS VDD=VDD
Xg119350 MUX2X1 $PINS Z=n_5794 A=spi_rx_data[32] B=spi_inst_shift_in[32]
+ S=n_5409 VSS=VSS VDD=VDD
Xg119351 MUX2X1 $PINS Z=n_5793 A=spi_rx_data[33] B=spi_inst_shift_in[33]
+ S=n_5409 VSS=VSS VDD=VDD
Xg119352 MUX2X1 $PINS Z=n_5792 A=spi_rx_data[34] B=spi_inst_shift_in[34]
+ S=n_5409 VSS=VSS VDD=VDD
Xg119353 MUX2X1 $PINS Z=n_5791 A=spi_rx_data[35] B=spi_inst_shift_in[35]
+ S=n_5409 VSS=VSS VDD=VDD
Xg119354 MUX2X1 $PINS Z=n_5790 A=spi_rx_data[36] B=spi_inst_shift_in[36]
+ S=n_5409 VSS=VSS VDD=VDD
Xg119355 MUX2X1 $PINS Z=n_5789 A=spi_rx_data[37] B=spi_inst_shift_in[37]
+ S=n_5409 VSS=VSS VDD=VDD
Xg119356 MUX2X1 $PINS Z=n_5788 A=spi_rx_data[38] B=spi_inst_shift_in[38]
+ S=n_5409 VSS=VSS VDD=VDD
Xg119357 MUX2X1 $PINS Z=n_5787 A=spi_rx_data[39] B=spi_inst_shift_in[39]
+ S=n_5409 VSS=VSS VDD=VDD
Xg119358 MUX2X1 $PINS Z=n_5786 A=spi_rx_data[40] B=spi_inst_shift_in[40]
+ S=n_5409 VSS=VSS VDD=VDD
Xg119359 MUX2X1 $PINS Z=n_5785 A=spi_rx_data[41] B=spi_inst_shift_in[41]
+ S=n_5409 VSS=VSS VDD=VDD
Xg119360 MUX2X1 $PINS Z=n_5784 A=spi_rx_data[42] B=spi_inst_shift_in[42]
+ S=n_5409 VSS=VSS VDD=VDD
Xg119361 MUX2X1 $PINS Z=n_5783 A=spi_rx_data[43] B=spi_inst_shift_in[43]
+ S=n_5409 VSS=VSS VDD=VDD
Xg119362 MUX2X1 $PINS Z=n_5782 A=spi_rx_data[44] B=spi_inst_shift_in[44]
+ S=n_5409 VSS=VSS VDD=VDD
Xg119363 MUX2X1 $PINS Z=n_5781 A=spi_rx_data[45] B=spi_inst_shift_in[45]
+ S=n_5409 VSS=VSS VDD=VDD
Xg119364 MUX2X1 $PINS Z=n_5780 A=spi_rx_data[46] B=spi_inst_shift_in[46]
+ S=n_5409 VSS=VSS VDD=VDD
Xg119365 MUX2X1 $PINS Z=n_5779 A=spi_rx_data[47] B=spi_inst_shift_in[47]
+ S=n_5409 VSS=VSS VDD=VDD
Xg119366 MUX2X1 $PINS Z=n_5778 A=spi_rx_data[48] B=spi_inst_shift_in[48]
+ S=n_5409 VSS=VSS VDD=VDD
Xg119367 MUX2X1 $PINS Z=n_5777 A=spi_rx_data[49] B=spi_inst_shift_in[49]
+ S=n_5409 VSS=VSS VDD=VDD
Xg119368 MUX2X1 $PINS Z=n_5776 A=spi_rx_data[50] B=spi_inst_shift_in[50]
+ S=n_5409 VSS=VSS VDD=VDD
Xg119369 MUX2X1 $PINS Z=n_5775 A=spi_rx_data[51] B=spi_inst_shift_in[51]
+ S=n_5409 VSS=VSS VDD=VDD
Xg119370 MUX2X1 $PINS Z=n_5774 A=spi_rx_data[52] B=spi_inst_shift_in[52]
+ S=n_5409 VSS=VSS VDD=VDD
Xg119371 MUX2X1 $PINS Z=n_5773 A=spi_rx_data[53] B=spi_inst_shift_in[53]
+ S=n_5409 VSS=VSS VDD=VDD
Xg119372 MUX2X1 $PINS Z=n_5772 A=spi_rx_data[55] B=spi_inst_shift_in[55]
+ S=n_5409 VSS=VSS VDD=VDD
Xg119373 MUX2X1 $PINS Z=n_5771 A=spi_rx_data[56] B=spi_inst_shift_in[56]
+ S=n_5409 VSS=VSS VDD=VDD
Xg119374 MUX2X1 $PINS Z=n_5770 A=spi_rx_data[57] B=spi_inst_shift_in[57]
+ S=n_5409 VSS=VSS VDD=VDD
Xg119375 MUX2X1 $PINS Z=n_5769 A=spi_rx_data[58] B=spi_inst_shift_in[58]
+ S=n_5409 VSS=VSS VDD=VDD
Xg119376 MUX2X1 $PINS Z=n_5768 A=spi_rx_data[59] B=spi_inst_shift_in[59]
+ S=n_5409 VSS=VSS VDD=VDD
Xg119377 MUX2X1 $PINS Z=n_5767 A=spi_rx_data[60] B=spi_inst_shift_in[60]
+ S=n_5409 VSS=VSS VDD=VDD
Xg119378 MUX2X1 $PINS Z=n_5766 A=spi_rx_data[61] B=spi_inst_shift_in[61]
+ S=n_5409 VSS=VSS VDD=VDD
Xg119379 MUX2X1 $PINS Z=n_5765 A=spi_rx_data[62] B=spi_inst_shift_in[62]
+ S=n_5409 VSS=VSS VDD=VDD
Xg119380 MUX2X1 $PINS Z=n_5764 A=spi_rx_data[63] B=spi_inst_shift_in[63]
+ S=n_5409 VSS=VSS VDD=VDD
Xg119381 MUX2X1 $PINS Z=n_5763 A=spi_rx_data[54] B=spi_inst_shift_in[54]
+ S=n_5409 VSS=VSS VDD=VDD
Xg119382 MUX2X1 $PINS Z=n_5762 A=spi_rx_data[27] B=spi_inst_shift_in[27]
+ S=n_5409 VSS=VSS VDD=VDD
Xg119383 MUX2X1 $PINS Z=n_5761 A=spi_rx_data[25] B=spi_inst_shift_in[25]
+ S=n_5409 VSS=VSS VDD=VDD
Xg119384 NAND2X1 $PINS Z=n_5760 A=n_5202 B=n_82 VSS=VSS VDD=VDD
Xg119385 NAND2X1 $PINS Z=n_5759 A=n_5210 B=n_82 VSS=VSS VDD=VDD
Xg119386 NAND2X1 $PINS Z=n_5758 A=n_5207 B=n_82 VSS=VSS VDD=VDD
Xg119387 NAND2X1 $PINS Z=n_5757 A=n_5214 B=n_82 VSS=VSS VDD=VDD
Xg119388 NAND2X1 $PINS Z=n_5756 A=n_5238 B=n_82 VSS=VSS VDD=VDD
Xg119389 NAND2X1 $PINS Z=n_5755 A=n_5226 B=n_82 VSS=VSS VDD=VDD
Xg119390 NAND2X1 $PINS Z=n_5754 A=n_5237 B=n_82 VSS=VSS VDD=VDD
Xg119391 NAND2X1 $PINS Z=n_5753 A=n_5230 B=n_82 VSS=VSS VDD=VDD
Xg119392 NAND2X1 $PINS Z=n_5752 A=n_5232 B=n_82 VSS=VSS VDD=VDD
Xg119393 NAND2X1 $PINS Z=n_5751 A=n_5198 B=n_82 VSS=VSS VDD=VDD
Xg119394 NAND2X1 $PINS Z=n_5750 A=n_5240 B=n_82 VSS=VSS VDD=VDD
Xg119395 NAND2X1 $PINS Z=n_5749 A=n_5264 B=n_82 VSS=VSS VDD=VDD
Xg119396 NAND2X1 $PINS Z=n_5748 A=n_5243 B=n_82 VSS=VSS VDD=VDD
Xg119397 NAND2X1 $PINS Z=n_5747 A=n_5229 B=n_82 VSS=VSS VDD=VDD
Xg119398 NAND2X1 $PINS Z=n_5746 A=n_5205 B=n_82 VSS=VSS VDD=VDD
Xg119399 NAND2X1 $PINS Z=n_5745 A=n_5245 B=n_82 VSS=VSS VDD=VDD
Xg119400 NAND2X1 $PINS Z=n_5744 A=n_5246 B=n_82 VSS=VSS VDD=VDD
Xg119401 NAND2X1 $PINS Z=n_5743 A=n_5235 B=n_82 VSS=VSS VDD=VDD
Xg119402 NAND2X1 $PINS Z=n_5742 A=n_5254 B=n_82 VSS=VSS VDD=VDD
Xg119403 NAND2X1 $PINS Z=n_5741 A=n_5263 B=n_82 VSS=VSS VDD=VDD
Xg119404 NAND2X1 $PINS Z=n_5740 A=n_5252 B=n_82 VSS=VSS VDD=VDD
Xg119405 NAND2X1 $PINS Z=n_5739 A=n_5217 B=n_82 VSS=VSS VDD=VDD
Xg119406 NAND2X1 $PINS Z=n_5738 A=n_5258 B=n_82 VSS=VSS VDD=VDD
Xg119407 NAND2X1 $PINS Z=n_5737 A=n_5247 B=n_82 VSS=VSS VDD=VDD
Xg119408 NAND2X1 $PINS Z=n_5736 A=n_5266 B=n_82 VSS=VSS VDD=VDD
Xg119409 NAND2X1 $PINS Z=n_5735 A=spi_tx_data[62] B=n_137 VSS=VSS VDD=VDD
Xg119410 NAND2X1 $PINS Z=n_5734 A=spi_tx_data[58] B=n_137 VSS=VSS VDD=VDD
Xg119411 NAND2X1 $PINS Z=n_5733 A=spi_tx_data[30] B=n_137 VSS=VSS VDD=VDD
Xg119412 NOR2X1 $PINS Z=n_5732 A=n_137 B=spi_inst_bit_count[0] VSS=VSS VDD=VDD
Xg119413 NAND2X1 $PINS Z=n_5731 A=spi_tx_data[61] B=n_137 VSS=VSS VDD=VDD
Xg119414 NAND2X1 $PINS Z=n_5730 A=spi_tx_data[60] B=n_137 VSS=VSS VDD=VDD
Xg119415 NAND2X1 $PINS Z=n_5729 A=spi_tx_data[59] B=n_137 VSS=VSS VDD=VDD
Xg119416 NAND2X1 $PINS Z=n_5728 A=spi_tx_data[57] B=n_137 VSS=VSS VDD=VDD
Xg119417 NAND2X1 $PINS Z=n_5727 A=spi_tx_data[55] B=n_137 VSS=VSS VDD=VDD
Xg119418 NAND2X1 $PINS Z=n_5726 A=spi_tx_data[54] B=n_137 VSS=VSS VDD=VDD
Xg119419 NAND2X1 $PINS Z=n_5725 A=spi_tx_data[53] B=n_137 VSS=VSS VDD=VDD
Xg119420 NAND2X1 $PINS Z=n_5724 A=spi_tx_data[52] B=n_137 VSS=VSS VDD=VDD
Xg119421 NOR2X1 $PINS Z=n_5723 A=n_137 B=spi_inst_bit_count[5] VSS=VSS VDD=VDD
Xg119422 NAND2X1 $PINS Z=n_5722 A=spi_tx_data[51] B=n_137 VSS=VSS VDD=VDD
Xg119423 NAND2X1 $PINS Z=n_5721 A=spi_tx_data[50] B=n_137 VSS=VSS VDD=VDD
Xg119424 NAND2X1 $PINS Z=n_5720 A=spi_tx_data[49] B=n_137 VSS=VSS VDD=VDD
Xg119425 NAND2X1 $PINS Z=n_5719 A=spi_tx_data[48] B=n_137 VSS=VSS VDD=VDD
Xg119426 NAND2X1 $PINS Z=n_5718 A=spi_tx_data[47] B=n_137 VSS=VSS VDD=VDD
Xg119427 NAND2X1 $PINS Z=n_5717 A=spi_tx_data[46] B=n_137 VSS=VSS VDD=VDD
Xg119428 NAND2X1 $PINS Z=n_5716 A=spi_tx_data[45] B=n_137 VSS=VSS VDD=VDD
Xg119429 NAND2X1 $PINS Z=n_5715 A=spi_tx_data[44] B=n_137 VSS=VSS VDD=VDD
Xg119430 NAND2X1 $PINS Z=n_5714 A=spi_tx_data[43] B=n_137 VSS=VSS VDD=VDD
Xg119431 NAND2X1 $PINS Z=n_5713 A=spi_tx_data[42] B=n_137 VSS=VSS VDD=VDD
Xg119432 NAND2X1 $PINS Z=n_5712 A=spi_tx_data[41] B=n_137 VSS=VSS VDD=VDD
Xg119433 NAND2X1 $PINS Z=n_5711 A=spi_tx_data[40] B=n_137 VSS=VSS VDD=VDD
Xg119434 NAND2X1 $PINS Z=n_5710 A=spi_tx_data[39] B=n_137 VSS=VSS VDD=VDD
Xg119435 NAND2X1 $PINS Z=n_5709 A=spi_tx_data[38] B=n_137 VSS=VSS VDD=VDD
Xg119436 NAND2X1 $PINS Z=n_5708 A=spi_tx_data[37] B=n_137 VSS=VSS VDD=VDD
Xg119437 NAND2X1 $PINS Z=n_5707 A=spi_tx_data[36] B=n_137 VSS=VSS VDD=VDD
Xg119438 NAND2X1 $PINS Z=n_5706 A=spi_tx_data[35] B=n_137 VSS=VSS VDD=VDD
Xg119439 NAND2X1 $PINS Z=n_5705 A=spi_tx_data[34] B=n_137 VSS=VSS VDD=VDD
Xg119440 NAND2X1 $PINS Z=n_5704 A=spi_tx_data[33] B=n_137 VSS=VSS VDD=VDD
Xg119441 NAND2X1 $PINS Z=n_5703 A=spi_tx_data[32] B=n_137 VSS=VSS VDD=VDD
Xg119442 NAND2X1 $PINS Z=n_5702 A=spi_tx_data[31] B=n_137 VSS=VSS VDD=VDD
Xg119443 NAND2X1 $PINS Z=n_5701 A=spi_tx_data[29] B=n_137 VSS=VSS VDD=VDD
Xg119444 NAND2X1 $PINS Z=n_5700 A=spi_tx_data[28] B=n_137 VSS=VSS VDD=VDD
Xg119445 NAND2X1 $PINS Z=n_5699 A=spi_tx_data[27] B=n_137 VSS=VSS VDD=VDD
Xg119446 NAND2X1 $PINS Z=n_5698 A=spi_tx_data[26] B=n_137 VSS=VSS VDD=VDD
Xg119447 NAND2X1 $PINS Z=n_5697 A=spi_tx_data[25] B=n_137 VSS=VSS VDD=VDD
Xg119448 NAND2X1 $PINS Z=n_5696 A=spi_tx_data[24] B=n_137 VSS=VSS VDD=VDD
Xg119449 NAND2X1 $PINS Z=n_5695 A=spi_tx_data[23] B=n_137 VSS=VSS VDD=VDD
Xg119450 NAND2X1 $PINS Z=n_5694 A=spi_tx_data[22] B=n_137 VSS=VSS VDD=VDD
Xg119451 NAND2X1 $PINS Z=n_5693 A=spi_tx_data[21] B=n_137 VSS=VSS VDD=VDD
Xg119452 NAND2X1 $PINS Z=n_5692 A=spi_tx_data[20] B=n_137 VSS=VSS VDD=VDD
Xg119453 NAND3X1 $PINS Z=n_5691 A=n_5280 B=n_3560 C=n_2682 VSS=VSS VDD=VDD
Xg119454 NOR2X1 $PINS Z=n_5690 A=start_encrypt B=n_5323 VSS=VSS VDD=VDD
Xg119455 NAND2X1 $PINS Z=n_5689 A=n_5162 B=n_4915 VSS=VSS VDD=VDD
Xg119456 OR2X1 $PINS Z=n_5688 A=n_218 B=n_5129 VSS=VSS VDD=VDD
Xg119457 NAND2X1 $PINS Z=n_5687 A=n_5269 B=n_1085 VSS=VSS VDD=VDD
Xg119458 NAND2X1 $PINS Z=n_5686 A=n_5268 B=n_1085 VSS=VSS VDD=VDD
Xg119459 NAND2X1 $PINS Z=n_5685 A=n_5215 B=n_1085 VSS=VSS VDD=VDD
Xg119460 NAND2X1 $PINS Z=n_5684 A=n_5228 B=n_1085 VSS=VSS VDD=VDD
Xg119461 NAND2X1 $PINS Z=n_5683 A=n_5250 B=n_1085 VSS=VSS VDD=VDD
Xg119462 NAND2X1 $PINS Z=n_5682 A=n_5248 B=n_1085 VSS=VSS VDD=VDD
Xg119463 NAND2X1 $PINS Z=n_5681 A=n_5264 B=n_1085 VSS=VSS VDD=VDD
Xg119464 NAND2X1 $PINS Z=n_5680 A=n_5254 B=n_1085 VSS=VSS VDD=VDD
Xg119465 NAND2X1 $PINS Z=n_5679 A=n_5241 B=n_1085 VSS=VSS VDD=VDD
Xg119466 NAND2X1 $PINS Z=n_5678 A=n_5247 B=n_1085 VSS=VSS VDD=VDD
Xg119467 NAND2X1 $PINS Z=n_5677 A=n_5240 B=n_1085 VSS=VSS VDD=VDD
Xg119468 NAND2X1 $PINS Z=n_5676 A=n_5239 B=n_1085 VSS=VSS VDD=VDD
Xg119469 NAND2X1 $PINS Z=n_5675 A=n_5257 B=n_1085 VSS=VSS VDD=VDD
Xg119470 NAND2X1 $PINS Z=n_5674 A=n_5207 B=n_1085 VSS=VSS VDD=VDD
Xg119471 NAND2X1 $PINS Z=n_5673 A=n_5229 B=n_1085 VSS=VSS VDD=VDD
Xg119472 NAND2X1 $PINS Z=n_5672 A=n_5238 B=n_1085 VSS=VSS VDD=VDD
Xg119473 NAND2X1 $PINS Z=n_5671 A=n_5220 B=n_1085 VSS=VSS VDD=VDD
Xg119474 NAND2X1 $PINS Z=n_5670 A=n_5235 B=n_1085 VSS=VSS VDD=VDD
Xg119475 NAND2X1 $PINS Z=n_5669 A=n_5223 B=n_1085 VSS=VSS VDD=VDD
Xg119476 NAND2X1 $PINS Z=n_5668 A=n_5226 B=n_1085 VSS=VSS VDD=VDD
Xg119477 NAND2X1 $PINS Z=n_5667 A=n_5213 B=n_1085 VSS=VSS VDD=VDD
Xg119478 NAND2X1 $PINS Z=n_5666 A=n_5220 B=n_1101 VSS=VSS VDD=VDD
Xg119479 NAND2X1 $PINS Z=n_5665 A=n_5269 B=n_1101 VSS=VSS VDD=VDD
Xg119480 NAND2X1 $PINS Z=n_5664 A=n_5218 B=n_1101 VSS=VSS VDD=VDD
Xg119481 NAND2X1 $PINS Z=n_5663 A=n_5216 B=n_1101 VSS=VSS VDD=VDD
Xg119482 NAND2X1 $PINS Z=n_5662 A=n_5257 B=n_1101 VSS=VSS VDD=VDD
Xg119483 NAND2X1 $PINS Z=n_5661 A=n_5260 B=n_1101 VSS=VSS VDD=VDD
Xg119484 NAND2X1 $PINS Z=n_5660 A=n_5209 B=n_1101 VSS=VSS VDD=VDD
Xg119485 NAND2X1 $PINS Z=n_5659 A=n_5248 B=n_1101 VSS=VSS VDD=VDD
Xg119486 NAND2X1 $PINS Z=n_5658 A=n_5241 B=n_1101 VSS=VSS VDD=VDD
Xg119487 NAND2X1 $PINS Z=n_5657 A=n_5225 B=n_1101 VSS=VSS VDD=VDD
Xg119488 NAND2X1 $PINS Z=n_5656 A=n_5239 B=n_1101 VSS=VSS VDD=VDD
Xg119489 NAND2X1 $PINS Z=n_5655 A=n_5270 B=n_1101 VSS=VSS VDD=VDD
Xg119490 NAND2X1 $PINS Z=n_5654 A=n_5223 B=n_1101 VSS=VSS VDD=VDD
Xg119491 NAND2X1 $PINS Z=n_5653 A=n_5268 B=n_1101 VSS=VSS VDD=VDD
Xg119492 NAND2X1 $PINS Z=n_5652 A=n_5215 B=n_1101 VSS=VSS VDD=VDD
Xg119493 NAND2X1 $PINS Z=n_5651 A=n_5213 B=n_1101 VSS=VSS VDD=VDD
Xg119494 NAND2X1 $PINS Z=n_5650 A=n_5250 B=n_1101 VSS=VSS VDD=VDD
Xg119495 NAND2X1 $PINS Z=n_5649 A=n_5228 B=n_1101 VSS=VSS VDD=VDD
Xg119496 NAND2X1 $PINS Z=n_5648 A=n_5222 B=n_1101 VSS=VSS VDD=VDD
Xg119497 NAND2X1 $PINS Z=n_5647 A=n_5204 B=n_1101 VSS=VSS VDD=VDD
Xg119498 NAND2X1 $PINS Z=n_5646 A=spi_tx_data[56] B=n_137 VSS=VSS VDD=VDD
Xg119499 NAND2X1 $PINS Z=n_5645 A=spi_tx_data[63] B=n_137 VSS=VSS VDD=VDD
Xg119500 NAND2X1 $PINS Z=n_5644 A=spi_tx_data[0] B=n_137 VSS=VSS VDD=VDD
Xg119501 NAND2X1 $PINS Z=n_5643 A=spi_tx_data[1] B=n_137 VSS=VSS VDD=VDD
Xg119502 NAND2X1 $PINS Z=n_5642 A=spi_tx_data[2] B=n_137 VSS=VSS VDD=VDD
Xg119503 NAND2X1 $PINS Z=n_5641 A=spi_tx_data[3] B=n_137 VSS=VSS VDD=VDD
Xg119504 NAND2X1 $PINS Z=n_5640 A=spi_tx_data[4] B=n_137 VSS=VSS VDD=VDD
Xg119505 NAND2X1 $PINS Z=n_5639 A=spi_tx_data[5] B=n_137 VSS=VSS VDD=VDD
Xg119506 NAND2X1 $PINS Z=n_5638 A=spi_tx_data[6] B=n_137 VSS=VSS VDD=VDD
Xg119507 NAND2X1 $PINS Z=n_5637 A=spi_tx_data[7] B=n_137 VSS=VSS VDD=VDD
Xg119508 NAND2X1 $PINS Z=n_5636 A=spi_tx_data[8] B=n_137 VSS=VSS VDD=VDD
Xg119509 NAND2X1 $PINS Z=n_5635 A=spi_tx_data[9] B=n_137 VSS=VSS VDD=VDD
Xg119510 NAND2X1 $PINS Z=n_5634 A=spi_tx_data[10] B=n_137 VSS=VSS VDD=VDD
Xg119511 NAND2X1 $PINS Z=n_5633 A=spi_tx_data[11] B=n_137 VSS=VSS VDD=VDD
Xg119512 NAND2X1 $PINS Z=n_5632 A=spi_tx_data[12] B=n_137 VSS=VSS VDD=VDD
Xg119513 NAND2X1 $PINS Z=n_5631 A=spi_tx_data[13] B=n_137 VSS=VSS VDD=VDD
Xg119514 NAND2X1 $PINS Z=n_5630 A=spi_tx_data[14] B=n_137 VSS=VSS VDD=VDD
Xg119515 NAND2X1 $PINS Z=n_5629 A=spi_tx_data[15] B=n_137 VSS=VSS VDD=VDD
Xg119516 NAND2X1 $PINS Z=n_5628 A=spi_tx_data[16] B=n_137 VSS=VSS VDD=VDD
Xg119517 NAND2X1 $PINS Z=n_5627 A=spi_tx_data[17] B=n_137 VSS=VSS VDD=VDD
Xg119518 NAND2X1 $PINS Z=n_5626 A=spi_tx_data[18] B=n_137 VSS=VSS VDD=VDD
Xg119519 NAND2X1 $PINS Z=n_5625 A=spi_tx_data[19] B=n_137 VSS=VSS VDD=VDD
Xg119589 INVX2 $PINS Z=n_5624 A=n_5467 VSS=VSS VDD=VDD
Xg119590 INVX2 $PINS Z=n_5623 A=n_5423 VSS=VSS VDD=VDD
Xg119591 NAND2X1 $PINS Z=n_5617 A=n_5270 B=n_81 VSS=VSS VDD=VDD
Xg119592 NAND2X1 $PINS Z=n_5616 A=n_5267 B=n_131 VSS=VSS VDD=VDD
Xg119593 NAND2X1 $PINS Z=n_5615 A=n_5211 B=n_126 VSS=VSS VDD=VDD
Xg119594 NAND2X1 $PINS Z=n_5614 A=n_5335 B=csm_inst_mode VSS=VSS VDD=VDD
Xg119595 NAND2X1 $PINS Z=n_5613 A=n_5321 B=csm_inst_mode VSS=VSS VDD=VDD
Xg119596 NAND3X1 $PINS Z=n_5612 A=n_4793 B=n_3821 C=n_4788 VSS=VSS VDD=VDD
Xg119597 NAND2X1 $PINS Z=n_5611 A=n_5204 B=n_81 VSS=VSS VDD=VDD
Xg119598 NAND2X1 $PINS Z=n_5610 A=n_5266 B=n_81 VSS=VSS VDD=VDD
Xg119599 NAND2X1 $PINS Z=n_5609 A=n_5261 B=n_126 VSS=VSS VDD=VDD
Xg119600 NAND2X1 $PINS Z=n_5608 A=n_4753 B=n_5402 VSS=VSS VDD=VDD
Xg119601 NAND3X1 $PINS Z=n_5607 A=n_4794 B=n_4953 C=n_4922 VSS=VSS VDD=VDD
Xg119602 NAND2X1 $PINS Z=n_5606 A=n_5407 B=n_5271 VSS=VSS VDD=VDD
Xg119603 NAND2X1 $PINS Z=n_5605 A=n_5265 B=n_131 VSS=VSS VDD=VDD
Xg119604 NAND2X1 $PINS Z=n_5604 A=n_5201 B=n_126 VSS=VSS VDD=VDD
Xg119605 NAND3X1 $PINS Z=n_5603 A=n_4792 B=n_3666 C=n_5010 VSS=VSS VDD=VDD
Xg119606 NAND2X1 $PINS Z=n_5602 A=n_5199 B=n_131 VSS=VSS VDD=VDD
Xg119607 NAND2X1 $PINS Z=n_5601 A=n_5231 B=n_126 VSS=VSS VDD=VDD
Xg119608 NAND3X1 $PINS Z=n_5600 A=n_4793 B=n_4161 C=n_3450 VSS=VSS VDD=VDD
Xg119609 NAND2X1 $PINS Z=n_5599 A=n_5260 B=n_81 VSS=VSS VDD=VDD
Xg119610 NAND2X1 $PINS Z=n_5598 A=n_5206 B=n_126 VSS=VSS VDD=VDD
Xg119611 NAND2X1 $PINS Z=n_5597 A=n_5219 B=n_126 VSS=VSS VDD=VDD
Xg119612 NAND3X1 $PINS Z=n_5596 A=n_4793 B=n_4869 C=n_4732 VSS=VSS VDD=VDD
Xg119613 NAND2X1 $PINS Z=n_5595 A=n_5330 B=n_3514 VSS=VSS VDD=VDD
Xg119614 NAND2X1 $PINS Z=n_5594 A=n_5227 B=n_131 VSS=VSS VDD=VDD
Xg119615 NAND2X1 $PINS Z=n_5593 A=n_5115 B=n_136 VSS=VSS VDD=VDD
Xg119616 NAND2X1 $PINS Z=n_5592 A=n_3314 B=n_136 VSS=VSS VDD=VDD
Xg119617 NAND3X1 $PINS Z=n_5591 A=n_4793 B=n_4747 C=n_4749 VSS=VSS VDD=VDD
Xg119618 NAND2X1 $PINS Z=n_5590 A=n_5414 B=n_136 VSS=VSS VDD=VDD
Xg119619 NAND2X1 $PINS Z=n_5589 A=n_5256 B=n_131 VSS=VSS VDD=VDD
Xg119620 NAND2X1 $PINS Z=n_5588 A=n_5274 B=n_477 VSS=VSS VDD=VDD
Xg119622 NAND3X1 $PINS Z=n_5586 A=n_4758 B=n_3436 C=n_4776 VSS=VSS VDD=VDD
Xg119623 NAND3X1 $PINS Z=n_5585 A=n_4794 B=n_3615 C=n_4324 VSS=VSS VDD=VDD
Xg119624 NAND3X1 $PINS Z=n_5584 A=n_3527 B=n_4995 C=n_126 VSS=VSS VDD=VDD
Xg119625 NAND3X1 $PINS Z=n_5583 A=n_4793 B=n_4997 C=n_4885 VSS=VSS VDD=VDD
Xg119626 NAND3X1 $PINS Z=n_5582 A=n_4874 B=n_4331 C=n_197 VSS=VSS VDD=VDD
Xg119627 NAND2X1 $PINS Z=n_5581 A=n_5255 B=n_81 VSS=VSS VDD=VDD
Xg119628 NAND2X1 $PINS Z=n_5580 A=n_5252 B=n_81 VSS=VSS VDD=VDD
Xg119629 NAND3X1 $PINS Z=n_5579 A=n_4792 B=n_4965 C=n_4986 VSS=VSS VDD=VDD
Xg119630 NAND3X1 $PINS Z=n_5578 A=n_4792 B=n_3630 C=n_3573 VSS=VSS VDD=VDD
Xg119631 NAND2X1 $PINS Z=n_5577 A=n_5258 B=n_81 VSS=VSS VDD=VDD
Xg119632 NAND2X1 $PINS Z=n_5576 A=n_5243 B=n_81 VSS=VSS VDD=VDD
Xg119633 NAND3X1 $PINS Z=n_5575 A=n_4792 B=n_3591 C=n_3844 VSS=VSS VDD=VDD
Xg119634 NAND2X1 $PINS Z=n_5574 A=n_5253 B=n_126 VSS=VSS VDD=VDD
Xg119635 NAND2X1 $PINS Z=n_5573 A=n_5219 B=n_131 VSS=VSS VDD=VDD
Xg119636 NAND2X1 $PINS Z=n_5572 A=n_5205 B=n_81 VSS=VSS VDD=VDD
Xg119637 NAND2X1 $PINS Z=n_5571 A=n_5209 B=n_81 VSS=VSS VDD=VDD
Xg119638 NAND2X1 $PINS Z=n_5570 A=n_5259 B=n_126 VSS=VSS VDD=VDD
Xg119639 NAND3X1 $PINS Z=n_5569 A=n_4792 B=n_4731 C=n_4930 VSS=VSS VDD=VDD
Xg119640 NAND2X1 $PINS Z=n_5568 A=n_5234 B=n_126 VSS=VSS VDD=VDD
Xg119641 NAND2X1 $PINS Z=n_5567 A=n_5259 B=n_81 VSS=VSS VDD=VDD
Xg119642 NAND2X1 $PINS Z=n_5566 A=n_5256 B=n_126 VSS=VSS VDD=VDD
Xg119643 NAND3X1 $PINS Z=n_5565 A=n_4792 B=n_3461 C=n_4761 VSS=VSS VDD=VDD
Xg119644 NAND2X1 $PINS Z=n_5564 A=n_5198 B=n_131 VSS=VSS VDD=VDD
Xg119645 NAND2X1 $PINS Z=n_5563 A=n_5263 B=n_131 VSS=VSS VDD=VDD
Xg119646 NAND2X1 $PINS Z=n_5562 A=n_5261 B=n_131 VSS=VSS VDD=VDD
Xg119647 NAND2X1 $PINS Z=n_5561 A=n_5203 B=n_126 VSS=VSS VDD=VDD
Xg119648 NAND2X1 $PINS Z=n_5560 A=n_5283 B=n_4829 VSS=VSS VDD=VDD
Xg119649 NAND2X1 $PINS Z=n_5559 A=n_5251 B=n_126 VSS=VSS VDD=VDD
Xg119650 NAND2X1 $PINS Z=n_5558 A=n_5233 B=n_126 VSS=VSS VDD=VDD
Xg119651 NAND2X1 $PINS Z=n_5557 A=n_5200 B=n_126 VSS=VSS VDD=VDD
Xg119652 NAND2X1 $PINS Z=n_5556 A=n_5253 B=n_81 VSS=VSS VDD=VDD
Xg119653 NAND2X1 $PINS Z=n_5555 A=n_5233 B=n_131 VSS=VSS VDD=VDD
Xg119654 NAND2X1 $PINS Z=n_5554 A=n_5211 B=n_131 VSS=VSS VDD=VDD
Xg119655 OR2X1 $PINS Z=n_5553 A=n_116 B=n_5255 VSS=VSS VDD=VDD
Xg119656 NAND2X1 $PINS Z=n_5552 A=n_5232 B=n_81 VSS=VSS VDD=VDD
Xg119657 NAND3X1 $PINS Z=n_5551 A=n_4794 B=n_4715 C=n_3776 VSS=VSS VDD=VDD
Xg119658 NOR2X1 $PINS Z=n_5550 A=n_4714 B=n_5308 VSS=VSS VDD=VDD
Xg119659 NAND2X1 $PINS Z=n_5549 A=n_5309 B=n_1119 VSS=VSS VDD=VDD
Xg119660 NAND2X1 $PINS Z=n_5548 A=n_5212 B=n_81 VSS=VSS VDD=VDD
Xg119661 NAND2X1 $PINS Z=n_5547 A=n_5244 B=n_126 VSS=VSS VDD=VDD
Xg119662 NAND2X1 $PINS Z=n_5546 A=n_5245 B=n_81 VSS=VSS VDD=VDD
Xg119663 NAND2X1 $PINS Z=n_5545 A=n_5415 B=n_193 VSS=VSS VDD=VDD
Xg119664 NAND2X1 $PINS Z=n_5544 A=n_5217 B=n_81 VSS=VSS VDD=VDD
Xg119665 NAND2X1 $PINS Z=n_5543 A=n_5265 B=n_126 VSS=VSS VDD=VDD
Xg119666 NAND2X1 $PINS Z=n_5542 A=n_5231 B=n_81 VSS=VSS VDD=VDD
Xg119667 NAND2X1 $PINS Z=n_5541 A=n_5222 B=n_81 VSS=VSS VDD=VDD
Xg119668 NAND2X1 $PINS Z=n_5540 A=n_5242 B=n_131 VSS=VSS VDD=VDD
Xg119669 NAND3X1 $PINS Z=n_5539 A=n_5367 B=n_1016 C=n_5068 VSS=VSS VDD=VDD
Xg119670 NAND2X1 $PINS Z=n_5538 A=n_5246 B=n_81 VSS=VSS VDD=VDD
Xg119671 NAND2X1 $PINS Z=n_5537 A=n_5216 B=n_81 VSS=VSS VDD=VDD
Xg119672 NAND3X1 $PINS Z=n_5536 A=n_4864 B=n_3893 C=n_167 VSS=VSS VDD=VDD
Xg119673 NAND2X1 $PINS Z=n_5535 A=n_5224 B=n_126 VSS=VSS VDD=VDD
Xg119674 AND2X1 $PINS Z=n_5534 A=n_5267 B=n_126 VSS=VSS VDD=VDD
Xg119675 NAND2X1 $PINS Z=n_5533 A=n_5236 B=n_126 VSS=VSS VDD=VDD
Xg119676 NAND2X1 $PINS Z=n_5532 A=n_5221 B=n_131 VSS=VSS VDD=VDD
Xg119677 NAND2X1 $PINS Z=n_5531 A=n_5262 B=n_126 VSS=VSS VDD=VDD
Xg119678 NAND2X1 $PINS Z=n_5530 A=n_5244 B=n_131 VSS=VSS VDD=VDD
Xg119679 NAND2X1 $PINS Z=n_5529 A=n_5221 B=n_126 VSS=VSS VDD=VDD
Xg119680 NAND2X1 $PINS Z=n_5528 A=n_5251 B=n_131 VSS=VSS VDD=VDD
Xg119681 NAND2X1 $PINS Z=n_5527 A=n_5130 B=n_81 VSS=VSS VDD=VDD
Xg119682 NAND2X1 $PINS Z=n_5526 A=n_5214 B=n_81 VSS=VSS VDD=VDD
Xg119683 NAND2X1 $PINS Z=n_5525 A=n_5196 B=n_196 VSS=VSS VDD=VDD
Xg119684 NAND2X1 $PINS Z=n_5524 A=n_5218 B=n_81 VSS=VSS VDD=VDD
Xg119685 NAND2X1 $PINS Z=n_5523 A=n_5230 B=n_131 VSS=VSS VDD=VDD
Xg119686 NAND2X1 $PINS Z=n_5522 A=n_5236 B=n_131 VSS=VSS VDD=VDD
Xg119687 NAND2X1 $PINS Z=n_5521 A=n_5127 B=n_3264 VSS=VSS VDD=VDD
Xg119688 NAND2X1 $PINS Z=n_5520 A=n_5307 B=n_1119 VSS=VSS VDD=VDD
Xg119689 NAND2X1 $PINS Z=n_5519 A=n_5210 B=n_81 VSS=VSS VDD=VDD
Xg119690 NAND2X1 $PINS Z=n_5518 A=n_5227 B=n_126 VSS=VSS VDD=VDD
Xg119691 NAND2X1 $PINS Z=n_5517 A=n_5208 B=n_81 VSS=VSS VDD=VDD
Xg119692 NAND2X1 $PINS Z=n_5516 A=n_5262 B=n_131 VSS=VSS VDD=VDD
Xg119693 NAND2X1 $PINS Z=n_5515 A=n_5249 B=n_131 VSS=VSS VDD=VDD
Xg119694 NAND3X1 $PINS Z=n_5514 A=n_4793 B=n_4724 C=n_4730 VSS=VSS VDD=VDD
Xg119695 NAND2X1 $PINS Z=n_5513 A=n_5202 B=n_81 VSS=VSS VDD=VDD
Xg119696 NAND2X1 $PINS Z=n_5512 A=n_5237 B=n_131 VSS=VSS VDD=VDD
Xg119697 NAND2X1 $PINS Z=n_5511 A=n_5206 B=n_131 VSS=VSS VDD=VDD
Xg119698 NAND2X1 $PINS Z=n_5510 A=n_5249 B=n_126 VSS=VSS VDD=VDD
Xg119699 NAND2X1 $PINS Z=n_5509 A=n_5242 B=n_126 VSS=VSS VDD=VDD
Xg119700 NAND2X1 $PINS Z=n_5508 A=n_5199 B=n_126 VSS=VSS VDD=VDD
Xg119701 NAND2X1 $PINS Z=n_5507 A=n_5224 B=n_131 VSS=VSS VDD=VDD
Xg119702 NAND2X1 $PINS Z=n_5506 A=n_5200 B=n_81 VSS=VSS VDD=VDD
Xg119703 NAND2X1 $PINS Z=n_5505 A=n_5234 B=n_131 VSS=VSS VDD=VDD
Xg119704 NAND2X1 $PINS Z=n_5504 A=n_5208 B=n_126 VSS=VSS VDD=VDD
Xg119705 NAND2X1 $PINS Z=n_5503 A=n_5225 B=n_81 VSS=VSS VDD=VDD
Xg119706 NAND3X1 $PINS Z=n_5502 A=n_4792 B=n_4873 C=n_3491 VSS=VSS VDD=VDD
Xg119707 NAND2X1 $PINS Z=n_5501 A=n_5212 B=n_126 VSS=VSS VDD=VDD
Xg119708 NAND2X1 $PINS Z=n_5500 A=n_5203 B=n_131 VSS=VSS VDD=VDD
Xg119709 NAND2X1 $PINS Z=n_5499 A=n_5201 B=n_131 VSS=VSS VDD=VDD
Xg119710 AND2X1 $PINS Z=n_5498 A=n_5336 B=n_4795 VSS=VSS VDD=VDD
Xg119711 NAND3X1 $PINS Z=n_5497 A=n_3510 B=n_5011
+ C=FE_DBTN2_csm_inst_round_counter_0 VSS=VSS VDD=VDD
Xg119712 NAND2X1 $PINS Z=n_5496 A=n_5277 B=n_119 VSS=VSS VDD=VDD
Xg119713 NAND2X1 $PINS Z=n_5495 A=n_5333 B=n_110 VSS=VSS VDD=VDD
Xg119714 NAND2X1 $PINS Z=n_5494 A=n_5324 B=n_110 VSS=VSS VDD=VDD
Xg119715 NAND2X1 $PINS Z=n_5493 A=n_5286 B=n_110 VSS=VSS VDD=VDD
Xg119716 NAND2X1 $PINS Z=n_5492 A=n_5300 B=n_119 VSS=VSS VDD=VDD
Xg119717 NAND2X1 $PINS Z=n_5491 A=n_5299 B=n_119 VSS=VSS VDD=VDD
Xg119718 NAND2X1 $PINS Z=n_5490 A=n_5273 B=n_4707 VSS=VSS VDD=VDD
Xg119719 NAND2X1 $PINS Z=n_5489 A=n_5272 B=n_4805 VSS=VSS VDD=VDD
Xg119720 NAND2X1 $PINS Z=n_5488 A=n_5406 B=n_3473 VSS=VSS VDD=VDD
Xg119721 NAND2X1 $PINS Z=n_5487 A=n_5404 B=n_3455 VSS=VSS VDD=VDD
Xg119722 NAND3X1 $PINS Z=n_5486 A=n_3667 B=n_3743 C=n_196 VSS=VSS VDD=VDD
Xg119723 NAND3X1 $PINS Z=n_5485 A=n_4882 B=n_3445 C=n_81 VSS=VSS VDD=VDD
Xg119724 NAND3X1 $PINS Z=n_5484 A=n_5394 B=n_4745 C=n_5072 VSS=VSS VDD=VDD
Xg119725 NAND3X1 $PINS Z=n_5483 A=n_5398 B=n_4947 C=n_5103 VSS=VSS VDD=VDD
Xg119726 NAND3X1 $PINS Z=n_5482 A=n_5334 B=n_4811 C=n_3753 VSS=VSS VDD=VDD
Xg119727 NAND3X1 $PINS Z=n_5481 A=n_5389 B=n_3519 C=n_5065 VSS=VSS VDD=VDD
Xg119728 NAND3X1 $PINS Z=n_5480 A=n_5369 B=n_3569 C=n_5056 VSS=VSS VDD=VDD
Xg119729 NAND3X1 $PINS Z=n_5479 A=n_5342 B=n_4924 C=n_5104 VSS=VSS VDD=VDD
Xg119730 NAND3X1 $PINS Z=n_5478 A=n_5386 B=n_4879 C=n_5097 VSS=VSS VDD=VDD
Xg119731 NAND3X1 $PINS Z=n_5477 A=n_5317 B=n_4992 C=n_4748 VSS=VSS VDD=VDD
Xg119732 NAND3X1 $PINS Z=n_5476 A=n_5279 B=n_4928 C=n_4936 VSS=VSS VDD=VDD
Xg119733 NOR2X1 $PINS Z=n_5475 A=n_5331 B=n_5332 VSS=VSS VDD=VDD
Xg119734 NAND3X1 $PINS Z=n_5474 A=n_5396 B=n_5109 C=n_5085 VSS=VSS VDD=VDD
Xg119735 NAND3X1 $PINS Z=n_5473 A=n_5316 B=n_3657 C=n_5012 VSS=VSS VDD=VDD
Xg119736 NAND3X1 $PINS Z=n_5472 A=n_5357 B=n_4866 C=n_5077 VSS=VSS VDD=VDD
Xg119737 NAND3X1 $PINS Z=n_5471 A=n_5395 B=n_4705 C=n_5091 VSS=VSS VDD=VDD
Xg119738 NAND3X1 $PINS Z=n_5470 A=n_5339 B=n_3564 C=n_5102 VSS=VSS VDD=VDD
Xg119739 NAND3X1 $PINS Z=n_5469 A=n_3996 B=n_5013 C=n_4877 VSS=VSS VDD=VDD
Xg119740 NAND3X1 $PINS Z=n_5468 A=n_5378 B=n_3520 C=n_5075 VSS=VSS VDD=VDD
Xg119741 NAND3X1 $PINS Z=n_5467 A=n_4974 B=n_4920 C=n_4338 VSS=VSS VDD=VDD
Xg119742 NAND3X1 $PINS Z=n_5466 A=n_5294 B=n_3820 C=n_3752 VSS=VSS VDD=VDD
Xg119743 NAND3X1 $PINS Z=n_5465 A=n_5390 B=n_4738 C=n_5101 VSS=VSS VDD=VDD
Xg119744 NAND3X1 $PINS Z=n_5464 A=n_5385 B=n_4737 C=n_5093 VSS=VSS VDD=VDD
Xg119745 NAND3X1 $PINS Z=n_5463 A=n_4290 B=n_4899 C=n_3837 VSS=VSS VDD=VDD
Xg119746 NAND3X1 $PINS Z=n_5462 A=n_4802 B=n_3522 C=n_5024 VSS=VSS VDD=VDD
Xg119747 NAND3X1 $PINS Z=n_5461 A=n_5380 B=n_4750 C=n_5059 VSS=VSS VDD=VDD
Xg119748 NAND3X1 $PINS Z=n_5460 A=n_5379 B=n_4908 C=n_5080 VSS=VSS VDD=VDD
Xg119749 NAND3X1 $PINS Z=n_5459 A=n_5319 B=n_5123 C=n_4675 VSS=VSS VDD=VDD
Xg119750 NAND3X1 $PINS Z=n_5458 A=n_5328 B=n_5113 C=n_4950 VSS=VSS VDD=VDD
Xg119751 NAND3X1 $PINS Z=n_5457 A=n_5377 B=n_4960 C=n_5098 VSS=VSS VDD=VDD
Xg119752 NAND3X1 $PINS Z=n_5456 A=n_5122 B=n_4969 C=n_3603 VSS=VSS VDD=VDD
Xg119753 NAND3X1 $PINS Z=n_5455 A=n_5372 B=n_4901 C=n_5076 VSS=VSS VDD=VDD
Xg119754 NAND3X1 $PINS Z=n_5454 A=n_5118 B=n_3538 C=n_4674 VSS=VSS VDD=VDD
Xg119755 NAND3X1 $PINS Z=n_5453 A=n_5326 B=n_3719 C=n_4755 VSS=VSS VDD=VDD
Xg119756 NAND3X1 $PINS Z=n_5452 A=n_5281 B=n_4811 C=n_4859 VSS=VSS VDD=VDD
Xg119757 NAND3X1 $PINS Z=n_5451 A=n_5310 B=n_4801 C=n_4919 VSS=VSS VDD=VDD
Xg119758 NAND3X1 $PINS Z=n_5450 A=n_5388 B=n_4385 C=n_5064 VSS=VSS VDD=VDD
Xg119759 NAND3X1 $PINS Z=n_5449 A=n_5298 B=n_3812 C=n_4716 VSS=VSS VDD=VDD
Xg119760 NAND3X1 $PINS Z=n_5448 A=n_5381 B=n_4676 C=n_5073 VSS=VSS VDD=VDD
Xg119761 NAND3X1 $PINS Z=n_5447 A=n_5368 B=n_3585 C=n_5100 VSS=VSS VDD=VDD
Xg119762 NAND3X1 $PINS Z=n_5446 A=n_5393 B=n_4985 C=n_5062 VSS=VSS VDD=VDD
Xg119763 NAND3X1 $PINS Z=n_5445 A=n_5371 B=n_4994 C=n_5066 VSS=VSS VDD=VDD
Xg119764 NAND3X1 $PINS Z=n_5444 A=n_5341 B=n_4685 C=n_5042 VSS=VSS VDD=VDD
Xg119765 NAND3X1 $PINS Z=n_5443 A=n_5306 B=n_5123 C=n_4959 VSS=VSS VDD=VDD
Xg119766 NAND3X1 $PINS Z=n_5442 A=n_5362 B=n_3766 C=n_5053 VSS=VSS VDD=VDD
Xg119767 NAND3X1 $PINS Z=n_5441 A=n_5364 B=n_5032 C=n_5060 VSS=VSS VDD=VDD
Xg119768 NAND3X1 $PINS Z=n_5440 A=n_5384 B=n_5007 C=n_5089 VSS=VSS VDD=VDD
Xg119769 NAND3X1 $PINS Z=n_5439 A=n_5302 B=n_3870 C=n_3861 VSS=VSS VDD=VDD
Xg119770 NAND3X1 $PINS Z=n_5438 A=n_5325 B=n_5039 C=n_4909 VSS=VSS VDD=VDD
Xg119771 NAND3X1 $PINS Z=n_5437 A=n_5301 B=n_4955 C=n_4977 VSS=VSS VDD=VDD
Xg119772 NAND3X1 $PINS Z=n_5436 A=n_5337 B=n_4871 C=n_4774 VSS=VSS VDD=VDD
Xg119773 NAND3X1 $PINS Z=n_5435 A=n_5297 B=n_3756 C=n_5014 VSS=VSS VDD=VDD
Xg119774 NAND3X1 $PINS Z=n_5434 A=n_5359 B=n_4961 C=n_5051 VSS=VSS VDD=VDD
Xg119775 NAND3X1 $PINS Z=n_5433 A=n_5408 B=n_4910 C=n_3570 VSS=VSS VDD=VDD
Xg119776 NAND3X1 $PINS Z=n_5432 A=n_5296 B=n_5119 C=n_3879 VSS=VSS VDD=VDD
Xg119777 NAND3X1 $PINS Z=n_5431 A=n_3456 B=n_3773 C=n_4626 VSS=VSS VDD=VDD
Xg119778 NAND3X1 $PINS Z=n_5430 A=n_5295 B=n_3693 C=n_5002 VSS=VSS VDD=VDD
Xg119779 NOR2X1 $PINS Z=n_5429 A=n_5291 B=n_5292 VSS=VSS VDD=VDD
Xg119780 NAND3X1 $PINS Z=n_5428 A=n_5352 B=n_4765 C=n_5049 VSS=VSS VDD=VDD
Xg119781 NAND3X1 $PINS Z=n_5427 A=n_5340 B=n_4894 C=n_5084 VSS=VSS VDD=VDD
Xg119782 NAND3X1 $PINS Z=n_5426 A=n_5354 B=n_3580 C=n_5045 VSS=VSS VDD=VDD
Xg119783 NAND3X1 $PINS Z=n_5425 A=n_5290 B=n_4800 C=n_5126 VSS=VSS VDD=VDD
Xg119784 NAND3X1 $PINS Z=n_5424 A=n_5347 B=n_3598 C=n_5058 VSS=VSS VDD=VDD
Xg119785 NAND3X1 $PINS Z=n_5423 A=n_3584 B=n_3466 C=FE_DBTN1_csm_inst_mode
+ VSS=VSS VDD=VDD
Xg119786 NAND3X1 $PINS Z=n_5422 A=n_3608 B=n_4315 C=n_3596 VSS=VSS VDD=VDD
Xg119787 NAND3X1 $PINS Z=n_5421 A=n_5348 B=n_4878 C=n_5094 VSS=VSS VDD=VDD
Xg119788 NAND3X1 $PINS Z=n_5420 A=n_5327 B=n_4234 C=n_3435 VSS=VSS VDD=VDD
Xg119789 NOR2X1 $PINS Z=n_5419 A=n_5284 B=n_5285 VSS=VSS VDD=VDD
Xg119790 NAND3X1 $PINS Z=n_5418 A=n_4799 B=n_4680 C=n_4517 VSS=VSS VDD=VDD
Xg119791 NAND3X1 $PINS Z=n_5417 A=n_5282 B=n_3540 C=n_3542 VSS=VSS VDD=VDD
Xg119792 NAND3X1 $PINS Z=n_5622 A=n_5312 B=n_3425 C=n_3268 VSS=VSS VDD=VDD
Xg119793 NAND3X1 $PINS Z=n_5621 A=n_5116 B=n_5114 C=spi_inst_sclk_sync2 VSS=VSS
+ VDD=VDD
Xg119794 NAND3X1 $PINS Z=n_5620 A=n_5289 B=n_3175 C=n_2915 VSS=VSS VDD=VDD
Xg119795 NAND3X1 $PINS Z=n_5619 A=n_5315 B=n_2682 C=n_3260 VSS=VSS VDD=VDD
Xg119798 INVX2 $PINS Z=n_5413 A=n_5414 VSS=VSS VDD=VDD
Xg119806 INVX2 $PINS Z=n_136 A=n_137 VSS=VSS VDD=VDD
Xg119808 AND2X1 $PINS Z=n_5408 A=n_4887 B=n_3515 VSS=VSS VDD=VDD
Xg119809 NAND3X1 $PINS Z=n_5407 A=n_84 B=n_1033 C=n_57 VSS=VSS VDD=VDD
Xg119810 NAND2X1 $PINS Z=n_5406 A=n_3472 B=n_1162 VSS=VSS VDD=VDD
Xg119811 NOR2X1 $PINS Z=n_5405 A=spi_inst_cs_prev B=n_3272 VSS=VSS VDD=VDD
Xg119812 NAND2X1 $PINS Z=n_5404 A=n_3467 B=n_1162 VSS=VSS VDD=VDD
Xg119813 OR2X1 $PINS Z=n_5403 A=n_167 B=n_4796 VSS=VSS VDD=VDD
Xg119814 NAND2X1 $PINS Z=n_5402 A=n_4797 B=csm_inst_round_counter[1] VSS=VSS
+ VDD=VDD
Xg119815 NAND2X1 $PINS Z=n_5401 A=n_4791 B=csm_inst_right_reg[29] VSS=VSS
+ VDD=VDD
Xg119816 NAND2X1 $PINS Z=n_5400 A=n_4791 B=csm_inst_right_reg[7] VSS=VSS
+ VDD=VDD
Xg119817 NAND2X1 $PINS Z=n_5399 A=n_4791 B=csm_inst_right_reg[30] VSS=VSS
+ VDD=VDD
Xg119818 NAND2X1 $PINS Z=n_5398 A=n_4791 B=csm_inst_left_reg[23] VSS=VSS
+ VDD=VDD
Xg119819 NAND2X1 $PINS Z=n_5397 A=n_4791 B=csm_inst_right_reg[31] VSS=VSS
+ VDD=VDD
Xg119820 NAND2X1 $PINS Z=n_5396 A=n_4791 B=csm_inst_left_reg[25] VSS=VSS
+ VDD=VDD
Xg119821 NAND2X1 $PINS Z=n_5395 A=n_4791 B=csm_inst_left_reg[26] VSS=VSS
+ VDD=VDD
Xg119822 NAND2X1 $PINS Z=n_5394 A=n_4791 B=csm_inst_left_reg[2] VSS=VSS VDD=VDD
Xg119823 NAND2X1 $PINS Z=n_5393 A=n_4791 B=csm_inst_left_reg[11] VSS=VSS
+ VDD=VDD
Xg119824 NAND2X1 $PINS Z=n_5392 A=n_4791 B=csm_inst_right_reg[5] VSS=VSS
+ VDD=VDD
Xg119825 NAND2X1 $PINS Z=n_5391 A=n_4791 B=csm_inst_right_reg[6] VSS=VSS
+ VDD=VDD
Xg119826 NAND2X1 $PINS Z=n_5390 A=n_4791 B=csm_inst_left_reg[3] VSS=VSS VDD=VDD
Xg119827 NAND2X1 $PINS Z=n_5389 A=n_4791 B=csm_inst_left_reg[12] VSS=VSS
+ VDD=VDD
Xg119828 NAND2X1 $PINS Z=n_5388 A=n_4791 B=csm_inst_left_reg[5] VSS=VSS VDD=VDD
Xg119829 NAND2X1 $PINS Z=n_5387 A=n_4791 B=csm_inst_right_reg[1] VSS=VSS
+ VDD=VDD
Xg119830 NAND2X1 $PINS Z=n_5386 A=n_4791 B=csm_inst_left_reg[24] VSS=VSS
+ VDD=VDD
Xg119831 NAND2X1 $PINS Z=n_5385 A=n_4791 B=csm_inst_left_reg[31] VSS=VSS
+ VDD=VDD
Xg119832 NAND2X1 $PINS Z=n_5384 A=n_4791 B=csm_inst_left_reg[27] VSS=VSS
+ VDD=VDD
Xg119833 NAND2X1 $PINS Z=n_5383 A=n_4791 B=csm_inst_right_reg[3] VSS=VSS
+ VDD=VDD
Xg119834 NAND2X1 $PINS Z=n_5382 A=n_4791 B=csm_inst_right_reg[0] VSS=VSS
+ VDD=VDD
Xg119835 NAND2X1 $PINS Z=n_5381 A=n_4791 B=csm_inst_left_reg[16] VSS=VSS
+ VDD=VDD
Xg119836 NAND2X1 $PINS Z=n_5380 A=n_4791 B=csm_inst_left_reg[4] VSS=VSS VDD=VDD
Xg119837 NAND2X1 $PINS Z=n_5379 A=n_4791 B=csm_inst_left_reg[14] VSS=VSS
+ VDD=VDD
Xg119838 NAND2X1 $PINS Z=n_5378 A=n_4791 B=csm_inst_left_reg[28] VSS=VSS
+ VDD=VDD
Xg119839 NAND2X1 $PINS Z=n_5377 A=n_4791 B=csm_inst_left_reg[9] VSS=VSS VDD=VDD
Xg119840 NAND2X1 $PINS Z=n_5376 A=n_4791 B=csm_inst_right_reg[4] VSS=VSS
+ VDD=VDD
Xg119841 NAND2X1 $PINS Z=n_5375 A=n_4791 B=csm_inst_right_reg[8] VSS=VSS
+ VDD=VDD
Xg119842 NAND2X1 $PINS Z=n_5374 A=n_4791 B=csm_inst_right_reg[9] VSS=VSS
+ VDD=VDD
Xg119843 NAND2X1 $PINS Z=n_5373 A=n_4791 B=csm_inst_right_reg[2] VSS=VSS
+ VDD=VDD
Xg119844 NAND2X1 $PINS Z=n_5372 A=n_4791 B=csm_inst_left_reg[0] VSS=VSS VDD=VDD
Xg119845 NAND2X1 $PINS Z=n_5371 A=n_4791 B=csm_inst_left_reg[17] VSS=VSS
+ VDD=VDD
Xg119846 NAND2X1 $PINS Z=n_5370 A=n_4791 B=csm_inst_right_reg[10] VSS=VSS
+ VDD=VDD
Xg119847 NAND2X1 $PINS Z=n_5369 A=n_4791 B=csm_inst_left_reg[13] VSS=VSS
+ VDD=VDD
Xg119848 NAND2X1 $PINS Z=n_5368 A=n_4791 B=csm_inst_left_reg[30] VSS=VSS
+ VDD=VDD
Xg119849 OR2X1 $PINS Z=n_5367 A=data_reg[35] B=n_4791 VSS=VSS VDD=VDD
Xg119850 NAND2X1 $PINS Z=n_5366 A=n_4791 B=csm_inst_right_reg[12] VSS=VSS
+ VDD=VDD
Xg119851 NAND2X1 $PINS Z=n_5365 A=n_4791 B=csm_inst_right_reg[13] VSS=VSS
+ VDD=VDD
Xg119852 NAND2X1 $PINS Z=n_5364 A=n_4791 B=csm_inst_left_reg[18] VSS=VSS
+ VDD=VDD
Xg119853 NAND2X1 $PINS Z=n_5363 A=n_4791 B=csm_inst_right_reg[14] VSS=VSS
+ VDD=VDD
Xg119854 NAND2X1 $PINS Z=n_5362 A=n_4791 B=csm_inst_left_reg[6] VSS=VSS VDD=VDD
Xg119855 NAND2X1 $PINS Z=n_5361 A=n_4791 B=csm_inst_right_reg[15] VSS=VSS
+ VDD=VDD
Xg119856 NAND2X1 $PINS Z=n_5360 A=n_4791 B=csm_inst_right_reg[16] VSS=VSS
+ VDD=VDD
Xg119857 NAND2X1 $PINS Z=n_5359 A=n_4791 B=csm_inst_left_reg[19] VSS=VSS
+ VDD=VDD
Xg119858 NAND2X1 $PINS Z=n_5358 A=n_4791 B=csm_inst_right_reg[17] VSS=VSS
+ VDD=VDD
Xg119859 NAND2X1 $PINS Z=n_5357 A=n_4791 B=csm_inst_left_reg[10] VSS=VSS
+ VDD=VDD
Xg119860 NAND2X1 $PINS Z=n_5356 A=n_4791 B=csm_inst_right_reg[18] VSS=VSS
+ VDD=VDD
Xg119861 NAND2X1 $PINS Z=n_5355 A=n_4791 B=csm_inst_right_reg[19] VSS=VSS
+ VDD=VDD
Xg119862 NAND2X1 $PINS Z=n_5354 A=n_4791 B=csm_inst_left_reg[7] VSS=VSS VDD=VDD
Xg119863 NAND2X1 $PINS Z=n_5353 A=n_4791 B=csm_inst_right_reg[20] VSS=VSS
+ VDD=VDD
Xg119864 NAND2X1 $PINS Z=n_5352 A=n_4791 B=csm_inst_left_reg[20] VSS=VSS
+ VDD=VDD
Xg119865 NAND2X1 $PINS Z=n_5351 A=n_4791 B=csm_inst_right_reg[21] VSS=VSS
+ VDD=VDD
Xg119866 NAND2X1 $PINS Z=n_5350 A=n_4791 B=csm_inst_right_reg[22] VSS=VSS
+ VDD=VDD
Xg119867 NAND2X1 $PINS Z=n_5349 A=n_4791 B=csm_inst_right_reg[23] VSS=VSS
+ VDD=VDD
Xg119868 NAND2X1 $PINS Z=n_5348 A=n_4791 B=csm_inst_left_reg[21] VSS=VSS
+ VDD=VDD
Xg119869 NAND2X1 $PINS Z=n_5347 A=n_4791 B=csm_inst_left_reg[29] VSS=VSS
+ VDD=VDD
Xg119870 NAND2X1 $PINS Z=n_5346 A=n_4791 B=csm_inst_right_reg[24] VSS=VSS
+ VDD=VDD
Xg119871 NAND2X1 $PINS Z=n_5345 A=n_4791 B=csm_inst_right_reg[25] VSS=VSS
+ VDD=VDD
Xg119872 NAND2X1 $PINS Z=n_5344 A=n_4791 B=csm_inst_right_reg[26] VSS=VSS
+ VDD=VDD
Xg119873 NAND2X1 $PINS Z=n_5343 A=n_4791 B=csm_inst_right_reg[27] VSS=VSS
+ VDD=VDD
Xg119874 NAND2X1 $PINS Z=n_5342 A=n_4791 B=csm_inst_left_reg[22] VSS=VSS
+ VDD=VDD
Xg119875 NAND2X1 $PINS Z=n_5341 A=n_4791 B=csm_inst_left_reg[15] VSS=VSS
+ VDD=VDD
Xg119876 NAND2X1 $PINS Z=n_5340 A=n_4791 B=csm_inst_left_reg[8] VSS=VSS VDD=VDD
Xg119877 NAND2X1 $PINS Z=n_5339 A=n_4791 B=csm_inst_left_reg[1] VSS=VSS VDD=VDD
Xg119878 NAND2X1 $PINS Z=n_5338 A=n_4791 B=csm_inst_right_reg[28] VSS=VSS
+ VDD=VDD
Xg119879 AND2X1 $PINS Z=n_5337 A=n_4982 B=n_3587 VSS=VSS VDD=VDD
Xg119880 NAND2X1 $PINS Z=n_5336 A=n_4860 B=n_1027 VSS=VSS VDD=VDD
Xg119881 NAND2X1 $PINS Z=n_5335 A=n_4764 B=n_5030 VSS=VSS VDD=VDD
Xg119882 AND2X1 $PINS Z=n_5334 A=n_5005 B=n_4991 VSS=VSS VDD=VDD
Xg119883 NAND2X1 $PINS Z=n_5333 A=n_4792 B=n_3334 VSS=VSS VDD=VDD
Xg119884 NAND2X1 $PINS Z=n_5332 A=n_4971 B=n_4862 VSS=VSS VDD=VDD
Xg119885 NAND2X1 $PINS Z=n_5331 A=n_4970 B=n_4798 VSS=VSS VDD=VDD
Xg119886 NAND2X1 $PINS Z=n_5330 A=n_4875 B=n_3278 VSS=VSS VDD=VDD
Xg119887 NAND2X1 $PINS Z=n_5329 A=n_4948 B=n_1009 VSS=VSS VDD=VDD
Xg119888 AND2X1 $PINS Z=n_5328 A=n_4772 B=n_3808 VSS=VSS VDD=VDD
Xg119889 AND2X1 $PINS Z=n_5327 A=n_3687 B=n_4917 VSS=VSS VDD=VDD
Xg119890 AND2X1 $PINS Z=n_5326 A=n_4981 B=n_3524 VSS=VSS VDD=VDD
Xg119891 AND2X1 $PINS Z=n_5325 A=n_3513 B=n_3979 VSS=VSS VDD=VDD
Xg119892 NAND2X1 $PINS Z=n_5324 A=n_4792 B=n_3302 VSS=VSS VDD=VDD
Xg119893 AND2X1 $PINS Z=n_5323 A=n_3589 B=FE_DBTN1_csm_inst_mode VSS=VSS
+ VDD=VDD
Xg119894 NAND2X1 $PINS Z=n_5322 A=n_3946 B=n_3647 VSS=VSS VDD=VDD
Xg119895 NAND2X1 $PINS Z=n_5321 A=n_4781 B=n_5025 VSS=VSS VDD=VDD
Xg119896 NAND2X1 $PINS Z=n_5320 A=n_4967 B=n_4940 VSS=VSS VDD=VDD
Xg119897 AND2X1 $PINS Z=n_5319 A=n_3709 B=n_4704 VSS=VSS VDD=VDD
Xg119898 NAND2X1 $PINS Z=n_5318 A=n_5107 B=n_5106 VSS=VSS VDD=VDD
Xg119899 AND2X1 $PINS Z=n_5317 A=n_4742 B=n_4741 VSS=VSS VDD=VDD
Xg119900 AND2X1 $PINS Z=n_5316 A=n_5031 B=n_5027 VSS=VSS VDD=VDD
Xg119901 NAND3X1 $PINS Z=n_5315 A=n_2580 B=n_2785
+ C=FE_DBTN2_csm_inst_round_counter_0 VSS=VSS VDD=VDD
Xg119902 NAND2X1 $PINS Z=n_5314 A=n_3440 B=n_3464 VSS=VSS VDD=VDD
Xg119903 AND2X1 $PINS Z=n_5313 A=n_4805 B=n_1164 VSS=VSS VDD=VDD
Xg119904 NAND3X1 $PINS Z=n_5312 A=n_2580 B=n_931 C=n_57 VSS=VSS VDD=VDD
Xg119905 NAND2X1 $PINS Z=n_5311 A=n_4752 B=n_4720 VSS=VSS VDD=VDD
Xg119906 AND2X1 $PINS Z=n_5310 A=n_4889 B=n_4929 VSS=VSS VDD=VDD
Xg119907 NAND2X1 $PINS Z=n_5309 A=n_4794 B=n_1414 VSS=VSS VDD=VDD
Xg119908 NOR2X1 $PINS Z=n_5308 A=n_1160 B=n_4706 VSS=VSS VDD=VDD
Xg119909 NAND2X1 $PINS Z=n_5307 A=n_4794 B=n_2532 VSS=VSS VDD=VDD
Xg119910 AND2X1 $PINS Z=n_5306 A=n_5038 B=n_5033 VSS=VSS VDD=VDD
Xg119911 AND2X1 $PINS Z=n_5305 A=n_5028 B=n_4280 VSS=VSS VDD=VDD
Xg119912 AND2X1 $PINS Z=n_5304 A=n_4169 B=n_4204 VSS=VSS VDD=VDD
Xg119913 AND2X1 $PINS Z=n_5303 A=n_4988 B=n_5003 VSS=VSS VDD=VDD
Xg119914 AND2X1 $PINS Z=n_5302 A=n_3845 B=n_4870 VSS=VSS VDD=VDD
Xg119915 AND2X1 $PINS Z=n_5301 A=n_3791 B=n_3796 VSS=VSS VDD=VDD
Xg119916 NAND2X1 $PINS Z=n_5300 A=n_4792 B=n_3318 VSS=VSS VDD=VDD
Xg119917 NAND2X1 $PINS Z=n_5299 A=n_4792 B=n_3331 VSS=VSS VDD=VDD
Xg119918 AND2X1 $PINS Z=n_5298 A=n_3577 B=n_3525 VSS=VSS VDD=VDD
Xg119919 AND2X1 $PINS Z=n_5297 A=n_4945 B=n_4900 VSS=VSS VDD=VDD
Xg119920 AND2X1 $PINS Z=n_5296 A=n_3745 B=n_4907 VSS=VSS VDD=VDD
Xg119921 AND2X1 $PINS Z=n_5295 A=n_4990 B=n_4998 VSS=VSS VDD=VDD
Xg119922 AND2X1 $PINS Z=n_5294 A=n_4897 B=n_4771 VSS=VSS VDD=VDD
Xg119923 AND2X1 $PINS Z=n_5293 A=n_4803 B=n_4762 VSS=VSS VDD=VDD
Xg119924 NAND2X1 $PINS Z=n_5292 A=n_3559 B=n_3643 VSS=VSS VDD=VDD
Xg119925 NAND2X1 $PINS Z=n_5291 A=n_3629 B=n_3458 VSS=VSS VDD=VDD
Xg119926 AND2X1 $PINS Z=n_5290 A=n_4903 B=n_3622 VSS=VSS VDD=VDD
Xg119927 NAND3X1 $PINS Z=n_5289 A=n_893 B=n_969 C=n_57 VSS=VSS VDD=VDD
Xg119928 AND2X1 $PINS Z=n_5288 A=n_4980 B=n_3757 VSS=VSS VDD=VDD
Xg119929 OR2X1 $PINS Z=n_5287 A=spi_inst_cs_prev B=spi_inst_cs_sync2 VSS=VSS
+ VDD=VDD
Xg119930 NAND2X1 $PINS Z=n_5286 A=n_4792 B=n_3388 VSS=VSS VDD=VDD
Xg119931 NAND2X1 $PINS Z=n_5285 A=n_4939 B=n_4937 VSS=VSS VDD=VDD
Xg119932 NAND2X1 $PINS Z=n_5284 A=n_3539 B=n_5009 VSS=VSS VDD=VDD
Xg119933 NAND2X1 $PINS Z=n_5283 A=n_4957 B=n_1162 VSS=VSS VDD=VDD
Xg119934 AND2X1 $PINS Z=n_5282 A=n_4941 B=n_4943 VSS=VSS VDD=VDD
Xg119935 AND2X1 $PINS Z=n_5281 A=n_4294 B=n_4925 VSS=VSS VDD=VDD
Xg119936 NAND3X1 $PINS Z=n_5280 A=n_3266 B=n_2845 C=csm_inst_round_counter[3]
+ VSS=VSS VDD=VDD
Xg119937 AND2X1 $PINS Z=n_5279 A=n_3562 B=n_4949 VSS=VSS VDD=VDD
Xg119938 NAND2X1 $PINS Z=n_5278 A=n_4760 B=n_4751 VSS=VSS VDD=VDD
Xg119939 NAND2X1 $PINS Z=n_5277 A=n_4792 B=n_2080 VSS=VSS VDD=VDD
Xg119940 NAND2X1 $PINS Z=n_5276 A=n_4905 B=n_3714 VSS=VSS VDD=VDD
Xg119941 NAND2X1 $PINS Z=n_5275 A=n_5108 B=n_5110 VSS=VSS VDD=VDD
Xg119942 NAND2X1 $PINS Z=n_5274 A=n_4893 B=n_3441 VSS=VSS VDD=VDD
Xg119943 NAND2X1 $PINS Z=n_5273 A=n_3881 B=n_3278 VSS=VSS VDD=VDD
Xg119944 NAND2X1 $PINS Z=n_5272 A=n_3982 B=n_3278 VSS=VSS VDD=VDD
Xg119945 NAND3X1 $PINS Z=n_5271 A=n_4926 B=n_247 C=csm_inst_round_counter[3]
+ VSS=VSS VDD=VDD
Xg119946 NAND2X1 $PINS Z=n_5415 A=n_3578 B=n_3537 VSS=VSS VDD=VDD
Xg119949 NAND2X1 $PINS Z=n_5414 A=n_5117 B=spi_inst_bit_count[4] VSS=VSS
+ VDD=VDD
Xg119950 AND2X1 $PINS Z=n_137 A=n_3272 B=spi_inst_cs_prev VSS=VSS VDD=VDD
Xg119951 NOR2X1 $PINS Z=n_5409 A=n_4336 B=n_933 VSS=VSS VDD=VDD
Xg119952 MUX2X1 $PINS Z=n_5197 A=csm_inst_right_reg[14] B=des_output[10]
+ S=n_1009 VSS=VSS VDD=VDD
Xg119953 NAND3X1 $PINS Z=n_5196 A=n_4972 B=n_3425 C=n_914 VSS=VSS VDD=VDD
Xg119955 MUX2X1 $PINS Z=n_5194 A=csm_inst_left_reg[3] B=des_output[33] S=n_1009
+ VSS=VSS VDD=VDD
Xg119956 MUX2X1 $PINS Z=n_5193 A=csm_inst_right_reg[11] B=des_output[34]
+ S=n_1009 VSS=VSS VDD=VDD
Xg119957 MUX2X1 $PINS Z=n_5192 A=csm_inst_left_reg[8] B=des_output[59] S=n_1009
+ VSS=VSS VDD=VDD
Xg119958 MUX2X1 $PINS Z=n_5191 A=csm_inst_right_reg[27] B=des_output[38]
+ S=n_1009 VSS=VSS VDD=VDD
Xg119959 MUX2X1 $PINS Z=n_5190 A=csm_inst_left_reg[29] B=des_output[23]
+ S=n_1009 VSS=VSS VDD=VDD
Xg119960 MUX2X1 $PINS Z=n_5189 A=csm_inst_right_reg[2] B=des_output[40]
+ S=n_1009 VSS=VSS VDD=VDD
Xg119961 MUX2X1 $PINS Z=n_5188 A=csm_inst_left_reg[2] B=des_output[41] S=n_1009
+ VSS=VSS VDD=VDD
Xg119962 MUX2X1 $PINS Z=n_5187 A=csm_inst_left_reg[13] B=des_output[19]
+ S=n_1009 VSS=VSS VDD=VDD
Xg119963 MUX2X1 $PINS Z=n_5186 A=csm_inst_right_reg[18] B=des_output[44]
+ S=n_1009 VSS=VSS VDD=VDD
Xg119964 MUX2X1 $PINS Z=n_5185 A=csm_inst_right_reg[24] B=des_output[62]
+ S=n_1009 VSS=VSS VDD=VDD
Xg119965 MUX2X1 $PINS Z=n_5184 A=csm_inst_right_reg[28] B=des_output[30]
+ S=n_1009 VSS=VSS VDD=VDD
Xg119966 MUX2X1 $PINS Z=n_5183 A=csm_inst_right_reg[16] B=des_output[60]
+ S=n_1009 VSS=VSS VDD=VDD
Xg119967 MUX2X1 $PINS Z=n_5182 A=csm_inst_right_reg[1] B=des_output[48]
+ S=n_1009 VSS=VSS VDD=VDD
Xg119968 MUX2X1 $PINS Z=n_5181 A=csm_inst_left_reg[9] B=des_output[51] S=n_1009
+ VSS=VSS VDD=VDD
Xg119969 MUX2X1 $PINS Z=n_5180 A=csm_inst_right_reg[17] B=des_output[52]
+ S=n_1009 VSS=VSS VDD=VDD
Xg119970 MUX2X1 $PINS Z=n_5179 A=csm_inst_right_reg[25] B=des_output[54]
+ S=n_1009 VSS=VSS VDD=VDD
Xg119971 MUX2X1 $PINS Z=n_5178 A=csm_inst_left_reg[25] B=des_output[55]
+ S=n_1009 VSS=VSS VDD=VDD
Xg119972 MUX2X1 $PINS Z=n_5177 A=csm_inst_left_reg[0] B=des_output[57] S=n_1009
+ VSS=VSS VDD=VDD
Xg119973 MUX2X1 $PINS Z=n_5176 A=csm_inst_left_reg[18] B=des_output[45]
+ S=n_1009 VSS=VSS VDD=VDD
Xg119974 MUX2X1 $PINS Z=n_5175 A=csm_inst_left_reg[27] B=des_output[39]
+ S=n_1009 VSS=VSS VDD=VDD
Xg119975 MUX2X1 $PINS Z=n_5174 A=csm_inst_left_reg[11] B=des_output[35]
+ S=n_1009 VSS=VSS VDD=VDD
Xg119976 MUX2X1 $PINS Z=n_5173 A=csm_inst_left_reg[26] B=des_output[47]
+ S=n_1009 VSS=VSS VDD=VDD
Xg119977 MUX2X1 $PINS Z=n_5172 A=csm_inst_left_reg[12] B=des_output[27]
+ S=n_1009 VSS=VSS VDD=VDD
Xg119978 MUX2X1 $PINS Z=n_5171 A=csm_inst_right_reg[7] B=des_output[0] S=n_1009
+ VSS=VSS VDD=VDD
Xg119979 MUX2X1 $PINS Z=n_5170 A=csm_inst_right_reg[26] B=des_output[46]
+ S=n_1009 VSS=VSS VDD=VDD
Xg119980 MUX2X1 $PINS Z=n_5169 A=csm_inst_left_reg[23] B=des_output[5] S=n_1009
+ VSS=VSS VDD=VDD
Xg119981 MUX2X1 $PINS Z=n_5168 A=csm_inst_left_reg[31] B=des_output[7] S=n_1009
+ VSS=VSS VDD=VDD
Xg119982 MUX2X1 $PINS Z=n_5167 A=csm_inst_left_reg[10] B=des_output[43]
+ S=n_1009 VSS=VSS VDD=VDD
Xg119983 MUX2X1 $PINS Z=n_5166 A=csm_inst_right_reg[0] B=des_output[56]
+ S=n_1009 VSS=VSS VDD=VDD
Xg119984 MUX2X1 $PINS Z=n_5165 A=csm_inst_left_reg[1] B=des_output[49] S=n_1009
+ VSS=VSS VDD=VDD
Xg119985 MUX2X1 $PINS Z=n_5164 A=csm_inst_right_reg[19] B=des_output[36]
+ S=n_1009 VSS=VSS VDD=VDD
Xg119986 MUX2X1 $PINS Z=n_5163 A=csm_inst_left_reg[6] B=des_output[9] S=n_1009
+ VSS=VSS VDD=VDD
Xg119987 NAND3X1 $PINS Z=n_5162 A=n_84 B=n_1033 C=csm_inst_round_counter[3]
+ VSS=VSS VDD=VDD
Xg119988 MUX2X1 $PINS Z=n_5161 A=csm_inst_left_reg[14] B=des_output[11]
+ S=n_1009 VSS=VSS VDD=VDD
Xg119989 MUX2X1 $PINS Z=n_5160 A=csm_inst_left_reg[15] B=des_output[3] S=n_1009
+ VSS=VSS VDD=VDD
Xg119990 MUX2X1 $PINS Z=n_5159 A=csm_inst_right_reg[22] B=des_output[12]
+ S=n_1009 VSS=VSS VDD=VDD
Xg119991 MUX2X1 $PINS Z=n_5158 A=csm_inst_right_reg[31] B=des_output[6]
+ S=n_1009 VSS=VSS VDD=VDD
Xg119992 MUX2X1 $PINS Z=n_5157 A=csm_inst_left_reg[22] B=des_output[13]
+ S=n_1009 VSS=VSS VDD=VDD
Xg119993 MUX2X1 $PINS Z=n_5156 A=csm_inst_left_reg[24] B=des_output[63]
+ S=n_1009 VSS=VSS VDD=VDD
Xg119994 MUX2X1 $PINS Z=n_5155 A=csm_inst_right_reg[10] B=des_output[42]
+ S=n_1009 VSS=VSS VDD=VDD
Xg119995 MUX2X1 $PINS Z=n_5154 A=csm_inst_right_reg[23] B=des_output[4]
+ S=n_1009 VSS=VSS VDD=VDD
Xg119996 MUX2X1 $PINS Z=n_5153 A=csm_inst_right_reg[30] B=des_output[14]
+ S=n_1009 VSS=VSS VDD=VDD
Xg119997 MUX2X1 $PINS Z=n_5152 A=csm_inst_left_reg[30] B=des_output[15]
+ S=n_1009 VSS=VSS VDD=VDD
Xg119998 MUX2X1 $PINS Z=n_5151 A=csm_inst_right_reg[5] B=des_output[16]
+ S=n_1009 VSS=VSS VDD=VDD
Xg119999 MUX2X1 $PINS Z=n_5150 A=csm_inst_left_reg[5] B=des_output[17] S=n_1009
+ VSS=VSS VDD=VDD
Xg120000 MUX2X1 $PINS Z=n_5149 A=csm_inst_right_reg[13] B=des_output[18]
+ S=n_1009 VSS=VSS VDD=VDD
Xg120001 MUX2X1 $PINS Z=n_5148 A=csm_inst_right_reg[15] B=des_output[2]
+ S=n_1009 VSS=VSS VDD=VDD
Xg120002 MUX2X1 $PINS Z=n_5147 A=csm_inst_right_reg[21] B=des_output[20]
+ S=n_1009 VSS=VSS VDD=VDD
Xg120003 MUX2X1 $PINS Z=n_5146 A=csm_inst_left_reg[21] B=des_output[21]
+ S=n_1009 VSS=VSS VDD=VDD
Xg120004 MUX2X1 $PINS Z=n_5145 A=csm_inst_right_reg[8] B=des_output[58]
+ S=n_1009 VSS=VSS VDD=VDD
Xg120005 MUX2X1 $PINS Z=n_5144 A=csm_inst_right_reg[29] B=des_output[22]
+ S=n_1009 VSS=VSS VDD=VDD
Xg120006 MUX2X1 $PINS Z=n_5143 A=csm_inst_right_reg[4] B=des_output[24]
+ S=n_1009 VSS=VSS VDD=VDD
Xg120007 MUX2X1 $PINS Z=n_5142 A=csm_inst_left_reg[7] B=des_output[1] S=n_1009
+ VSS=VSS VDD=VDD
Xg120008 MUX2X1 $PINS Z=n_5141 A=csm_inst_left_reg[4] B=des_output[25] S=n_1009
+ VSS=VSS VDD=VDD
Xg120009 MUX2X1 $PINS Z=n_5140 A=csm_inst_left_reg[16] B=des_output[61]
+ S=n_1009 VSS=VSS VDD=VDD
Xg120010 MUX2X1 $PINS Z=n_5139 A=csm_inst_left_reg[17] B=des_output[53]
+ S=n_1009 VSS=VSS VDD=VDD
Xg120011 MUX2X1 $PINS Z=n_5138 A=csm_inst_right_reg[12] B=des_output[26]
+ S=n_1009 VSS=VSS VDD=VDD
Xg120012 MUX2X1 $PINS Z=n_5137 A=csm_inst_left_reg[19] B=des_output[37]
+ S=n_1009 VSS=VSS VDD=VDD
Xg120013 MUX2X1 $PINS Z=n_5136 A=csm_inst_right_reg[20] B=des_output[28]
+ S=n_1009 VSS=VSS VDD=VDD
Xg120014 MUX2X1 $PINS Z=n_5135 A=csm_inst_left_reg[20] B=des_output[29]
+ S=n_1009 VSS=VSS VDD=VDD
Xg120015 MUX2X1 $PINS Z=n_5134 A=csm_inst_right_reg[6] B=des_output[8] S=n_1009
+ VSS=VSS VDD=VDD
Xg120016 MUX2X1 $PINS Z=n_5133 A=csm_inst_right_reg[9] B=des_output[50]
+ S=n_1009 VSS=VSS VDD=VDD
Xg120017 MUX2X1 $PINS Z=n_5132 A=csm_inst_left_reg[28] B=des_output[31]
+ S=n_1009 VSS=VSS VDD=VDD
Xg120018 MUX2X1 $PINS Z=n_5131 A=csm_inst_right_reg[3] B=des_output[32]
+ S=n_1009 VSS=VSS VDD=VDD
Xg120019 MUX2X1 $PINS Z=n_5130 A=n_1293 B=n_3321
+ S=FE_DBTN2_csm_inst_round_counter_0 VSS=VSS VDD=VDD
Xg120020 MUX2X1 $PINS Z=n_5129 A=n_1258 B=n_1609 S=csm_inst_round_counter[0]
+ VSS=VSS VDD=VDD
Xg120021 MUX2X1 $PINS Z=n_5128 A=n_84 B=n_2125 S=csm_inst_round_counter[0]
+ VSS=VSS VDD=VDD
Xg120022 MUX2X1 $PINS Z=n_5127 A=n_1605 B=n_482 S=csm_inst_round_counter[0]
+ VSS=VSS VDD=VDD
Xg120023 MUX2X1 $PINS Z=n_5270 A=n_3403 B=n_3400 S=csm_inst_round_counter[0]
+ VSS=VSS VDD=VDD
Xg120024 NAND3X1 $PINS Z=n_5269 A=n_5035 B=n_3427 C=n_3263 VSS=VSS VDD=VDD
Xg120025 MUX2X1 $PINS Z=n_5268 A=n_1582 B=n_1579
+ S=FE_DBTN2_csm_inst_round_counter_0 VSS=VSS VDD=VDD
Xg120026 MUX2X1 $PINS Z=n_5267 A=n_3308 B=n_1417
+ S=FE_DBTN2_csm_inst_round_counter_0 VSS=VSS VDD=VDD
Xg120027 MUX2X1 $PINS Z=n_5266 A=n_3324 B=n_1242 S=csm_inst_round_counter[0]
+ VSS=VSS VDD=VDD
Xg120028 MUX2X1 $PINS Z=n_5265 A=n_1403 B=n_1338 S=csm_inst_round_counter[0]
+ VSS=VSS VDD=VDD
Xg120029 MUX2X1 $PINS Z=n_5264 A=n_1274 B=n_3321 S=csm_inst_round_counter[0]
+ VSS=VSS VDD=VDD
Xg120030 MUX2X1 $PINS Z=n_5263 A=n_2091 B=n_1375
+ S=FE_DBTN2_csm_inst_round_counter_0 VSS=VSS VDD=VDD
Xg120031 MUX2X1 $PINS Z=n_5262 A=n_3331 B=n_3310 S=csm_inst_round_counter[0]
+ VSS=VSS VDD=VDD
Xg120032 MUX2X1 $PINS Z=n_5261 A=n_1398 B=n_3333
+ S=FE_DBTN2_csm_inst_round_counter_0 VSS=VSS VDD=VDD
Xg120033 MUX2X1 $PINS Z=n_5260 A=n_2701 B=n_1260 S=csm_inst_round_counter[0]
+ VSS=VSS VDD=VDD
Xg120034 MUX2X1 $PINS Z=n_5259 A=n_2073 B=n_3309
+ S=FE_DBTN2_csm_inst_round_counter_0 VSS=VSS VDD=VDD
Xg120035 MUX2X1 $PINS Z=n_5258 A=n_1593 B=n_1555 S=csm_inst_round_counter[0]
+ VSS=VSS VDD=VDD
Xg120036 MUX2X1 $PINS Z=n_5257 A=n_1293 B=n_2675 S=csm_inst_round_counter[0]
+ VSS=VSS VDD=VDD
Xg120037 MUX2X1 $PINS Z=n_5256 A=n_1276 B=n_1350 S=csm_inst_round_counter[0]
+ VSS=VSS VDD=VDD
Xg120038 MUX2X1 $PINS Z=n_5255 A=n_3413 B=n_1847 S=csm_inst_round_counter[0]
+ VSS=VSS VDD=VDD
Xg120039 MUX2X1 $PINS Z=n_5254 A=n_1582 B=n_3329 S=csm_inst_round_counter[0]
+ VSS=VSS VDD=VDD
Xg120040 NAND3X1 $PINS Z=n_5253 A=n_4789 B=n_3269 C=n_1004 VSS=VSS VDD=VDD
Xg120041 MUX2X1 $PINS Z=n_5252 A=n_1417 B=n_3417
+ S=FE_DBTN2_csm_inst_round_counter_0 VSS=VSS VDD=VDD
Xg120042 MUX2X1 $PINS Z=n_5251 A=n_1421 B=n_3386
+ S=FE_DBTN2_csm_inst_round_counter_0 VSS=VSS VDD=VDD
Xg120043 MUX2X1 $PINS Z=n_5250 A=n_1390 B=n_1300
+ S=FE_DBTN2_csm_inst_round_counter_0 VSS=VSS VDD=VDD
Xg120044 MUX2X1 $PINS Z=n_5249 A=n_1366 B=n_1572
+ S=FE_DBTN2_csm_inst_round_counter_0 VSS=VSS VDD=VDD
Xg120045 MUX2X1 $PINS Z=n_5248 A=n_3392 B=n_1597
+ S=FE_DBTN2_csm_inst_round_counter_0 VSS=VSS VDD=VDD
Xg120046 MUX2X1 $PINS Z=n_5247 A=n_1385 B=n_1318
+ S=FE_DBTN2_csm_inst_round_counter_0 VSS=VSS VDD=VDD
Xg120047 MUX2X1 $PINS Z=n_5246 A=n_1838 B=n_3316
+ S=FE_DBTN2_csm_inst_round_counter_0 VSS=VSS VDD=VDD
Xg120048 MUX2X1 $PINS Z=n_5245 A=n_1576 B=n_1419
+ S=FE_DBTN2_csm_inst_round_counter_0 VSS=VSS VDD=VDD
Xg120049 MUX2X1 $PINS Z=n_5244 A=n_2377 B=n_1688
+ S=FE_DBTN2_csm_inst_round_counter_0 VSS=VSS VDD=VDD
Xg120050 MUX2X1 $PINS Z=n_5243 A=n_1289 B=n_1227 S=csm_inst_round_counter[0]
+ VSS=VSS VDD=VDD
Xg120051 MUX2X1 $PINS Z=n_5242 A=n_3402 B=n_1218
+ S=FE_DBTN2_csm_inst_round_counter_0 VSS=VSS VDD=VDD
Xg120052 MUX2X1 $PINS Z=n_5241 A=n_1597 B=n_3405
+ S=FE_DBTN2_csm_inst_round_counter_0 VSS=VSS VDD=VDD
Xg120053 MUX2X1 $PINS Z=n_5240 A=n_3304 B=n_1983
+ S=FE_DBTN2_csm_inst_round_counter_0 VSS=VSS VDD=VDD
Xg120054 MUX2X1 $PINS Z=n_5239 A=n_3408 B=n_2511 S=csm_inst_round_counter[0]
+ VSS=VSS VDD=VDD
Xg120055 MUX2X1 $PINS Z=n_5238 A=n_1393 B=n_3332
+ S=FE_DBTN2_csm_inst_round_counter_0 VSS=VSS VDD=VDD
Xg120056 MUX2X1 $PINS Z=n_5237 A=n_1607 B=n_3308
+ S=FE_DBTN2_csm_inst_round_counter_0 VSS=VSS VDD=VDD
Xg120057 MUX2X1 $PINS Z=n_5236 A=n_1276 B=n_3330
+ S=FE_DBTN2_csm_inst_round_counter_0 VSS=VSS VDD=VDD
Xg120058 MUX2X1 $PINS Z=n_5235 A=n_1394 B=n_3311 S=csm_inst_round_counter[0]
+ VSS=VSS VDD=VDD
Xg120059 MUX2X1 $PINS Z=n_5234 A=n_1413 B=n_2230 S=csm_inst_round_counter[0]
+ VSS=VSS VDD=VDD
Xg120060 MUX2X1 $PINS Z=n_5233 A=n_3359 B=n_3393
+ S=FE_DBTN2_csm_inst_round_counter_0 VSS=VSS VDD=VDD
Xg120061 MUX2X1 $PINS Z=n_5232 A=n_1982 B=n_2080
+ S=FE_DBTN2_csm_inst_round_counter_0 VSS=VSS VDD=VDD
Xg120062 MUX2X1 $PINS Z=n_5231 A=n_1306 B=n_3417 S=csm_inst_round_counter[0]
+ VSS=VSS VDD=VDD
Xg120063 MUX2X1 $PINS Z=n_5230 A=n_2230 B=n_3330 S=csm_inst_round_counter[0]
+ VSS=VSS VDD=VDD
Xg120064 MUX2X1 $PINS Z=n_5229 A=n_3319 B=n_3382 S=csm_inst_round_counter[0]
+ VSS=VSS VDD=VDD
Xg120065 MUX2X1 $PINS Z=n_5228 A=n_1576 B=n_3319 S=csm_inst_round_counter[0]
+ VSS=VSS VDD=VDD
Xg120066 MUX2X1 $PINS Z=n_5227 A=n_1790 B=n_2113 S=csm_inst_round_counter[0]
+ VSS=VSS VDD=VDD
Xg120067 MUX2X1 $PINS Z=n_5226 A=n_1569 B=n_1289 S=csm_inst_round_counter[0]
+ VSS=VSS VDD=VDD
Xg120068 MUX2X1 $PINS Z=n_5225 A=n_1233 B=n_2028 S=csm_inst_round_counter[0]
+ VSS=VSS VDD=VDD
Xg120069 MUX2X1 $PINS Z=n_5224 A=n_1886 B=n_1328 S=csm_inst_round_counter[0]
+ VSS=VSS VDD=VDD
Xg120070 MUX2X1 $PINS Z=n_5223 A=n_1983 B=n_1319
+ S=FE_DBTN2_csm_inst_round_counter_0 VSS=VSS VDD=VDD
Xg120071 MUX2X1 $PINS Z=n_5222 A=n_1838 B=n_1569 S=csm_inst_round_counter[0]
+ VSS=VSS VDD=VDD
Xg120072 MUX2X1 $PINS Z=n_5221 A=n_1410 B=n_3335
+ S=FE_DBTN2_csm_inst_round_counter_0 VSS=VSS VDD=VDD
Xg120073 MUX2X1 $PINS Z=n_5220 A=n_3329 B=n_1300 S=csm_inst_round_counter[0]
+ VSS=VSS VDD=VDD
Xg120074 MUX2X1 $PINS Z=n_5219 A=n_1422 B=n_1444 S=csm_inst_round_counter[0]
+ VSS=VSS VDD=VDD
Xg120075 MUX2X1 $PINS Z=n_5218 A=n_3382 B=n_1409 S=csm_inst_round_counter[0]
+ VSS=VSS VDD=VDD
Xg120076 MUX2X1 $PINS Z=n_5217 A=n_2073 B=n_1593 S=csm_inst_round_counter[0]
+ VSS=VSS VDD=VDD
Xg120077 MUX2X1 $PINS Z=n_5216 A=n_3328 B=n_2028
+ S=FE_DBTN2_csm_inst_round_counter_0 VSS=VSS VDD=VDD
Xg120078 MUX2X1 $PINS Z=n_5215 A=n_1233 B=n_3304
+ S=FE_DBTN2_csm_inst_round_counter_0 VSS=VSS VDD=VDD
Xg120079 MUX2X1 $PINS Z=n_5214 A=n_2060 B=n_2084
+ S=FE_DBTN2_csm_inst_round_counter_0 VSS=VSS VDD=VDD
Xg120080 MUX2X1 $PINS Z=n_5213 A=n_1227 B=n_1419 S=csm_inst_round_counter[0]
+ VSS=VSS VDD=VDD
Xg120081 MUX2X1 $PINS Z=n_5212 A=n_3391 B=n_3303
+ S=FE_DBTN2_csm_inst_round_counter_0 VSS=VSS VDD=VDD
Xg120082 MUX2X1 $PINS Z=n_5211 A=n_3315 B=n_1607
+ S=FE_DBTN2_csm_inst_round_counter_0 VSS=VSS VDD=VDD
Xg120083 MUX2X1 $PINS Z=n_5210 A=n_3387 B=n_2140 S=csm_inst_round_counter[0]
+ VSS=VSS VDD=VDD
Xg120084 MUX2X1 $PINS Z=n_5209 A=n_2578 B=n_3392
+ S=FE_DBTN2_csm_inst_round_counter_0 VSS=VSS VDD=VDD
Xg120085 MUX2X1 $PINS Z=n_5208 A=n_1847 B=n_1295 S=csm_inst_round_counter[0]
+ VSS=VSS VDD=VDD
Xg120086 MUX2X1 $PINS Z=n_5207 A=n_1269 B=n_3408 S=csm_inst_round_counter[0]
+ VSS=VSS VDD=VDD
Xg120087 MUX2X1 $PINS Z=n_5206 A=n_1456 B=n_1982
+ S=FE_DBTN2_csm_inst_round_counter_0 VSS=VSS VDD=VDD
Xg120088 MUX2X1 $PINS Z=n_5205 A=n_1693 B=n_2259
+ S=FE_DBTN2_csm_inst_round_counter_0 VSS=VSS VDD=VDD
Xg120089 MUX2X1 $PINS Z=n_5204 A=n_3327 B=n_3385
+ S=FE_DBTN2_csm_inst_round_counter_0 VSS=VSS VDD=VDD
Xg120090 MUX2X1 $PINS Z=n_5203 A=n_1614 B=n_3416 S=csm_inst_round_counter[0]
+ VSS=VSS VDD=VDD
Xg120091 MUX2X1 $PINS Z=n_5202 A=n_1704 B=n_3385 S=csm_inst_round_counter[0]
+ VSS=VSS VDD=VDD
Xg120092 MUX2X1 $PINS Z=n_5201 A=n_3318 B=n_1614 S=csm_inst_round_counter[0]
+ VSS=VSS VDD=VDD
Xg120093 MUX2X1 $PINS Z=n_5200 A=n_1886 B=n_1208
+ S=FE_DBTN2_csm_inst_round_counter_0 VSS=VSS VDD=VDD
Xg120094 NAND3X1 $PINS Z=n_5199 A=n_4914 B=n_940 C=n_2858 VSS=VSS VDD=VDD
Xg120095 MUX2X1 $PINS Z=n_5198 A=n_1421 B=n_3335 S=csm_inst_round_counter[0]
+ VSS=VSS VDD=VDD
Xg120096 INVX2 $PINS Z=n_5116 A=n_5115 VSS=VSS VDD=VDD
Xg120097 INVX2 $PINS Z=n_5114 A=spi_inst_sclk_prev VSS=VSS VDD=VDD
Xg120098 NAND2X1 $PINS Z=n_5112 A=n_1027 B=n_1456 VSS=VSS VDD=VDD
Xg120099 NAND2X1 $PINS Z=n_5111 A=n_106 B=n_1751 VSS=VSS VDD=VDD
Xg120100 OR2X1 $PINS Z=n_5110 A=csm_inst_mode B=n_2563 VSS=VSS VDD=VDD
Xg120101 NAND2X1 $PINS Z=n_5109 A=n_84 B=csm_inst_right_reg[25] VSS=VSS VDD=VDD
Xg120102 NAND2X1 $PINS Z=n_5108 A=n_3288 B=done_encrypt VSS=VSS VDD=VDD
Xg120103 NAND2X1 $PINS Z=n_5107 A=n_3288 B=done_decrypt VSS=VSS VDD=VDD
Xg120104 OR2X1 $PINS Z=n_5106 A=FE_DBTN1_csm_inst_mode B=n_2563 VSS=VSS VDD=VDD
Xg120105 NAND2X1 $PINS Z=n_5105 A=n_90 B=data_reg[23] VSS=VSS VDD=VDD
Xg120106 NAND2X1 $PINS Z=n_5104 A=n_90 B=data_reg[12] VSS=VSS VDD=VDD
Xg120107 NAND2X1 $PINS Z=n_5103 A=n_90 B=data_reg[4] VSS=VSS VDD=VDD
Xg120108 NAND2X1 $PINS Z=n_5102 A=n_90 B=data_reg[48] VSS=VSS VDD=VDD
Xg120109 NAND2X1 $PINS Z=n_5101 A=n_90 B=data_reg[32] VSS=VSS VDD=VDD
Xg120110 NAND2X1 $PINS Z=n_5100 A=n_90 B=data_reg[14] VSS=VSS VDD=VDD
Xg120111 NAND2X1 $PINS Z=n_5099 A=n_90 B=data_reg[25] VSS=VSS VDD=VDD
Xg120112 NAND2X1 $PINS Z=n_5098 A=n_90 B=data_reg[50] VSS=VSS VDD=VDD
Xg120113 NAND2X1 $PINS Z=n_5097 A=n_90 B=data_reg[62] VSS=VSS VDD=VDD
Xg120114 NAND2X1 $PINS Z=n_5096 A=n_90 B=data_reg[47] VSS=VSS VDD=VDD
Xg120115 NAND2X1 $PINS Z=n_5095 A=n_90 B=data_reg[31] VSS=VSS VDD=VDD
Xg120116 NAND2X1 $PINS Z=n_5094 A=n_90 B=data_reg[20] VSS=VSS VDD=VDD
Xg120117 NAND2X1 $PINS Z=n_5093 A=n_90 B=data_reg[6] VSS=VSS VDD=VDD
Xg120118 NAND2X1 $PINS Z=n_5092 A=n_90 B=data_reg[9] VSS=VSS VDD=VDD
Xg120119 NAND2X1 $PINS Z=n_5091 A=n_90 B=data_reg[46] VSS=VSS VDD=VDD
Xg120120 NAND2X1 $PINS Z=n_5090 A=n_90 B=data_reg[55] VSS=VSS VDD=VDD
Xg120121 NAND2X1 $PINS Z=n_5089 A=n_90 B=data_reg[38] VSS=VSS VDD=VDD
Xg120122 NAND2X1 $PINS Z=n_5088 A=n_90 B=data_reg[15] VSS=VSS VDD=VDD
Xg120123 NAND2X1 $PINS Z=n_5087 A=n_90 B=data_reg[11] VSS=VSS VDD=VDD
Xg120124 NAND2X1 $PINS Z=n_5086 A=n_90 B=data_reg[7] VSS=VSS VDD=VDD
Xg120125 NAND2X1 $PINS Z=n_5085 A=n_90 B=data_reg[54] VSS=VSS VDD=VDD
Xg120126 NAND2X1 $PINS Z=n_5084 A=n_90 B=data_reg[58] VSS=VSS VDD=VDD
Xg120127 NAND2X1 $PINS Z=n_5083 A=n_90 B=data_reg[49] VSS=VSS VDD=VDD
Xg120128 NAND2X1 $PINS Z=n_5082 A=n_90 B=data_reg[57] VSS=VSS VDD=VDD
Xg120129 NAND2X1 $PINS Z=n_5081 A=n_90 B=data_reg[17] VSS=VSS VDD=VDD
Xg120130 NAND2X1 $PINS Z=n_5080 A=n_90 B=data_reg[10] VSS=VSS VDD=VDD
Xg120131 NAND2X1 $PINS Z=n_5079 A=n_90 B=data_reg[1] VSS=VSS VDD=VDD
Xg120132 NAND2X1 $PINS Z=n_5078 A=n_90 B=data_reg[21] VSS=VSS VDD=VDD
Xg120133 NAND2X1 $PINS Z=n_5077 A=n_90 B=data_reg[42] VSS=VSS VDD=VDD
Xg120134 NAND2X1 $PINS Z=n_5076 A=n_90 B=data_reg[56] VSS=VSS VDD=VDD
Xg120135 NAND2X1 $PINS Z=n_5075 A=n_90 B=data_reg[30] VSS=VSS VDD=VDD
Xg120136 NAND2X1 $PINS Z=n_5074 A=n_90 B=data_reg[59] VSS=VSS VDD=VDD
Xg120137 NAND2X1 $PINS Z=n_5073 A=n_90 B=data_reg[60] VSS=VSS VDD=VDD
Xg120138 NAND2X1 $PINS Z=n_5072 A=n_90 B=data_reg[40] VSS=VSS VDD=VDD
Xg120139 NAND2X1 $PINS Z=n_5071 A=n_90 B=data_reg[51] VSS=VSS VDD=VDD
Xg120140 NAND2X1 $PINS Z=n_5070 A=n_90 B=data_reg[41] VSS=VSS VDD=VDD
Xg120141 NAND2X1 $PINS Z=n_5069 A=n_90 B=data_reg[43] VSS=VSS VDD=VDD
Xg120142 OR2X1 $PINS Z=n_5068 A=csm_inst_right_reg[11] B=n_90 VSS=VSS VDD=VDD
Xg120143 NAND2X1 $PINS Z=n_5067 A=n_90 B=data_reg[27] VSS=VSS VDD=VDD
Xg120144 NAND2X1 $PINS Z=n_5066 A=n_90 B=data_reg[52] VSS=VSS VDD=VDD
Xg120145 NAND2X1 $PINS Z=n_5065 A=n_90 B=data_reg[26] VSS=VSS VDD=VDD
Xg120146 NAND2X1 $PINS Z=n_5064 A=n_90 B=data_reg[16] VSS=VSS VDD=VDD
Xg120147 NAND2X1 $PINS Z=n_5063 A=n_90 B=data_reg[19] VSS=VSS VDD=VDD
Xg120148 NAND2X1 $PINS Z=n_5062 A=n_90 B=data_reg[34] VSS=VSS VDD=VDD
Xg120149 NAND2X1 $PINS Z=n_5061 A=n_90 B=data_reg[3] VSS=VSS VDD=VDD
Xg120150 NAND2X1 $PINS Z=n_5060 A=n_90 B=data_reg[44] VSS=VSS VDD=VDD
Xg120151 NAND2X1 $PINS Z=n_5059 A=n_90 B=data_reg[24] VSS=VSS VDD=VDD
Xg120152 NAND2X1 $PINS Z=n_5058 A=n_90 B=data_reg[22] VSS=VSS VDD=VDD
Xg120153 NAND2X1 $PINS Z=n_5057 A=n_90 B=data_reg[61] VSS=VSS VDD=VDD
Xg120154 NAND2X1 $PINS Z=n_5056 A=n_90 B=data_reg[18] VSS=VSS VDD=VDD
Xg120155 NAND2X1 $PINS Z=n_5055 A=n_90 B=data_reg[53] VSS=VSS VDD=VDD
Xg120156 NAND2X1 $PINS Z=n_5054 A=n_90 B=data_reg[45] VSS=VSS VDD=VDD
Xg120157 NAND2X1 $PINS Z=n_5053 A=n_90 B=data_reg[8] VSS=VSS VDD=VDD
Xg120158 NAND2X1 $PINS Z=n_5052 A=n_90 B=data_reg[37] VSS=VSS VDD=VDD
Xg120159 NAND2X1 $PINS Z=n_5051 A=n_90 B=data_reg[36] VSS=VSS VDD=VDD
Xg120160 NAND2X1 $PINS Z=n_5050 A=n_90 B=data_reg[29] VSS=VSS VDD=VDD
Xg120161 NAND2X1 $PINS Z=n_5049 A=n_90 B=data_reg[28] VSS=VSS VDD=VDD
Xg120162 NAND2X1 $PINS Z=n_5048 A=n_90 B=data_reg[13] VSS=VSS VDD=VDD
Xg120163 NAND2X1 $PINS Z=n_5047 A=n_90 B=data_reg[33] VSS=VSS VDD=VDD
Xg120164 NAND2X1 $PINS Z=n_5046 A=n_90 B=data_reg[5] VSS=VSS VDD=VDD
Xg120165 NAND2X1 $PINS Z=n_5045 A=n_90 B=data_reg[0] VSS=VSS VDD=VDD
Xg120166 NAND2X1 $PINS Z=n_5044 A=n_90 B=data_reg[63] VSS=VSS VDD=VDD
Xg120167 NAND2X1 $PINS Z=n_5043 A=n_90 B=data_reg[39] VSS=VSS VDD=VDD
Xg120168 NAND2X1 $PINS Z=n_5042 A=n_90 B=data_reg[2] VSS=VSS VDD=VDD
Xg120169 NAND2X1 $PINS Z=n_5041 A=n_1033 B=n_3388 VSS=VSS VDD=VDD
Xg120170 NAND2X1 $PINS Z=n_5040 A=n_1409 B=n_472 VSS=VSS VDD=VDD
Xg120171 NAND2X1 $PINS Z=n_5039 A=n_1385 B=n_1163 VSS=VSS VDD=VDD
Xg120172 NAND2X1 $PINS Z=n_5038 A=n_1027 B=n_2113 VSS=VSS VDD=VDD
Xg120173 NAND2X1 $PINS Z=n_5037 A=n_2511 B=n_1024 VSS=VSS VDD=VDD
Xg120174 NAND2X1 $PINS Z=n_5036 A=n_106 B=n_3323 VSS=VSS VDD=VDD
Xg120175 AND2X1 $PINS Z=n_5035 A=n_2790 B=n_2788 VSS=VSS VDD=VDD
Xg120176 NAND2X1 $PINS Z=n_5034 A=n_1024 B=n_2073 VSS=VSS VDD=VDD
Xg120177 NAND2X1 $PINS Z=n_5033 A=n_1156 B=n_1328 VSS=VSS VDD=VDD
Xg120178 NAND2X1 $PINS Z=n_5032 A=n_84 B=csm_inst_right_reg[18] VSS=VSS VDD=VDD
Xg120179 NAND2X1 $PINS Z=n_5031 A=n_3271 B=n_1319 VSS=VSS VDD=VDD
Xg120180 OR2X1 $PINS Z=n_5030 A=n_1605 B=n_101 VSS=VSS VDD=VDD
Xg120181 NAND2X1 $PINS Z=n_5029 A=n_3387 B=n_473 VSS=VSS VDD=VDD
Xg120182 NAND2X1 $PINS Z=n_5028 A=n_2377 B=n_190 VSS=VSS VDD=VDD
Xg120183 NAND2X1 $PINS Z=n_5027 A=n_1163 B=n_1393 VSS=VSS VDD=VDD
Xg120184 NAND2X1 $PINS Z=n_5026 A=n_116 B=n_1593 VSS=VSS VDD=VDD
Xg120185 NAND2X1 $PINS Z=n_5025 A=n_1027 B=n_1390 VSS=VSS VDD=VDD
Xg120186 NAND2X1 $PINS Z=n_5024 A=n_1027 B=n_3311 VSS=VSS VDD=VDD
Xg120187 NAND2X1 $PINS Z=n_5023 A=n_1027 B=n_2259 VSS=VSS VDD=VDD
Xg120188 NAND2X1 $PINS Z=n_5022 A=n_116 B=n_1295 VSS=VSS VDD=VDD
Xg120189 NAND2X1 $PINS Z=n_5021 A=n_1126 B=n_2701 VSS=VSS VDD=VDD
Xg120190 NAND2X1 $PINS Z=n_5020 A=n_120 B=n_1673 VSS=VSS VDD=VDD
Xg120191 NAND2X1 $PINS Z=n_5019 A=n_121 B=n_3326 VSS=VSS VDD=VDD
Xg120192 NAND2X1 $PINS Z=n_5018 A=n_1126 B=n_3385 VSS=VSS VDD=VDD
Xg120193 NAND2X1 $PINS Z=n_5017 A=n_116 B=n_3330 VSS=VSS VDD=VDD
Xg120195 NAND2X1 $PINS Z=n_5015 A=n_1033 B=n_1751 VSS=VSS VDD=VDD
Xg120196 NAND2X1 $PINS Z=n_5014 A=n_1024 B=n_1393 VSS=VSS VDD=VDD
Xg120197 NAND2X1 $PINS Z=n_5013 A=n_3309 B=n_3271 VSS=VSS VDD=VDD
Xg120198 NAND2X1 $PINS Z=n_5012 A=n_1027 B=n_1233 VSS=VSS VDD=VDD
Xg120199 OR2X1 $PINS Z=n_5011 A=n_472 B=n_1242 VSS=VSS VDD=VDD
Xg120200 OR2X1 $PINS Z=n_5010 A=n_3416 B=n_120 VSS=VSS VDD=VDD
Xg120201 NAND2X1 $PINS Z=n_5009 A=n_121 B=n_1678 VSS=VSS VDD=VDD
Xg120202 NAND2X1 $PINS Z=n_5008 A=n_1024 B=n_3327 VSS=VSS VDD=VDD
Xg120203 NAND2X1 $PINS Z=n_5007 A=n_84 B=csm_inst_right_reg[27] VSS=VSS VDD=VDD
Xg120204 NAND2X1 $PINS Z=n_5006 A=n_1024 B=n_3400 VSS=VSS VDD=VDD
Xg120205 NAND2X1 $PINS Z=n_5005 A=n_1027 B=n_1982 VSS=VSS VDD=VDD
Xg120206 NAND2X1 $PINS Z=n_5004 A=n_1149 B=n_3321 VSS=VSS VDD=VDD
Xg120207 NAND2X1 $PINS Z=n_5003 A=n_1587 B=n_190 VSS=VSS VDD=VDD
Xg120208 NAND2X1 $PINS Z=n_5002 A=n_117 B=n_1276 VSS=VSS VDD=VDD
Xg120209 NAND2X1 $PINS Z=n_5001 A=n_117 B=n_3333 VSS=VSS VDD=VDD
Xg120210 NAND2X1 $PINS Z=n_5000 A=n_106 B=n_1591 VSS=VSS VDD=VDD
Xg120211 NAND2X1 $PINS Z=n_4999 A=n_1033 B=n_2128 VSS=VSS VDD=VDD
Xg120212 NAND2X1 $PINS Z=n_4998 A=n_121 B=n_2691 VSS=VSS VDD=VDD
Xg120213 OR2X1 $PINS Z=n_4997 A=n_1417 B=n_121 VSS=VSS VDD=VDD
Xg120214 NAND2X1 $PINS Z=n_4996 A=n_106 B=n_1578 VSS=VSS VDD=VDD
Xg120215 OR2X1 $PINS Z=n_4995 A=n_1204 B=n_3315 VSS=VSS VDD=VDD
Xg120216 NAND2X1 $PINS Z=n_4994 A=n_84 B=csm_inst_right_reg[17] VSS=VSS VDD=VDD
Xg120217 NAND2X1 $PINS Z=n_4993 A=n_121 B=n_1578 VSS=VSS VDD=VDD
Xg120218 NAND2X1 $PINS Z=n_4992 A=n_1300 B=n_1024 VSS=VSS VDD=VDD
Xg120219 NAND2X1 $PINS Z=n_4991 A=n_106 B=n_3348 VSS=VSS VDD=VDD
Xg120220 NAND2X1 $PINS Z=n_4990 A=n_116 B=n_1886 VSS=VSS VDD=VDD
Xg120221 NAND2X1 $PINS Z=n_4989 A=n_117 B=n_3402 VSS=VSS VDD=VDD
Xg120222 NAND2X1 $PINS Z=n_4988 A=n_1576 B=n_476 VSS=VSS VDD=VDD
Xg120223 NAND2X1 $PINS Z=n_4987 A=n_3326 B=n_1108 VSS=VSS VDD=VDD
Xg120224 OR2X1 $PINS Z=n_4986 A=n_3348 B=n_116 VSS=VSS VDD=VDD
Xg120225 NAND2X1 $PINS Z=n_4985 A=n_84 B=csm_inst_right_reg[11] VSS=VSS VDD=VDD
Xg120226 NAND2X1 $PINS Z=n_4984 A=n_3311 B=n_1981 VSS=VSS VDD=VDD
Xg120227 NAND2X1 $PINS Z=n_4983 A=n_121 B=n_3358 VSS=VSS VDD=VDD
Xg120228 NAND2X1 $PINS Z=n_4982 A=n_1033 B=n_3307 VSS=VSS VDD=VDD
Xg120229 NAND2X1 $PINS Z=n_4981 A=n_1981 B=n_1693 VSS=VSS VDD=VDD
Xg120230 NAND2X1 $PINS Z=n_4980 A=n_1027 B=n_1444 VSS=VSS VDD=VDD
Xg120231 NAND2X1 $PINS Z=n_4979 A=n_120 B=n_3358 VSS=VSS VDD=VDD
Xg120232 NAND2X1 $PINS Z=n_4978 A=n_116 B=n_3386 VSS=VSS VDD=VDD
Xg120233 NAND2X1 $PINS Z=n_4977 A=n_121 B=n_3340 VSS=VSS VDD=VDD
Xg120234 NAND2X1 $PINS Z=n_4976 A=n_1024 B=n_1847 VSS=VSS VDD=VDD
Xg120235 NAND2X1 $PINS Z=n_4975 A=n_2084 B=n_476 VSS=VSS VDD=VDD
Xg120236 NAND2X1 $PINS Z=n_4974 A=n_1115 B=n_3302 VSS=VSS VDD=VDD
Xg120237 NAND2X1 $PINS Z=n_4973 A=n_121 B=n_2128 VSS=VSS VDD=VDD
Xg120238 NAND2X1 $PINS Z=n_4972 A=n_1274 B=csm_inst_round_counter[0] VSS=VSS
+ VDD=VDD
Xg120239 NAND2X1 $PINS Z=n_4971 A=n_1033 B=n_3334 VSS=VSS VDD=VDD
Xg120240 NAND2X1 $PINS Z=n_4970 A=n_1024 B=n_2675 VSS=VSS VDD=VDD
Xg120241 NAND2X1 $PINS Z=n_4969 A=n_1033 B=n_3398 VSS=VSS VDD=VDD
Xg120242 NAND2X1 $PINS Z=n_4968 A=n_1024 B=n_3304 VSS=VSS VDD=VDD
Xg120243 NAND2X1 $PINS Z=n_4967 A=n_117 B=n_1328 VSS=VSS VDD=VDD
Xg120244 NAND2X1 $PINS Z=n_4966 A=n_120 B=n_3323 VSS=VSS VDD=VDD
Xg120245 OR2X1 $PINS Z=n_4965 A=n_120 B=n_1417 VSS=VSS VDD=VDD
Xg120246 OR2X1 $PINS Z=n_4964 A=n_3413 B=n_120 VSS=VSS VDD=VDD
Xg120247 NAND2X1 $PINS Z=n_4963 A=n_1024 B=n_1227 VSS=VSS VDD=VDD
Xg120248 NAND2X1 $PINS Z=n_4962 A=n_1149 B=n_3329 VSS=VSS VDD=VDD
Xg120249 NAND2X1 $PINS Z=n_4961 A=n_84 B=csm_inst_right_reg[19] VSS=VSS VDD=VDD
Xg120250 NAND2X1 $PINS Z=n_4960 A=n_84 B=csm_inst_right_reg[9] VSS=VSS VDD=VDD
Xg120251 NAND2X1 $PINS Z=n_4959 A=n_1158 B=n_1790 VSS=VSS VDD=VDD
Xg120252 NAND2X1 $PINS Z=n_4958 A=n_117 B=n_3386 VSS=VSS VDD=VDD
Xg120253 NAND2X1 $PINS Z=n_4957 A=n_131 B=n_1338 VSS=VSS VDD=VDD
Xg120254 NAND2X1 $PINS Z=n_4956 A=n_1276 B=n_472 VSS=VSS VDD=VDD
Xg120255 NAND2X1 $PINS Z=n_4955 A=n_3309 B=n_116 VSS=VSS VDD=VDD
Xg120256 NAND2X1 $PINS Z=n_4954 A=n_106 B=n_1285 VSS=VSS VDD=VDD
Xg120257 NAND2X1 $PINS Z=n_4953 A=n_1588 B=n_1119 VSS=VSS VDD=VDD
Xg120258 NAND2X1 $PINS Z=n_4952 A=n_2506 B=n_473 VSS=VSS VDD=VDD
Xg120259 NAND2X1 $PINS Z=n_4951 A=n_1160 B=n_3413 VSS=VSS VDD=VDD
Xg120260 NAND2X1 $PINS Z=n_4950 A=n_1024 B=n_1419 VSS=VSS VDD=VDD
Xg120261 NAND2X1 $PINS Z=n_4949 A=n_1024 B=n_3403 VSS=VSS VDD=VDD
Xg120262 OR2X1 $PINS Z=n_4948 A=n_2563 B=n_330 VSS=VSS VDD=VDD
Xg120263 NAND2X1 $PINS Z=n_4947 A=n_84 B=csm_inst_right_reg[23] VSS=VSS VDD=VDD
Xg120264 NAND2X1 $PINS Z=n_4946 A=n_117 B=n_1366 VSS=VSS VDD=VDD
Xg120265 NAND2X1 $PINS Z=n_4945 A=n_1033 B=n_3384 VSS=VSS VDD=VDD
Xg120266 NAND2X1 $PINS Z=n_4944 A=n_1260 B=n_1156 VSS=VSS VDD=VDD
Xg120267 NAND2X1 $PINS Z=n_4943 A=n_1293 B=n_1024 VSS=VSS VDD=VDD
Xg120268 NAND2X1 $PINS Z=n_4942 A=n_120 B=n_2449 VSS=VSS VDD=VDD
Xg120269 NAND2X1 $PINS Z=n_4941 A=n_106 B=n_2128 VSS=VSS VDD=VDD
Xg120270 NAND2X1 $PINS Z=n_4940 A=n_121 B=n_2057 VSS=VSS VDD=VDD
Xg120271 NAND2X1 $PINS Z=n_4939 A=n_117 B=n_1338 VSS=VSS VDD=VDD
Xg120272 NAND2X1 $PINS Z=n_4938 A=n_120 B=n_1578 VSS=VSS VDD=VDD
Xg120273 NAND2X1 $PINS Z=n_4937 A=n_116 B=n_3391 VSS=VSS VDD=VDD
Xg120274 OR2X1 $PINS Z=n_4936 A=n_1609 B=n_1055 VSS=VSS VDD=VDD
Xg120275 NAND2X1 $PINS Z=n_4935 A=n_117 B=n_3318 VSS=VSS VDD=VDD
Xg120276 NAND2X1 $PINS Z=n_4934 A=n_1024 B=n_2140 VSS=VSS VDD=VDD
Xg120277 NAND2X1 $PINS Z=n_4933 A=n_117 B=n_3330 VSS=VSS VDD=VDD
Xg120278 NAND2X1 $PINS Z=n_4932 A=n_121 B=n_1397 VSS=VSS VDD=VDD
Xg120279 NAND2X1 $PINS Z=n_4931 A=n_1027 B=n_3327 VSS=VSS VDD=VDD
Xg120280 OR2X1 $PINS Z=n_4930 A=n_3384 B=n_116 VSS=VSS VDD=VDD
Xg120281 NAND2X1 $PINS Z=n_4929 A=n_106 B=n_3338 VSS=VSS VDD=VDD
Xg120282 NAND2X1 $PINS Z=n_4928 A=n_1033 B=n_3399 VSS=VSS VDD=VDD
Xg120283 NAND2X1 $PINS Z=n_4927 A=n_117 B=n_1413 VSS=VSS VDD=VDD
Xg120284 OR2X1 $PINS Z=n_4926 A=n_101 B=n_2125 VSS=VSS VDD=VDD
Xg120285 NAND2X1 $PINS Z=n_4925 A=n_106 B=n_2108 VSS=VSS VDD=VDD
Xg120286 NAND2X1 $PINS Z=n_4924 A=n_84 B=csm_inst_right_reg[22] VSS=VSS VDD=VDD
Xg120287 NAND2X1 $PINS Z=n_4923 A=n_106 B=n_3340 VSS=VSS VDD=VDD
Xg120288 OR2X1 $PINS Z=n_4922 A=n_1108 B=n_3358 VSS=VSS VDD=VDD
Xg120289 NAND2X1 $PINS Z=n_4921 A=n_117 B=n_1350 VSS=VSS VDD=VDD
Xg120290 NAND2X1 $PINS Z=n_4920 A=n_1108 B=n_1285 VSS=VSS VDD=VDD
Xg120291 NAND2X1 $PINS Z=n_4919 A=n_1024 B=n_3391 VSS=VSS VDD=VDD
Xg120292 NAND2X1 $PINS Z=n_4918 A=n_120 B=n_1291 VSS=VSS VDD=VDD
Xg120293 NAND2X1 $PINS Z=n_4917 A=n_106 B=n_2427 VSS=VSS VDD=VDD
Xg120294 NOR2X1 $PINS Z=n_4916 A=spi_inst_bit_count[3] B=n_3314 VSS=VSS VDD=VDD
Xg120295 NAND2X1 $PINS Z=n_4915 A=n_327 B=n_3290 VSS=VSS VDD=VDD
Xg120296 NAND2X1 $PINS Z=n_4914 A=n_3303 B=csm_inst_round_counter[0] VSS=VSS
+ VDD=VDD
Xg120297 NAND2X1 $PINS Z=n_4913 A=n_120 B=n_1587 VSS=VSS VDD=VDD
Xg120298 NAND2X1 $PINS Z=n_4912 A=n_1033 B=n_1397 VSS=VSS VDD=VDD
Xg120299 NAND2X1 $PINS Z=n_4911 A=n_1024 B=n_1569 VSS=VSS VDD=VDD
Xg120300 NAND2X1 $PINS Z=n_4910 A=n_1149 B=n_3328 VSS=VSS VDD=VDD
Xg120301 NAND2X1 $PINS Z=n_4909 A=n_1579 B=n_3271 VSS=VSS VDD=VDD
Xg120302 NAND2X1 $PINS Z=n_4908 A=n_84 B=csm_inst_right_reg[14] VSS=VSS VDD=VDD
Xg120303 NAND2X1 $PINS Z=n_4907 A=n_1033 B=n_2699 VSS=VSS VDD=VDD
Xg120304 NAND2X1 $PINS Z=n_4906 A=n_117 B=n_2113 VSS=VSS VDD=VDD
Xg120305 NAND2X1 $PINS Z=n_4905 A=n_1158 B=n_3324 VSS=VSS VDD=VDD
Xg120306 NAND2X1 $PINS Z=n_4904 A=n_117 B=n_1444 VSS=VSS VDD=VDD
Xg120307 NAND2X1 $PINS Z=n_4903 A=n_1027 B=n_3382 VSS=VSS VDD=VDD
Xg120308 NAND2X1 $PINS Z=n_4902 A=n_121 B=n_3388 VSS=VSS VDD=VDD
Xg120309 NAND2X1 $PINS Z=n_4901 A=n_84 B=csm_inst_right_reg[0] VSS=VSS VDD=VDD
Xg120310 NAND2X1 $PINS Z=n_4900 A=n_106 B=n_2732 VSS=VSS VDD=VDD
Xg120311 NAND2X1 $PINS Z=n_4899 A=n_1204 B=n_1403 VSS=VSS VDD=VDD
Xg120312 NAND2X1 $PINS Z=n_4898 A=n_1108 B=n_2491 VSS=VSS VDD=VDD
Xg120313 NAND2X1 $PINS Z=n_4897 A=n_1306 B=n_3271 VSS=VSS VDD=VDD
Xg120314 NAND2X1 $PINS Z=n_4896 A=n_1115 B=n_1581 VSS=VSS VDD=VDD
Xg120315 NAND2X1 $PINS Z=n_4895 A=n_1108 B=n_3302 VSS=VSS VDD=VDD
Xg120316 NAND2X1 $PINS Z=n_4894 A=n_84 B=csm_inst_right_reg[8] VSS=VSS VDD=VDD
Xg120317 NAND2X1 $PINS Z=n_4893 A=n_1274 B=n_473 VSS=VSS VDD=VDD
Xg120318 NAND2X1 $PINS Z=n_4892 A=n_1027 B=n_1410 VSS=VSS VDD=VDD
Xg120319 NAND2X1 $PINS Z=n_4891 A=n_117 B=n_3303 VSS=VSS VDD=VDD
Xg120320 NAND2X1 $PINS Z=n_4890 A=n_121 B=n_3412 VSS=VSS VDD=VDD
Xg120321 NAND2X1 $PINS Z=n_4889 A=n_1027 B=n_1366 VSS=VSS VDD=VDD
Xg120322 OR2X1 $PINS Z=n_4888 A=n_3338 B=n_1108 VSS=VSS VDD=VDD
Xg120323 NAND2X1 $PINS Z=n_4887 A=n_1115 B=n_1397 VSS=VSS VDD=VDD
Xg120324 NAND2X1 $PINS Z=n_4886 A=n_1115 B=n_3399 VSS=VSS VDD=VDD
Xg120325 NAND2X1 $PINS Z=n_4885 A=n_1 B=n_3322 VSS=VSS VDD=VDD
Xg120326 NAND2X1 $PINS Z=n_4884 A=n_116 B=n_1328 VSS=VSS VDD=VDD
Xg120327 NAND2X1 $PINS Z=n_4883 A=n_1033 B=n_1678 VSS=VSS VDD=VDD
Xg120328 OR2X1 $PINS Z=n_4882 A=n_1295 B=n_3271 VSS=VSS VDD=VDD
Xg120329 NAND2X1 $PINS Z=n_4881 A=n_1027 B=n_1419 VSS=VSS VDD=VDD
Xg120330 NAND2X1 $PINS Z=n_4880 A=n_116 B=n_1688 VSS=VSS VDD=VDD
Xg120331 NAND2X1 $PINS Z=n_4879 A=n_84 B=csm_inst_right_reg[24] VSS=VSS VDD=VDD
Xg120332 NAND2X1 $PINS Z=n_4878 A=n_84 B=csm_inst_right_reg[21] VSS=VSS VDD=VDD
Xg120333 NAND2X1 $PINS Z=n_4877 A=n_1163 B=n_3310 VSS=VSS VDD=VDD
Xg120334 NAND2X1 $PINS Z=n_4876 A=n_3348 B=n_473 VSS=VSS VDD=VDD
Xg120335 NAND2X1 $PINS Z=n_4875 A=n_126 B=n_3331 VSS=VSS VDD=VDD
Xg120336 OR2X1 $PINS Z=n_4874 A=n_3390 B=n_1027 VSS=VSS VDD=VDD
Xg120337 OR2X1 $PINS Z=n_4873 A=n_1676 B=n_116 VSS=VSS VDD=VDD
Xg120338 NAND2X1 $PINS Z=n_4872 A=n_117 B=n_1555 VSS=VSS VDD=VDD
Xg120339 NAND2X1 $PINS Z=n_4871 A=n_1398 B=n_1024 VSS=VSS VDD=VDD
Xg120340 NAND2X1 $PINS Z=n_4870 A=n_106 B=n_2699 VSS=VSS VDD=VDD
Xg120341 NAND2X1 $PINS Z=n_4869 A=n_1 B=n_2426 VSS=VSS VDD=VDD
Xg120342 NAND2X1 $PINS Z=n_4868 A=n_116 B=n_3393 VSS=VSS VDD=VDD
Xg120343 NAND2X1 $PINS Z=n_4867 A=n_1115 B=n_1291 VSS=VSS VDD=VDD
Xg120344 NAND2X1 $PINS Z=n_4866 A=n_84 B=csm_inst_right_reg[10] VSS=VSS VDD=VDD
Xg120345 NAND2X1 $PINS Z=n_4865 A=n_1390 B=n_472 VSS=VSS VDD=VDD
Xg120346 OR2X1 $PINS Z=n_4864 A=n_476 B=n_1676 VSS=VSS VDD=VDD
Xg120347 NAND2X1 $PINS Z=n_4863 A=n_1318 B=n_1126 VSS=VSS VDD=VDD
Xg120348 NAND2X1 $PINS Z=n_4862 A=n_1027 B=n_1579 VSS=VSS VDD=VDD
Xg120349 OR2X1 $PINS Z=n_4860 A=n_3271 B=n_2511 VSS=VSS VDD=VDD
Xg120350 NAND2X1 $PINS Z=n_4859 A=n_1024 B=n_1260 VSS=VSS VDD=VDD
Xg120351 NAND2X1 $PINS Z=n_4846 A=n_121 B=n_1285 VSS=VSS VDD=VDD
Xg120352 NAND2X1 $PINS Z=n_4835 A=n_1024 B=n_2060 VSS=VSS VDD=VDD
Xg120353 NAND2X1 $PINS Z=n_4834 A=n_1024 B=n_1693 VSS=VSS VDD=VDD
Xg120354 OR2X1 $PINS Z=n_4829 A=n_3318 B=n_1164 VSS=VSS VDD=VDD
Xg120355 NAND2X1 $PINS Z=n_4828 A=n_120 B=n_3340 VSS=VSS VDD=VDD
Xg120356 NAND2X1 $PINS Z=n_4812 A=n_1033 B=n_3397 VSS=VSS VDD=VDD
Xg120357 NAND2X1 $PINS Z=n_5126 A=n_106 B=n_2687 VSS=VSS VDD=VDD
Xg120358 NAND2X1 $PINS Z=n_5125 A=n_1033 B=n_2057 VSS=VSS VDD=VDD
Xg120359 NAND2X1 $PINS Z=n_5124 A=n_1033 B=n_1581 VSS=VSS VDD=VDD
Xg120360 NAND2X1 $PINS Z=n_5123 A=n_106 B=n_3429 VSS=VSS VDD=VDD
Xg120361 NAND2X1 $PINS Z=n_5122 A=n_106 B=n_2532 VSS=VSS VDD=VDD
Xg120362 NAND2X1 $PINS Z=n_5121 A=n_1033 B=n_3338 VSS=VSS VDD=VDD
Xg120363 NAND2X1 $PINS Z=n_5120 A=n_106 B=n_2694 VSS=VSS VDD=VDD
Xg120364 NAND2X1 $PINS Z=n_5119 A=n_106 B=n_3426 VSS=VSS VDD=VDD
Xg120365 NAND2X1 $PINS Z=n_5118 A=n_106 B=n_3390 VSS=VSS VDD=VDD
Xg120366 NOR2X1 $PINS Z=n_5117 A=n_160 B=n_3314 VSS=VSS VDD=VDD
Xg120367 NAND2X1 $PINS Z=n_5115 A=spi_inst_active B=n_3272 VSS=VSS VDD=VDD
Xg120369 NAND2X1 $PINS Z=n_5113 A=n_1033 B=n_3429 VSS=VSS VDD=VDD
Xg120371 INVX2 $PINS Z=n_4797 A=n_4796 VSS=VSS VDD=VDD
Xg120373 NAND2X1 $PINS Z=n_4790 A=n_117 B=n_1456 VSS=VSS VDD=VDD
Xg120374 NAND2X1 $PINS Z=n_4789 A=n_3402 B=FE_DBTN2_csm_inst_round_counter_0
+ VSS=VSS VDD=VDD
Xg120375 NAND2X1 $PINS Z=n_4788 A=n_1609 B=n_1 VSS=VSS VDD=VDD
Xg120376 NAND2X1 $PINS Z=n_4787 A=n_1115 B=n_1414 VSS=VSS VDD=VDD
Xg120377 NAND2X1 $PINS Z=n_4786 A=n_116 B=n_3333 VSS=VSS VDD=VDD
Xg120378 NAND2X1 $PINS Z=n_4785 A=n_1027 B=n_3319 VSS=VSS VDD=VDD
Xg120379 NAND2X1 $PINS Z=n_4784 A=n_116 B=n_1790 VSS=VSS VDD=VDD
Xg120380 NAND2X1 $PINS Z=n_4783 A=n_1156 B=n_1456 VSS=VSS VDD=VDD
Xg120381 NAND2X1 $PINS Z=n_4782 A=n_116 B=n_3310 VSS=VSS VDD=VDD
Xg120382 NAND2X1 $PINS Z=n_4781 A=n_1385 B=n_1024 VSS=VSS VDD=VDD
Xg120383 NAND2X1 $PINS Z=n_4779 A=n_1149 B=n_3408 VSS=VSS VDD=VDD
Xg120384 NAND2X1 $PINS Z=n_4778 A=n_1033 B=n_1291 VSS=VSS VDD=VDD
Xg120385 NAND2X1 $PINS Z=n_4777 A=n_84 B=n_3271 VSS=VSS VDD=VDD
Xg120386 NAND2X1 $PINS Z=n_4776 A=n_2696 B=n_190 VSS=VSS VDD=VDD
Xg120387 OR2X1 $PINS Z=n_4775 A=n_1572 B=n_120 VSS=VSS VDD=VDD
Xg120388 NAND2X1 $PINS Z=n_4774 A=n_1156 B=n_1295 VSS=VSS VDD=VDD
Xg120389 NAND2X1 $PINS Z=n_4773 A=n_121 B=n_1599 VSS=VSS VDD=VDD
Xg120390 NAND2X1 $PINS Z=n_4772 A=n_1027 B=n_3387 VSS=VSS VDD=VDD
Xg120391 NAND2X1 $PINS Z=n_4771 A=n_1163 B=n_2091 VSS=VSS VDD=VDD
Xg120392 NAND2X1 $PINS Z=n_4770 A=n_1024 B=n_3319 VSS=VSS VDD=VDD
Xg120393 NAND2X1 $PINS Z=n_4769 A=n_120 B=n_3398 VSS=VSS VDD=VDD
Xg120394 NAND2X1 $PINS Z=n_4768 A=n_1024 B=n_1202 VSS=VSS VDD=VDD
Xg120395 NAND2X1 $PINS Z=n_4767 A=n_1027 B=n_3316 VSS=VSS VDD=VDD
Xg120396 NAND2X1 $PINS Z=n_4766 A=n_1024 B=n_1218 VSS=VSS VDD=VDD
Xg120397 NAND2X1 $PINS Z=n_4765 A=n_84 B=csm_inst_right_reg[20] VSS=VSS VDD=VDD
Xg120398 NAND2X1 $PINS Z=n_4764 A=n_106 B=n_3397 VSS=VSS VDD=VDD
Xg120399 NAND2X1 $PINS Z=n_4763 A=n_1027 B=n_1409 VSS=VSS VDD=VDD
Xg120400 NAND2X1 $PINS Z=n_4762 A=n_1024 B=n_3331 VSS=VSS VDD=VDD
Xg120401 OR2X1 $PINS Z=n_4761 A=n_1285 B=n_116 VSS=VSS VDD=VDD
Xg120402 NAND2X1 $PINS Z=n_4760 A=n_1158 B=n_1394 VSS=VSS VDD=VDD
Xg120403 NAND2X1 $PINS Z=n_4759 A=n_121 B=n_2506 VSS=VSS VDD=VDD
Xg120404 NAND2X1 $PINS Z=n_4758 A=n_2060 B=n_472 VSS=VSS VDD=VDD
Xg120405 NAND2X1 $PINS Z=n_4757 A=n_106 B=n_3389 VSS=VSS VDD=VDD
Xg120406 NAND2X1 $PINS Z=n_4756 A=n_1033 B=n_1587 VSS=VSS VDD=VDD
Xg120407 NAND2X1 $PINS Z=n_4755 A=n_1126 B=n_1289 VSS=VSS VDD=VDD
Xg120408 NAND3X1 $PINS Z=n_4753 A=n_84 B=csm_inst_round_counter[0] C=n_165
+ VSS=VSS VDD=VDD
Xg120409 NAND2X1 $PINS Z=n_4752 A=n_116 B=n_1338 VSS=VSS VDD=VDD
Xg120410 NAND2X1 $PINS Z=n_4751 A=n_1156 B=n_3328 VSS=VSS VDD=VDD
Xg120411 NAND2X1 $PINS Z=n_4750 A=n_84 B=csm_inst_right_reg[4] VSS=VSS VDD=VDD
Xg120412 OR2X1 $PINS Z=n_4749 A=n_2377 B=n_121 VSS=VSS VDD=VDD
Xg120413 NAND2X1 $PINS Z=n_4748 A=n_1027 B=n_1293 VSS=VSS VDD=VDD
Xg120414 OR2X1 $PINS Z=n_4747 A=n_3302 B=n_117 VSS=VSS VDD=VDD
Xg120415 NAND2X1 $PINS Z=n_4746 A=n_121 B=n_3383 VSS=VSS VDD=VDD
Xg120416 NAND2X1 $PINS Z=n_4745 A=n_84 B=csm_inst_right_reg[2] VSS=VSS VDD=VDD
Xg120417 NAND2X1 $PINS Z=n_4744 A=n_116 B=n_1350 VSS=VSS VDD=VDD
Xg120418 NAND2X1 $PINS Z=n_4743 A=n_1160 B=n_1218 VSS=VSS VDD=VDD
Xg120419 NAND2X1 $PINS Z=n_4742 A=n_1033 B=n_3410 VSS=VSS VDD=VDD
Xg120420 NAND2X1 $PINS Z=n_4741 A=n_1163 B=n_1390 VSS=VSS VDD=VDD
Xg120421 NAND2X1 $PINS Z=n_4740 A=n_120 B=n_1397 VSS=VSS VDD=VDD
Xg120422 NAND2X1 $PINS Z=n_4739 A=n_1158 B=n_1572 VSS=VSS VDD=VDD
Xg120423 NAND2X1 $PINS Z=n_4738 A=n_84 B=csm_inst_right_reg[3] VSS=VSS VDD=VDD
Xg120424 NAND2X1 $PINS Z=n_4737 A=n_84 B=csm_inst_right_reg[31] VSS=VSS VDD=VDD
Xg120425 NAND2X1 $PINS Z=n_4736 A=n_117 B=n_1181 VSS=VSS VDD=VDD
Xg120426 NAND2X1 $PINS Z=n_4735 A=n_1024 B=n_3332 VSS=VSS VDD=VDD
Xg120427 NAND2X1 $PINS Z=n_4734 A=n_106 B=n_2057 VSS=VSS VDD=VDD
Xg120428 NAND2X1 $PINS Z=n_4733 A=n_121 B=n_1751 VSS=VSS VDD=VDD
Xg120429 OR2X1 $PINS Z=n_4732 A=n_3315 B=n_121 VSS=VSS VDD=VDD
Xg120430 OR2X1 $PINS Z=n_4731 A=n_1413 B=n_120 VSS=VSS VDD=VDD
Xg120431 OR2X1 $PINS Z=n_4730 A=n_3359 B=n_121 VSS=VSS VDD=VDD
Xg120432 NAND2X1 $PINS Z=n_4729 A=n_330 B=n_962 VSS=VSS VDD=VDD
Xg120433 NAND2X1 $PINS Z=n_4728 A=n_106 B=n_1673 VSS=VSS VDD=VDD
Xg120434 NAND2X1 $PINS Z=n_4726 A=n_1033 B=n_1879 VSS=VSS VDD=VDD
Xg120435 NAND2X1 $PINS Z=n_4725 A=n_117 B=n_1572 VSS=VSS VDD=VDD
Xg120436 OR2X1 $PINS Z=n_4724 A=n_3307 B=n_117 VSS=VSS VDD=VDD
Xg120437 NAND2X1 $PINS Z=n_4723 A=n_1024 B=n_1242 VSS=VSS VDD=VDD
Xg120438 NAND2X1 $PINS Z=n_4722 A=n_117 B=n_1403 VSS=VSS VDD=VDD
Xg120439 NAND2X1 $PINS Z=n_4721 A=n_120 B=n_1580 VSS=VSS VDD=VDD
Xg120440 NAND2X1 $PINS Z=n_4720 A=n_1149 B=n_3324 VSS=VSS VDD=VDD
Xg120441 NAND2X1 $PINS Z=n_4719 A=n_1269 B=n_2672 VSS=VSS VDD=VDD
Xg120442 NAND2X1 $PINS Z=n_4718 A=n_1126 B=n_3328 VSS=VSS VDD=VDD
Xg120443 NAND2X1 $PINS Z=n_4717 A=n_1149 B=n_1319 VSS=VSS VDD=VDD
Xg120444 NAND2X1 $PINS Z=n_4716 A=n_1115 B=n_3326 VSS=VSS VDD=VDD
Xg120445 OR2X1 $PINS Z=n_4715 A=n_1599 B=n_1108 VSS=VSS VDD=VDD
Xg120446 NOR2X1 $PINS Z=n_4714 A=n_1164 B=n_3393 VSS=VSS VDD=VDD
Xg120447 NAND2X1 $PINS Z=n_4713 A=n_121 B=n_1581 VSS=VSS VDD=VDD
Xg120448 NAND2X1 $PINS Z=n_4712 A=n_1149 B=n_3311 VSS=VSS VDD=VDD
Xg120449 NAND2X1 $PINS Z=n_4711 A=n_1024 B=n_3316 VSS=VSS VDD=VDD
Xg120450 NAND2X1 $PINS Z=n_4710 A=n_116 B=n_1403 VSS=VSS VDD=VDD
Xg120451 NAND2X1 $PINS Z=n_4709 A=n_1033 B=n_3389 VSS=VSS VDD=VDD
Xg120452 NAND2X1 $PINS Z=n_4708 A=n_1024 B=n_3416 VSS=VSS VDD=VDD
Xg120453 OR2X1 $PINS Z=n_4707 A=n_1204 B=n_1181 VSS=VSS VDD=VDD
Xg120454 AND2X1 $PINS Z=n_4706 A=n_1366 B=n_131 VSS=VSS VDD=VDD
Xg120455 NAND2X1 $PINS Z=n_4705 A=n_84 B=csm_inst_right_reg[26] VSS=VSS VDD=VDD
Xg120456 NAND2X1 $PINS Z=n_4704 A=n_1033 B=n_1580 VSS=VSS VDD=VDD
Xg120457 NAND2X1 $PINS Z=n_4685 A=n_84 B=csm_inst_right_reg[15] VSS=VSS VDD=VDD
Xg120458 NAND2X1 $PINS Z=n_4680 A=n_1158 B=n_1422 VSS=VSS VDD=VDD
Xg120459 NAND2X1 $PINS Z=n_4677 A=n_1027 B=n_3315 VSS=VSS VDD=VDD
Xg120460 NAND2X1 $PINS Z=n_4676 A=n_84 B=csm_inst_right_reg[16] VSS=VSS VDD=VDD
Xg120461 NAND2X1 $PINS Z=n_4675 A=n_1024 B=n_1983 VSS=VSS VDD=VDD
Xg120462 NAND2X1 $PINS Z=n_4674 A=n_1027 B=n_1269 VSS=VSS VDD=VDD
Xg120463 NAND2X1 $PINS Z=n_4672 A=n_121 B=n_3397 VSS=VSS VDD=VDD
Xg120464 OR2X1 $PINS Z=n_4626 A=n_1192 B=n_3278 VSS=VSS VDD=VDD
Xg120465 NAND2X1 $PINS Z=n_4517 A=n_1156 B=n_1555 VSS=VSS VDD=VDD
Xg120466 NAND2X1 $PINS Z=n_4487 A=n_120 B=n_1414 VSS=VSS VDD=VDD
Xg120467 NAND2X1 $PINS Z=n_4484 A=n_1024 B=n_2091 VSS=VSS VDD=VDD
Xg120468 NAND2X1 $PINS Z=n_4385 A=n_84 B=csm_inst_right_reg[5] VSS=VSS VDD=VDD
Xg120469 OR2X1 $PINS Z=n_4384 A=n_3410 B=n_116 VSS=VSS VDD=VDD
Xg120470 NAND2X1 $PINS Z=n_4338 A=n_1126 B=n_1393 VSS=VSS VDD=VDD
Xg120471 NAND3X1 $PINS Z=n_4336 A=n_182 B=n_168 C=spi_inst_cs_sync2 VSS=VSS
+ VDD=VDD
Xg120472 OR2X1 $PINS Z=n_4331 A=n_1033 B=n_1300 VSS=VSS VDD=VDD
Xg120473 OR2X1 $PINS Z=n_4324 A=n_1115 B=n_2449 VSS=VSS VDD=VDD
Xg120474 NAND2X1 $PINS Z=n_4315 A=n_1115 B=n_1613 VSS=VSS VDD=VDD
Xg120475 NAND2X1 $PINS Z=n_4294 A=n_1027 B=n_3329 VSS=VSS VDD=VDD
Xg120476 NAND2X1 $PINS Z=n_4290 A=n_121 B=n_1591 VSS=VSS VDD=VDD
Xg120477 NAND2X1 $PINS Z=n_4280 A=n_1413 B=n_476 VSS=VSS VDD=VDD
Xg120478 NAND2X1 $PINS Z=n_4234 A=n_1027 B=n_3400 VSS=VSS VDD=VDD
Xg120479 NAND2X1 $PINS Z=n_4215 A=n_1027 B=n_3405 VSS=VSS VDD=VDD
Xg120480 NAND2X1 $PINS Z=n_4204 A=n_1024 B=n_1688 VSS=VSS VDD=VDD
Xg120481 NAND2X1 $PINS Z=n_4169 A=n_106 B=n_3325 VSS=VSS VDD=VDD
Xg120482 NAND2X1 $PINS Z=n_4163 A=n_1579 B=n_1149 VSS=VSS VDD=VDD
Xg120483 OR2X1 $PINS Z=n_4161 A=n_3389 B=n_117 VSS=VSS VDD=VDD
Xg120484 NAND2X1 $PINS Z=n_4126 A=n_121 B=n_1879 VSS=VSS VDD=VDD
Xg120485 NAND2X1 $PINS Z=n_4109 A=n_117 B=n_3308 VSS=VSS VDD=VDD
Xg120486 NAND2X1 $PINS Z=n_4089 A=n_3313 B=n_1108 VSS=VSS VDD=VDD
Xg120487 NAND2X1 $PINS Z=n_4086 A=n_2140 B=n_1126 VSS=VSS VDD=VDD
Xg120488 NAND2X1 $PINS Z=n_4040 A=n_1024 B=n_1704 VSS=VSS VDD=VDD
Xg120489 NAND2X1 $PINS Z=n_4010 A=n_1027 B=n_1607 VSS=VSS VDD=VDD
Xg120490 NAND2X1 $PINS Z=n_3999 A=n_1027 B=n_1306 VSS=VSS VDD=VDD
Xg120491 NAND2X1 $PINS Z=n_3996 A=n_1027 B=n_1555 VSS=VSS VDD=VDD
Xg120492 NAND2X1 $PINS Z=n_3987 A=n_1126 B=n_1704 VSS=VSS VDD=VDD
Xg120493 NAND2X1 $PINS Z=n_3982 A=n_126 B=n_1181 VSS=VSS VDD=VDD
Xg120494 NAND2X1 $PINS Z=n_3979 A=n_1024 B=n_1318 VSS=VSS VDD=VDD
Xg120495 NAND2X1 $PINS Z=n_3978 A=n_1027 B=n_1227 VSS=VSS VDD=VDD
Xg120496 NAND2X1 $PINS Z=n_3974 A=n_116 B=n_3303 VSS=VSS VDD=VDD
Xg120497 NAND2X1 $PINS Z=n_3962 A=n_1033 B=n_3325 VSS=VSS VDD=VDD
Xg120498 NAND2X1 $PINS Z=n_3946 A=n_117 B=n_1422 VSS=VSS VDD=VDD
Xg120499 NAND2X1 $PINS Z=n_3945 A=n_106 B=n_2506 VSS=VSS VDD=VDD
Xg120500 NAND2X1 $PINS Z=n_3936 A=n_1108 B=n_3323 VSS=VSS VDD=VDD
Xg120501 OR2X1 $PINS Z=n_3893 A=n_190 B=n_1582 VSS=VSS VDD=VDD
Xg120502 NAND2X1 $PINS Z=n_3891 A=n_121 B=n_3313 VSS=VSS VDD=VDD
Xg120503 NAND2X1 $PINS Z=n_3881 A=n_126 B=n_1202 VSS=VSS VDD=VDD
Xg120504 NAND2X1 $PINS Z=n_3879 A=n_1024 B=n_1838 VSS=VSS VDD=VDD
Xg120505 NAND2X1 $PINS Z=n_3870 A=n_1027 B=n_3304 VSS=VSS VDD=VDD
Xg120506 NAND2X1 $PINS Z=n_3861 A=n_1024 B=n_2578 VSS=VSS VDD=VDD
Xg120507 NAND2X1 $PINS Z=n_3845 A=n_1033 B=n_1673 VSS=VSS VDD=VDD
Xg120508 OR2X1 $PINS Z=n_3844 A=n_3325 B=n_116 VSS=VSS VDD=VDD
Xg120509 NAND2X1 $PINS Z=n_3837 A=n_3277 B=n_3359 VSS=VSS VDD=VDD
Xg120510 OR2X1 $PINS Z=n_3821 A=n_121 B=n_3417 VSS=VSS VDD=VDD
Xg120511 NAND2X1 $PINS Z=n_3820 A=n_1027 B=n_3308 VSS=VSS VDD=VDD
Xg120512 NAND2X1 $PINS Z=n_3812 A=n_1149 B=n_3280 VSS=VSS VDD=VDD
Xg120513 NAND2X1 $PINS Z=n_3808 A=n_106 B=n_3412 VSS=VSS VDD=VDD
Xg120514 NAND2X1 $PINS Z=n_3799 A=n_1274 B=n_1126 VSS=VSS VDD=VDD
Xg120515 NAND2X1 $PINS Z=n_3796 A=n_120 B=n_2691 VSS=VSS VDD=VDD
Xg120516 NAND2X1 $PINS Z=n_3791 A=n_117 B=n_1421 VSS=VSS VDD=VDD
Xg120517 NAND2X1 $PINS Z=n_3790 A=n_120 B=n_1879 VSS=VSS VDD=VDD
Xg120518 OR2X1 $PINS Z=n_3776 A=n_2687 B=n_1115 VSS=VSS VDD=VDD
Xg120519 NAND2X1 $PINS Z=n_3773 A=n_1204 B=n_1208 VSS=VSS VDD=VDD
Xg120520 NAND2X1 $PINS Z=n_3766 A=n_84 B=csm_inst_right_reg[6] VSS=VSS VDD=VDD
Xg120521 OR2X1 $PINS Z=n_3763 A=n_1613 B=n_116 VSS=VSS VDD=VDD
Xg120522 NAND2X1 $PINS Z=n_3760 A=n_1149 B=n_1269 VSS=VSS VDD=VDD
Xg120523 OR2X1 $PINS Z=n_3758 A=n_3410 B=n_1108 VSS=VSS VDD=VDD
Xg120524 NAND2X1 $PINS Z=n_3757 A=n_1024 B=n_3309 VSS=VSS VDD=VDD
Xg120525 NAND2X1 $PINS Z=n_3756 A=n_1027 B=n_2028 VSS=VSS VDD=VDD
Xg120526 NAND2X1 $PINS Z=n_3755 A=n_1027 B=n_1218 VSS=VSS VDD=VDD
Xg120527 NAND2X1 $PINS Z=n_3753 A=n_1024 B=n_1614 VSS=VSS VDD=VDD
Xg120528 NAND2X1 $PINS Z=n_3752 A=n_106 B=n_3334 VSS=VSS VDD=VDD
Xg120529 NAND2X1 $PINS Z=n_3748 A=n_1024 B=n_1409 VSS=VSS VDD=VDD
Xg120530 NAND2X1 $PINS Z=n_3747 A=n_1126 B=n_3332 VSS=VSS VDD=VDD
Xg120531 NAND2X1 $PINS Z=n_3746 A=n_1024 B=n_3310 VSS=VSS VDD=VDD
Xg120532 NAND2X1 $PINS Z=n_3745 A=n_1027 B=n_1576 VSS=VSS VDD=VDD
Xg120533 OR2X1 $PINS Z=n_3743 A=n_1597 B=n_106 VSS=VSS VDD=VDD
Xg120534 NAND2X1 $PINS Z=n_3742 A=n_1163 B=n_3280 VSS=VSS VDD=VDD
Xg120535 NAND2X1 $PINS Z=n_3741 A=n_1027 B=n_2084 VSS=VSS VDD=VDD
Xg120536 NAND2X1 $PINS Z=n_3740 A=n_1126 B=n_3321 VSS=VSS VDD=VDD
Xg120537 NAND2X1 $PINS Z=n_3719 A=n_1149 B=n_2259 VSS=VSS VDD=VDD
Xg120538 NAND2X1 $PINS Z=n_3714 A=n_1156 B=n_3327 VSS=VSS VDD=VDD
Xg120539 NAND2X1 $PINS Z=n_3709 A=n_1027 B=n_1394 VSS=VSS VDD=VDD
Xg120540 NAND2X1 $PINS Z=n_3695 A=n_1164 B=n_1444 VSS=VSS VDD=VDD
Xg120541 NAND2X1 $PINS Z=n_3693 A=n_120 B=n_3383 VSS=VSS VDD=VDD
Xg120542 NAND2X1 $PINS Z=n_3687 A=n_1033 B=n_1676 VSS=VSS VDD=VDD
Xg120543 NAND2X1 $PINS Z=n_3671 A=n_120 B=n_3313 VSS=VSS VDD=VDD
Xg120544 OR2X1 $PINS Z=n_3667 A=n_1024 B=n_3325 VSS=VSS VDD=VDD
Xg120545 OR2X1 $PINS Z=n_3666 A=n_3326 B=n_116 VSS=VSS VDD=VDD
Xg120546 NAND2X1 $PINS Z=n_3657 A=n_1033 B=n_3426 VSS=VSS VDD=VDD
Xg120547 NAND2X1 $PINS Z=n_3647 A=n_121 B=n_1291 VSS=VSS VDD=VDD
Xg120548 NAND2X1 $PINS Z=n_3643 A=n_120 B=n_2491 VSS=VSS VDD=VDD
Xg120549 OR2X1 $PINS Z=n_3630 A=n_1398 B=n_120 VSS=VSS VDD=VDD
Xg120550 NAND2X1 $PINS Z=n_3629 A=n_121 B=n_1613 VSS=VSS VDD=VDD
Xg120551 NAND2X1 $PINS Z=n_3627 A=n_1214 B=n_3271 VSS=VSS VDD=VDD
Xg120552 NAND2X1 $PINS Z=n_3626 A=n_121 B=n_2108 VSS=VSS VDD=VDD
Xg120553 NAND2X1 $PINS Z=n_3622 A=n_1024 B=n_1289 VSS=VSS VDD=VDD
Xg120554 OR2X1 $PINS Z=n_3615 A=n_3307 B=n_1108 VSS=VSS VDD=VDD
Xg120555 NAND2X1 $PINS Z=n_3614 A=n_1024 B=n_1375 VSS=VSS VDD=VDD
Xg120556 NAND2X1 $PINS Z=n_3608 A=n_1149 B=n_1394 VSS=VSS VDD=VDD
Xg120557 NAND2X1 $PINS Z=n_3607 A=n_1024 B=n_1306 VSS=VSS VDD=VDD
Xg120558 NAND2X1 $PINS Z=n_3603 A=n_1027 B=n_1242 VSS=VSS VDD=VDD
Xg120559 NAND2X1 $PINS Z=n_3598 A=n_84 B=csm_inst_right_reg[29] VSS=VSS VDD=VDD
Xg120560 NAND2X1 $PINS Z=n_3596 A=n_1108 B=n_1578 VSS=VSS VDD=VDD
Xg120561 OR2X1 $PINS Z=n_3591 A=n_1421 B=n_120 VSS=VSS VDD=VDD
Xg120562 NAND2X1 $PINS Z=n_3590 A=n_117 B=n_1410 VSS=VSS VDD=VDD
Xg120563 NAND2X1 $PINS Z=n_3589 A=n_3290 B=start_decrypt VSS=VSS VDD=VDD
Xg120564 NAND2X1 $PINS Z=n_3587 A=n_1027 B=n_1375 VSS=VSS VDD=VDD
Xg120565 NAND2X1 $PINS Z=n_3585 A=n_84 B=csm_inst_right_reg[30] VSS=VSS VDD=VDD
Xg120566 NAND2X1 $PINS Z=n_3584 A=n_1158 B=n_1375 VSS=VSS VDD=VDD
Xg120567 NAND2X1 $PINS Z=n_3580 A=n_84 B=csm_inst_right_reg[7] VSS=VSS VDD=VDD
Xg120568 NAND2X1 $PINS Z=n_3578 A=n_3405 B=n_476 VSS=VSS VDD=VDD
Xg120569 NAND2X1 $PINS Z=n_3577 A=n_1108 B=n_3307 VSS=VSS VDD=VDD
Xg120570 NAND2X1 $PINS Z=n_3574 A=n_1108 B=n_2427 VSS=VSS VDD=VDD
Xg120571 OR2X1 $PINS Z=n_3573 A=n_3399 B=n_116 VSS=VSS VDD=VDD
Xg120572 NAND2X1 $PINS Z=n_3570 A=n_1126 B=n_3392 VSS=VSS VDD=VDD
Xg120573 NAND2X1 $PINS Z=n_3569 A=n_84 B=csm_inst_right_reg[13] VSS=VSS VDD=VDD
Xg120574 NAND2X1 $PINS Z=n_3567 A=n_1024 B=n_1233 VSS=VSS VDD=VDD
Xg120575 OR2X1 $PINS Z=n_3566 A=n_3335 B=n_120 VSS=VSS VDD=VDD
Xg120576 NAND2X1 $PINS Z=n_3564 A=n_84 B=csm_inst_right_reg[1] VSS=VSS VDD=VDD
Xg120577 NAND2X1 $PINS Z=n_3563 A=n_1158 B=n_3298 VSS=VSS VDD=VDD
Xg120578 NAND2X1 $PINS Z=n_3562 A=n_1027 B=n_3324 VSS=VSS VDD=VDD
Xg120579 AND2X1 $PINS Z=n_3560 A=n_3427 B=n_80 VSS=VSS VDD=VDD
Xg120580 NAND2X1 $PINS Z=n_3559 A=n_117 B=n_2230 VSS=VSS VDD=VDD
Xg120581 NAND2X1 $PINS Z=n_3548 A=n_106 B=n_2491 VSS=VSS VDD=VDD
Xg120582 NAND2X1 $PINS Z=n_3547 A=n_120 B=n_2532 VSS=VSS VDD=VDD
Xg120583 NAND2X1 $PINS Z=n_3545 A=n_1027 B=n_1422 VSS=VSS VDD=VDD
Xg120584 NAND2X1 $PINS Z=n_3544 A=n_117 B=n_2080 VSS=VSS VDD=VDD
Xg120585 NAND2X1 $PINS Z=n_3543 A=n_121 B=n_3398 VSS=VSS VDD=VDD
Xg120586 NAND2X1 $PINS Z=n_3542 A=n_1027 B=n_1385 VSS=VSS VDD=VDD
Xg120587 NAND2X1 $PINS Z=n_3540 A=n_1318 B=n_1158 VSS=VSS VDD=VDD
Xg120588 OR2X1 $PINS Z=n_3539 A=n_1605 B=n_119 VSS=VSS VDD=VDD
Xg120589 NAND2X1 $PINS Z=n_3538 A=n_1033 B=n_2108 VSS=VSS VDD=VDD
Xg120590 NAND2X1 $PINS Z=n_3537 A=n_2578 B=n_472 VSS=VSS VDD=VDD
Xg120591 NAND2X1 $PINS Z=n_3535 A=n_1027 B=n_1319 VSS=VSS VDD=VDD
Xg120592 OR2X1 $PINS Z=n_3527 A=n_3277 B=n_3333 VSS=VSS VDD=VDD
Xg120593 NAND2X1 $PINS Z=n_3526 A=n_1398 B=n_1164 VSS=VSS VDD=VDD
Xg120594 NAND2X1 $PINS Z=n_3525 A=n_1126 B=n_3403 VSS=VSS VDD=VDD
Xg120595 NAND2X1 $PINS Z=n_3524 A=n_3316 B=n_2672 VSS=VSS VDD=VDD
Xg120596 NAND2X1 $PINS Z=n_3522 A=n_106 B=n_3313 VSS=VSS VDD=VDD
Xg120597 NAND2X1 $PINS Z=n_3521 A=n_121 B=n_1414 VSS=VSS VDD=VDD
Xg120598 NAND2X1 $PINS Z=n_3520 A=n_84 B=csm_inst_right_reg[28] VSS=VSS VDD=VDD
Xg120599 NAND2X1 $PINS Z=n_3519 A=n_84 B=csm_inst_right_reg[12] VSS=VSS VDD=VDD
Xg120600 NAND2X1 $PINS Z=n_3518 A=n_1027 B=n_1569 VSS=VSS VDD=VDD
Xg120601 OR2X1 $PINS Z=n_3517 A=n_3390 B=n_116 VSS=VSS VDD=VDD
Xg120602 NAND2X1 $PINS Z=n_3515 A=n_1108 B=n_3383 VSS=VSS VDD=VDD
Xg120603 OR2X1 $PINS Z=n_3514 A=n_1410 B=n_1204 VSS=VSS VDD=VDD
Xg120604 NAND2X1 $PINS Z=n_3513 A=n_106 B=n_1678 VSS=VSS VDD=VDD
Xg120605 OR2X1 $PINS Z=n_3510 A=n_190 B=n_3281 VSS=VSS VDD=VDD
Xg120606 NAND2X1 $PINS Z=n_3508 A=n_1214 B=n_1126 VSS=VSS VDD=VDD
Xg120607 NAND2X1 $PINS Z=n_3498 A=n_3281 B=n_1981 VSS=VSS VDD=VDD
Xg120608 NAND2X1 $PINS Z=n_3491 A=n_119 B=n_3291 VSS=VSS VDD=VDD
Xg120609 NAND2X1 $PINS Z=n_3476 A=n_116 B=n_1208 VSS=VSS VDD=VDD
Xg120610 OR2X1 $PINS Z=n_3473 A=n_1208 B=n_1164 VSS=VSS VDD=VDD
Xg120611 NAND2X1 $PINS Z=n_3472 A=n_131 B=n_1202 VSS=VSS VDD=VDD
Xg120612 NAND2X1 $PINS Z=n_3467 A=n_131 B=n_1181 VSS=VSS VDD=VDD
Xg120613 NAND2X1 $PINS Z=n_3466 A=n_1156 B=n_3298 VSS=VSS VDD=VDD
Xg120614 NAND2X1 $PINS Z=n_3464 A=n_1156 B=n_3280 VSS=VSS VDD=VDD
Xg120615 NAND2X1 $PINS Z=n_3462 A=n_1027 B=n_3280 VSS=VSS VDD=VDD
Xg120616 NAND2X1 $PINS Z=n_3461 A=n_119 B=n_1178 VSS=VSS VDD=VDD
Xg120617 NAND2X1 $PINS Z=n_3458 A=n_116 B=n_1202 VSS=VSS VDD=VDD
Xg120618 NAND2X1 $PINS Z=n_3456 A=n_1181 B=n_1160 VSS=VSS VDD=VDD
Xg120619 OR2X1 $PINS Z=n_3455 A=n_1202 B=n_1164 VSS=VSS VDD=VDD
Xg120620 OR2X1 $PINS Z=n_3450 A=n_3298 B=n_121 VSS=VSS VDD=VDD
Xg120621 NAND2X1 $PINS Z=n_3447 A=n_3281 B=n_3271 VSS=VSS VDD=VDD
Xg120622 OR2X1 $PINS Z=n_3445 A=n_3298 B=n_1163 VSS=VSS VDD=VDD
Xg120623 NOR2X1 $PINS Z=n_3442 A=FE_DBTN1_csm_inst_mode B=n_3290 VSS=VSS
+ VDD=VDD
Xg120624 NAND2X1 $PINS Z=n_3441 A=n_1214 B=n_472 VSS=VSS VDD=VDD
Xg120625 NAND2X1 $PINS Z=n_3440 A=n_1158 B=n_3281 VSS=VSS VDD=VDD
Xg120626 NAND2X1 $PINS Z=n_3439 A=n_1149 B=n_1214 VSS=VSS VDD=VDD
Xg120627 NAND2X1 $PINS Z=n_3436 A=n_3280 B=n_473 VSS=VSS VDD=VDD
Xg120628 NAND2X1 $PINS Z=n_3435 A=n_1024 B=n_3281 VSS=VSS VDD=VDD
Xg120629 NAND2X1 $PINS Z=n_3434 A=n_1214 B=n_473 VSS=VSS VDD=VDD
Xg120630 NAND2X1 $PINS Z=n_3433 A=n_117 B=n_1208 VSS=VSS VDD=VDD
Xg120631 NAND2X1 $PINS Z=n_4811 A=n_1033 B=n_2696 VSS=VSS VDD=VDD
Xg120632 NAND2X1 $PINS Z=n_4807 A=n_1033 B=n_2768 VSS=VSS VDD=VDD
Xg120633 OR2X1 $PINS Z=n_4805 A=n_1350 B=n_1204 VSS=VSS VDD=VDD
Xg120634 NAND2X1 $PINS Z=n_4804 A=n_1033 B=n_1599 VSS=VSS VDD=VDD
Xg120635 NAND2X1 $PINS Z=n_4803 A=n_106 B=n_1580 VSS=VSS VDD=VDD
Xg120636 NAND2X1 $PINS Z=n_4802 A=n_1033 B=n_3412 VSS=VSS VDD=VDD
Xg120637 NAND2X1 $PINS Z=n_4801 A=n_1033 B=n_2694 VSS=VSS VDD=VDD
Xg120638 NAND2X1 $PINS Z=n_4800 A=n_1033 B=n_2732 VSS=VSS VDD=VDD
Xg120639 NAND2X1 $PINS Z=n_4799 A=n_106 B=n_3384 VSS=VSS VDD=VDD
Xg120640 NAND2X1 $PINS Z=n_4798 A=n_106 B=n_2768 VSS=VSS VDD=VDD
Xg120641 NOR2X1 $PINS Z=n_4796 A=n_970 B=n_2125 VSS=VSS VDD=VDD
Xg120642 NAND2X1 $PINS Z=n_4795 A=n_106 B=n_2449 VSS=VSS VDD=VDD
Xg120643 OR2X1 $PINS Z=n_4794 A=n_1115 B=n_1108 VSS=VSS VDD=VDD
Xg120644 NAND2X1 $PINS Z=n_4793 A=n_1 B=n_1062 VSS=VSS VDD=VDD
Xg120645 NAND2X1 $PINS Z=n_4792 A=n_119 B=n_110 VSS=VSS VDD=VDD
Xg120646 NOR2X1 $PINS Z=n_4791 A=n_90 B=n_84 VSS=VSS VDD=VDD
Xg120647 INVX2 $PINS Z=n_3322 A=n_3323 VSS=VSS VDD=VDD
Xg120648 INVX2 $PINS Z=n_3291 A=n_3298 VSS=VSS VDD=VDD
Xg120649 INVX2 $PINS Z=n_3288 A=n_3290 VSS=VSS VDD=VDD
Xg120650 INVX2 $PINS Z=n_3277 A=n_3278 VSS=VSS VDD=VDD
Xg120651 INVX2 $PINS Z=n_3272 A=spi_inst_cs_sync2 VSS=VSS VDD=VDD
Xg120652 NAND2X1 $PINS Z=n_3270 A=n_79 B=des_output[59] VSS=VSS VDD=VDD
Xg120653 NAND2X1 $PINS Z=n_3269 A=n_191 B=key_reg[14] VSS=VSS VDD=VDD
Xg120654 NAND2X1 $PINS Z=n_3268 A=n_191 B=key_reg[43] VSS=VSS VDD=VDD
Xg120655 OR2X1 $PINS Z=n_3266 A=key_reg[33] B=n_191 VSS=VSS VDD=VDD
Xg120656 NAND2X1 $PINS Z=n_3264 A=n_191 B=key_reg[51] VSS=VSS VDD=VDD
Xg120657 NAND2X1 $PINS Z=n_3263 A=n_191 B=key_reg[1] VSS=VSS VDD=VDD
Xg120658 NAND2X1 $PINS Z=n_3260 A=n_191 B=key_reg[33] VSS=VSS VDD=VDD
Xg120659 NAND2X1 $PINS Z=n_3257 A=n_79 B=des_output[19] VSS=VSS VDD=VDD
Xg120660 NAND2X1 $PINS Z=n_3256 A=n_79 B=des_output[3] VSS=VSS VDD=VDD
Xg120661 NAND2X1 $PINS Z=n_3255 A=n_79 B=des_output[26] VSS=VSS VDD=VDD
Xg120662 NAND2X1 $PINS Z=n_3254 A=n_79 B=des_output[1] VSS=VSS VDD=VDD
Xg120663 NAND2X1 $PINS Z=n_3253 A=n_79 B=des_output[60] VSS=VSS VDD=VDD
Xg120664 NAND2X1 $PINS Z=n_3252 A=n_79 B=des_output[29] VSS=VSS VDD=VDD
Xg120665 NAND2X1 $PINS Z=n_3251 A=n_79 B=des_output[62] VSS=VSS VDD=VDD
Xg120666 NAND2X1 $PINS Z=n_3250 A=n_79 B=des_output[18] VSS=VSS VDD=VDD
Xg120667 NAND2X1 $PINS Z=n_3249 A=n_79 B=des_output[55] VSS=VSS VDD=VDD
Xg120668 NAND2X1 $PINS Z=n_3246 A=n_79 B=des_output[20] VSS=VSS VDD=VDD
Xg120669 NAND2X1 $PINS Z=n_3245 A=n_79 B=des_output[31] VSS=VSS VDD=VDD
Xg120670 NAND2X1 $PINS Z=n_3244 A=n_79 B=des_output[36] VSS=VSS VDD=VDD
Xg120671 NAND2X1 $PINS Z=n_3241 A=n_79 B=des_output[54] VSS=VSS VDD=VDD
Xg120672 NAND2X1 $PINS Z=n_3240 A=n_79 B=des_output[39] VSS=VSS VDD=VDD
Xg120673 NAND2X1 $PINS Z=n_3239 A=n_79 B=des_output[33] VSS=VSS VDD=VDD
Xg120674 NAND2X1 $PINS Z=n_3237 A=n_79 B=des_output[51] VSS=VSS VDD=VDD
Xg120675 NAND2X1 $PINS Z=n_3236 A=n_79 B=des_output[22] VSS=VSS VDD=VDD
Xg120676 NAND2X1 $PINS Z=n_3233 A=n_79 B=des_output[6] VSS=VSS VDD=VDD
Xg120677 NAND2X1 $PINS Z=n_3231 A=n_79 B=des_output[38] VSS=VSS VDD=VDD
Xg120678 NAND2X1 $PINS Z=n_3230 A=n_79 B=des_output[2] VSS=VSS VDD=VDD
Xg120679 NAND2X1 $PINS Z=n_3228 A=n_79 B=des_output[14] VSS=VSS VDD=VDD
Xg120680 NAND2X1 $PINS Z=n_3219 A=n_79 B=des_output[12] VSS=VSS VDD=VDD
Xg120681 NAND2X1 $PINS Z=n_3215 A=n_79 B=des_output[27] VSS=VSS VDD=VDD
Xg120682 NAND2X1 $PINS Z=n_3211 A=n_79 B=des_output[28] VSS=VSS VDD=VDD
Xg120683 NAND2X1 $PINS Z=n_3206 A=n_79 B=des_output[15] VSS=VSS VDD=VDD
Xg120684 NAND2X1 $PINS Z=n_3201 A=n_79 B=des_output[42] VSS=VSS VDD=VDD
Xg120685 NAND2X1 $PINS Z=n_3198 A=n_79 B=des_output[45] VSS=VSS VDD=VDD
Xg120686 NAND2X1 $PINS Z=n_3191 A=n_79 B=des_output[23] VSS=VSS VDD=VDD
Xg120687 NAND2X1 $PINS Z=n_3189 A=n_79 B=des_output[4] VSS=VSS VDD=VDD
Xg120688 NAND2X1 $PINS Z=n_3188 A=n_79 B=des_output[63] VSS=VSS VDD=VDD
Xg120689 NAND2X1 $PINS Z=n_3180 A=n_79 B=des_output[37] VSS=VSS VDD=VDD
Xg120690 NAND2X1 $PINS Z=n_3179 A=n_79 B=des_output[32] VSS=VSS VDD=VDD
Xg120691 NAND2X1 $PINS Z=n_3177 A=n_79 B=des_output[44] VSS=VSS VDD=VDD
Xg120692 NAND2X1 $PINS Z=n_3175 A=n_191 B=key_reg[10] VSS=VSS VDD=VDD
Xg120693 NAND2X1 $PINS Z=n_3174 A=n_79 B=des_output[34] VSS=VSS VDD=VDD
Xg120694 NAND2X1 $PINS Z=n_3173 A=n_79 B=des_output[0] VSS=VSS VDD=VDD
Xg120695 NAND2X1 $PINS Z=n_3172 A=n_79 B=des_output[40] VSS=VSS VDD=VDD
Xg120696 NAND2X1 $PINS Z=n_3170 A=n_79 B=des_output[61] VSS=VSS VDD=VDD
Xg120697 NAND2X1 $PINS Z=n_3167 A=n_79 B=des_output[8] VSS=VSS VDD=VDD
Xg120698 NAND2X1 $PINS Z=n_3159 A=n_79 B=des_output[41] VSS=VSS VDD=VDD
Xg120699 NAND2X1 $PINS Z=n_3156 A=n_79 B=des_output[50] VSS=VSS VDD=VDD
Xg120700 NAND2X1 $PINS Z=n_3148 A=n_79 B=des_output[11] VSS=VSS VDD=VDD
Xg120701 NAND2X1 $PINS Z=n_3147 A=n_79 B=des_output[53] VSS=VSS VDD=VDD
Xg120702 NAND2X1 $PINS Z=n_3146 A=n_79 B=des_output[21] VSS=VSS VDD=VDD
Xg120703 NAND2X1 $PINS Z=n_3144 A=n_79 B=des_output[52] VSS=VSS VDD=VDD
Xg120704 NAND2X1 $PINS Z=n_3143 A=n_79 B=des_output[43] VSS=VSS VDD=VDD
Xg120705 NAND2X1 $PINS Z=n_3139 A=n_79 B=des_output[49] VSS=VSS VDD=VDD
Xg120706 NAND2X1 $PINS Z=n_3134 A=n_79 B=des_output[48] VSS=VSS VDD=VDD
Xg120707 NAND2X1 $PINS Z=n_3130 A=n_79 B=des_output[7] VSS=VSS VDD=VDD
Xg120708 NAND2X1 $PINS Z=n_3129 A=n_79 B=des_output[16] VSS=VSS VDD=VDD
Xg120709 NAND2X1 $PINS Z=n_3126 A=n_79 B=des_output[13] VSS=VSS VDD=VDD
Xg120710 NAND2X1 $PINS Z=n_3125 A=n_79 B=des_output[9] VSS=VSS VDD=VDD
Xg120711 NAND2X1 $PINS Z=n_3123 A=n_79 B=des_output[5] VSS=VSS VDD=VDD
Xg120712 NAND2X1 $PINS Z=n_3117 A=n_79 B=des_output[25] VSS=VSS VDD=VDD
Xg120713 NAND2X1 $PINS Z=n_3105 A=n_79 B=des_output[10] VSS=VSS VDD=VDD
Xg120714 NAND2X1 $PINS Z=n_3034 A=n_79 B=des_output[35] VSS=VSS VDD=VDD
Xg120715 NAND2X1 $PINS Z=n_3033 A=n_79 B=des_output[56] VSS=VSS VDD=VDD
Xg120716 NAND2X1 $PINS Z=n_3025 A=n_79 B=des_output[46] VSS=VSS VDD=VDD
Xg120717 NAND2X1 $PINS Z=n_3024 A=n_79 B=des_output[57] VSS=VSS VDD=VDD
Xg120718 NAND2X1 $PINS Z=n_3021 A=n_79 B=des_output[24] VSS=VSS VDD=VDD
Xg120719 NAND2X1 $PINS Z=n_3020 A=n_79 B=des_output[58] VSS=VSS VDD=VDD
Xg120720 NAND2X1 $PINS Z=n_3018 A=n_79 B=des_output[17] VSS=VSS VDD=VDD
Xg120721 NAND2X1 $PINS Z=n_3015 A=n_79 B=des_output[30] VSS=VSS VDD=VDD
Xg120722 NAND2X1 $PINS Z=n_3006 A=n_79 B=des_output[47] VSS=VSS VDD=VDD
Xg120723 NAND2X1 $PINS Z=n_2915 A=n_194 B=key_reg[26] VSS=VSS VDD=VDD
Xg120724 NAND2X1 $PINS Z=n_2858 A=n_194 B=key_reg[58] VSS=VSS VDD=VDD
Xg120725 OR2X1 $PINS Z=n_2845 A=key_reg[41] B=n_194 VSS=VSS VDD=VDD
Xg120726 NAND2X1 $PINS Z=n_2790 A=n_195 B=key_reg[58] VSS=VSS VDD=VDD
Xg120727 NAND2X1 $PINS Z=n_2788 A=n_194 B=key_reg[17] VSS=VSS VDD=VDD
Xg120728 OR2X1 $PINS Z=n_2785 A=key_reg[43] B=n_194 VSS=VSS VDD=VDD
Xg120729 NAND2X1 $PINS Z=n_3429 A=n_642 B=n_424 VSS=VSS VDD=VDD
Xg120730 NAND2X1 $PINS Z=n_3427 A=n_231 B=key_reg[11] VSS=VSS VDD=VDD
Xg120731 NAND2X1 $PINS Z=n_3426 A=n_455 B=n_525 VSS=VSS VDD=VDD
Xg120732 NAND2X1 $PINS Z=n_3425 A=n_194 B=key_reg[27] VSS=VSS VDD=VDD
Xg120733 NAND2X1 $PINS Z=n_3417 A=n_507 B=n_393 VSS=VSS VDD=VDD
Xg120734 NAND2X1 $PINS Z=n_3416 A=n_639 B=n_251 VSS=VSS VDD=VDD
Xg120735 NAND2X1 $PINS Z=n_3413 A=n_482 B=n_307 VSS=VSS VDD=VDD
Xg120736 NAND2X1 $PINS Z=n_3412 A=n_743 B=n_321 VSS=VSS VDD=VDD
Xg120737 NAND2X1 $PINS Z=n_3410 A=n_674 B=n_313 VSS=VSS VDD=VDD
Xg120738 NAND2X1 $PINS Z=n_3408 A=n_526 B=n_393 VSS=VSS VDD=VDD
Xg120739 NAND2X1 $PINS Z=n_3405 A=n_743 B=n_281 VSS=VSS VDD=VDD
Xg120740 NAND2X1 $PINS Z=n_3403 A=n_512 B=n_886 VSS=VSS VDD=VDD
Xg120741 NAND2X1 $PINS Z=n_3402 A=n_539 B=n_888 VSS=VSS VDD=VDD
Xg120742 NAND2X1 $PINS Z=n_3400 A=n_593 B=n_402 VSS=VSS VDD=VDD
Xg120743 NAND2X1 $PINS Z=n_3399 A=n_317 B=n_482 VSS=VSS VDD=VDD
Xg120744 NAND2X1 $PINS Z=n_3398 A=n_504 B=n_396 VSS=VSS VDD=VDD
Xg120745 NAND2X1 $PINS Z=n_3397 A=n_309 B=n_512 VSS=VSS VDD=VDD
Xg120746 NAND2X1 $PINS Z=n_3393 A=n_605 B=n_391 VSS=VSS VDD=VDD
Xg120747 NAND2X1 $PINS Z=n_3392 A=n_846 B=n_253 VSS=VSS VDD=VDD
Xg120748 NAND2X1 $PINS Z=n_3391 A=n_633 B=n_396 VSS=VSS VDD=VDD
Xg120749 NAND2X1 $PINS Z=n_3390 A=n_547 B=n_307 VSS=VSS VDD=VDD
Xg120750 NAND2X1 $PINS Z=n_3389 A=n_399 B=n_542 VSS=VSS VDD=VDD
Xg120751 NAND2X1 $PINS Z=n_3388 A=n_312 B=n_515 VSS=VSS VDD=VDD
Xg120752 NAND2X1 $PINS Z=n_3387 A=n_833 B=n_265 VSS=VSS VDD=VDD
Xg120753 NAND2X1 $PINS Z=n_3386 A=n_728 B=n_443 VSS=VSS VDD=VDD
Xg120754 NAND2X1 $PINS Z=n_3385 A=n_399 B=n_624 VSS=VSS VDD=VDD
Xg120755 NAND2X1 $PINS Z=n_3384 A=n_780 B=n_398 VSS=VSS VDD=VDD
Xg120756 NAND2X1 $PINS Z=n_3383 A=n_710 B=n_888 VSS=VSS VDD=VDD
Xg120757 NAND2X1 $PINS Z=n_3382 A=n_539 B=n_437 VSS=VSS VDD=VDD
Xg120758 NAND2X1 $PINS Z=n_3359 A=n_767 B=n_309 VSS=VSS VDD=VDD
Xg120760 NAND2X1 $PINS Z=n_3358 A=n_721 B=n_372 VSS=VSS VDD=VDD
Xg120761 NAND2X1 $PINS Z=n_3348 A=n_836 B=n_250 VSS=VSS VDD=VDD
Xg120762 NAND2X1 $PINS Z=n_3340 A=n_846 B=n_443 VSS=VSS VDD=VDD
Xg120763 NAND2X1 $PINS Z=n_3338 A=n_859 B=n_318 VSS=VSS VDD=VDD
Xg120764 NAND2X1 $PINS Z=n_3335 A=n_577 B=n_321 VSS=VSS VDD=VDD
Xg120765 NAND2X1 $PINS Z=n_3334 A=n_855 B=n_389 VSS=VSS VDD=VDD
Xg120766 NAND2X1 $PINS Z=n_3333 A=n_859 B=n_271 VSS=VSS VDD=VDD
Xg120767 NAND2X1 $PINS Z=n_3332 A=n_619 B=n_286 VSS=VSS VDD=VDD
Xg120768 NAND2X1 $PINS Z=n_3331 A=n_627 B=n_325 VSS=VSS VDD=VDD
Xg120769 NAND2X1 $PINS Z=n_3330 A=n_525 B=n_401 VSS=VSS VDD=VDD
Xg120770 NAND2X1 $PINS Z=n_3329 A=n_542 B=n_248 VSS=VSS VDD=VDD
Xg120771 NAND2X1 $PINS Z=n_3328 A=n_780 B=n_278 VSS=VSS VDD=VDD
Xg120772 NAND2X1 $PINS Z=n_3327 A=n_648 B=n_311 VSS=VSS VDD=VDD
Xg120773 NAND2X1 $PINS Z=n_3326 A=n_400 B=n_603 VSS=VSS VDD=VDD
Xg120774 NAND2X1 $PINS Z=n_3325 A=n_577 B=n_281 VSS=VSS VDD=VDD
Xg120775 NAND2X1 $PINS Z=n_3324 A=n_515 B=n_307 VSS=VSS VDD=VDD
Xg120776 NAND2X1 $PINS Z=n_3323 A=n_537 B=n_393 VSS=VSS VDD=VDD
Xg120777 NAND2X1 $PINS Z=n_3321 A=n_603 B=n_251 VSS=VSS VDD=VDD
Xg120778 NAND2X1 $PINS Z=n_3319 A=n_728 B=n_888 VSS=VSS VDD=VDD
Xg120779 NAND2X1 $PINS Z=n_3318 A=n_721 B=n_250 VSS=VSS VDD=VDD
Xg120780 NAND2X1 $PINS Z=n_3316 A=n_536 B=n_455 VSS=VSS VDD=VDD
Xg120781 NAND2X1 $PINS Z=n_3315 A=n_400 B=n_500 VSS=VSS VDD=VDD
Xg120782 NAND2X1 $PINS Z=n_3314 A=n_463 B=spi_inst_bit_count[2] VSS=VSS VDD=VDD
Xg120783 NAND2X1 $PINS Z=n_3313 A=n_821 B=n_397 VSS=VSS VDD=VDD
Xg120784 NAND2X1 $PINS Z=n_3311 A=n_314 B=n_860 VSS=VSS VDD=VDD
Xg120785 NAND2X1 $PINS Z=n_3310 A=n_665 B=n_398 VSS=VSS VDD=VDD
Xg120786 NAND2X1 $PINS Z=n_3309 A=n_695 B=n_455 VSS=VSS VDD=VDD
Xg120787 NAND2X1 $PINS Z=n_3308 A=n_836 B=n_313 VSS=VSS VDD=VDD
Xg120788 NAND2X1 $PINS Z=n_3307 A=n_391 B=n_593 VSS=VSS VDD=VDD
Xg120789 NAND2X1 $PINS Z=n_3304 A=n_295 B=n_737 VSS=VSS VDD=VDD
Xg120790 NAND2X1 $PINS Z=n_3303 A=n_603 B=n_318 VSS=VSS VDD=VDD
Xg120791 NAND2X1 $PINS Z=n_3302 A=n_314 B=n_540 VSS=VSS VDD=VDD
Xg120792 NAND2X1 $PINS Z=n_3298 A=n_624 B=n_389 VSS=VSS VDD=VDD
Xg120793 NOR2X1 $PINS Z=n_3290 A=csm_inst_state[0] B=n_247 VSS=VSS VDD=VDD
Xg120794 NAND2X1 $PINS Z=n_3281 A=n_535 B=n_313 VSS=VSS VDD=VDD
Xg120795 NAND2X1 $PINS Z=n_3280 A=n_500 B=n_421 VSS=VSS VDD=VDD
Xg120796 NAND2X1 $PINS Z=n_3278 A=n_246 B=n_472 VSS=VSS VDD=VDD
Xg120798 AND2X1 $PINS Z=n_3271 A=n_476 B=csm_inst_round_counter[1] VSS=VSS
+ VDD=VDD
Xg120799 INVX2 $PINS Z=n_2426 A=n_2427 VSS=VSS VDD=VDD
Xg120800 INVX2 $PINS Z=n_1588 A=n_1591 VSS=VSS VDD=VDD
Xg120801 INVX2 $PINS Z=n_1258 A=n_1260 VSS=VSS VDD=VDD
Xg120802 INVX2 $PINS Z=n_1192 A=n_1202 VSS=VSS VDD=VDD
Xg120803 INVX2 $PINS Z=n_1178 A=n_1181 VSS=VSS VDD=VDD
Xg120804 INVX2 $PINS Z=n_1160 A=n_1162 VSS=VSS VDD=VDD
Xg120805 INVX2 $PINS Z=n_1115 A=n_1119 VSS=VSS VDD=VDD
Xg120811 INVX2 $PINS Z=n_1074 A=n_131 VSS=VSS VDD=VDD
Xg120836 INVX2 $PINS Z=n_121 A=n_1062 VSS=VSS VDD=VDD
Xg120856 INVX2 $PINS Z=n_120 A=n_119 VSS=VSS VDD=VDD
Xg120873 INVX2 $PINS Z=n_117 A=n_1 VSS=VSS VDD=VDD
Xg120889 INVX2 $PINS Z=n_110 A=n_116 VSS=VSS VDD=VDD
Xg120896 INVX2 $PINS Z=n_1055 A=n_106 VSS=VSS VDD=VDD
Xg120913 INVX2 $PINS Z=n_101 A=n_1033 VSS=VSS VDD=VDD
Xg120920 INVX2 $PINS Z=n_1027 A=n_890 VSS=VSS VDD=VDD
Xg120939 INVX4 $PINS Z=n_90 A=n_87 VSS=VSS VDD=VDD
Xg120950 INVX2 $PINS Z=n_1016 A=n_84 VSS=VSS VDD=VDD
Xg120951 NAND2X1 $PINS Z=n_1004 A=n_195 B=key_reg[53] VSS=VSS VDD=VDD
Xg120952 NAND2X1 $PINS Z=n_983 A=n_484 B=n_82 VSS=VSS VDD=VDD
Xg120953 NOR2X1 $PINS Z=n_970 A=csm_inst_round_counter[0] B=n_487 VSS=VSS
+ VDD=VDD
Xg120954 OR2X1 $PINS Z=n_969 A=key_reg[52] B=n_195 VSS=VSS VDD=VDD
Xg120955 NAND2X1 $PINS Z=n_962 A=n_188 B=active VSS=VSS VDD=VDD
Xg120956 NAND2X1 $PINS Z=n_940 A=n_231 B=key_reg[1] VSS=VSS VDD=VDD
Xg120957 NAND3X1 $PINS Z=n_933 A=n_186 B=n_159 C=spi_inst_bit_count[6] VSS=VSS
+ VDD=VDD
Xg120958 OR2X1 $PINS Z=n_931 A=key_reg[33] B=n_195 VSS=VSS VDD=VDD
Xg120959 NAND2X1 $PINS Z=n_914 A=n_231 B=key_reg[41] VSS=VSS VDD=VDD
Xg120960 OR2X1 $PINS Z=n_893 A=key_reg[36] B=n_231 VSS=VSS VDD=VDD
Xg120961 NAND2X1 $PINS Z=n_2768 A=n_535 B=n_458 VSS=VSS VDD=VDD
Xg120962 NAND2X1 $PINS Z=n_2732 A=n_286 B=n_498 VSS=VSS VDD=VDD
Xg120963 NAND2X1 $PINS Z=n_2701 A=n_721 B=n_267 VSS=VSS VDD=VDD
Xg120964 NAND2X1 $PINS Z=n_2699 A=n_728 B=n_253 VSS=VSS VDD=VDD
Xg120965 NAND2X1 $PINS Z=n_2696 A=n_546 B=n_311 VSS=VSS VDD=VDD
Xg120966 NAND2X1 $PINS Z=n_2694 A=n_605 B=n_402 VSS=VSS VDD=VDD
Xg120967 NAND2X1 $PINS Z=n_2691 A=n_536 B=n_401 VSS=VSS VDD=VDD
Xg120968 NAND2X1 $PINS Z=n_2687 A=n_325 B=n_495 VSS=VSS VDD=VDD
Xg120969 NAND2X1 $PINS Z=n_2682 A=n_195 B=key_reg[27] VSS=VSS VDD=VDD
Xg120970 NAND2X1 $PINS Z=n_2675 A=n_674 B=n_250 VSS=VSS VDD=VDD
Xg120971 AND2X1 $PINS Z=n_2672 A=n_476 B=n_193 VSS=VSS VDD=VDD
Xg120972 OR2X1 $PINS Z=n_2580 A=key_reg[49] B=n_231 VSS=VSS VDD=VDD
Xg120973 NAND2X1 $PINS Z=n_2578 A=n_710 B=n_454 VSS=VSS VDD=VDD
Xg120974 NAND3X1 $PINS Z=n_2563 A=n_157 B=n_177 C=csm_inst_state[2] VSS=VSS
+ VDD=VDD
Xg120975 NAND2X1 $PINS Z=n_2532 A=n_767 B=n_886 VSS=VSS VDD=VDD
Xg120976 NAND2X1 $PINS Z=n_2511 A=n_507 B=n_326 VSS=VSS VDD=VDD
Xg120977 NAND2X1 $PINS Z=n_2506 A=n_737 B=n_305 VSS=VSS VDD=VDD
Xg120978 NAND2X1 $PINS Z=n_2491 A=n_853 B=n_308 VSS=VSS VDD=VDD
Xg120979 NAND2X1 $PINS Z=n_2449 A=n_633 B=n_271 VSS=VSS VDD=VDD
Xg120980 NAND2X1 $PINS Z=n_2427 A=n_639 B=n_421 VSS=VSS VDD=VDD
Xg120981 NAND2X1 $PINS Z=n_2377 A=n_860 B=n_435 VSS=VSS VDD=VDD
Xg120982 NAND2X1 $PINS Z=n_2259 A=n_821 B=n_305 VSS=VSS VDD=VDD
Xg120983 NAND2X1 $PINS Z=n_2230 A=n_780 B=n_432 VSS=VSS VDD=VDD
Xg120984 NAND2X1 $PINS Z=n_2140 A=n_444 B=n_642 VSS=VSS VDD=VDD
Xg120985 NAND2X1 $PINS Z=n_2128 A=n_500 B=n_251 VSS=VSS VDD=VDD
Xg120986 AND2X1 $PINS Z=n_2125 A=n_180 B=n_247 VSS=VSS VDD=VDD
Xg120987 NAND2X1 $PINS Z=n_2113 A=n_532 B=n_281 VSS=VSS VDD=VDD
Xg120988 NAND2X1 $PINS Z=n_2108 A=n_526 B=n_267 VSS=VSS VDD=VDD
Xg120989 NAND2X1 $PINS Z=n_2091 A=n_593 B=n_886 VSS=VSS VDD=VDD
Xg120990 NAND2X1 $PINS Z=n_2084 A=n_504 B=n_271 VSS=VSS VDD=VDD
Xg120991 NAND2X1 $PINS Z=n_2080 A=n_514 B=n_317 VSS=VSS VDD=VDD
Xg120992 NAND2X1 $PINS Z=n_2073 A=n_536 B=n_883 VSS=VSS VDD=VDD
Xg120993 NAND2X1 $PINS Z=n_2060 A=n_859 B=n_400 VSS=VSS VDD=VDD
Xg120994 NAND2X1 $PINS Z=n_2057 A=n_539 B=n_454 VSS=VSS VDD=VDD
Xg120995 NAND2X1 $PINS Z=n_2028 A=n_525 B=n_432 VSS=VSS VDD=VDD
Xg120996 NAND2X1 $PINS Z=n_1983 A=n_544 B=n_397 VSS=VSS VDD=VDD
Xg120997 NAND2X1 $PINS Z=n_1982 A=n_312 B=n_547 VSS=VSS VDD=VDD
Xg120998 AND2X1 $PINS Z=n_1981 A=n_190 B=n_193 VSS=VSS VDD=VDD
Xg120999 NAND2X1 $PINS Z=n_1886 A=n_619 B=n_454 VSS=VSS VDD=VDD
Xg121000 NAND2X1 $PINS Z=n_1879 A=n_404 B=n_494 VSS=VSS VDD=VDD
Xg121001 NAND2X1 $PINS Z=n_1847 A=n_515 B=n_311 VSS=VSS VDD=VDD
Xg121002 NAND2X1 $PINS Z=n_1838 A=n_695 B=n_398 VSS=VSS VDD=VDD
Xg121003 NAND2X1 $PINS Z=n_1790 A=n_404 B=n_846 VSS=VSS VDD=VDD
Xg121004 NAND2X1 $PINS Z=n_1751 A=n_295 B=n_637 VSS=VSS VDD=VDD
Xg121005 NAND2X1 $PINS Z=n_1704 A=n_672 B=n_389 VSS=VSS VDD=VDD
Xg121006 NAND2X1 $PINS Z=n_1693 A=n_637 B=n_883 VSS=VSS VDD=VDD
Xg121007 NAND2X1 $PINS Z=n_1688 A=n_743 B=n_314 VSS=VSS VDD=VDD
Xg121008 NAND2X1 $PINS Z=n_1678 A=n_507 B=n_258 VSS=VSS VDD=VDD
Xg121009 NAND2X1 $PINS Z=n_1676 A=n_394 B=n_672 VSS=VSS VDD=VDD
Xg121010 NAND2X1 $PINS Z=n_1673 A=n_722 B=n_883 VSS=VSS VDD=VDD
Xg121011 NAND2X1 $PINS Z=n_1614 A=n_458 B=n_674 VSS=VSS VDD=VDD
Xg121012 NAND2X1 $PINS Z=n_1613 A=n_665 B=n_278 VSS=VSS VDD=VDD
Xg121013 AND2X1 $PINS Z=n_1609 A=n_541 B=n_326 VSS=VSS VDD=VDD
Xg121014 NAND2X1 $PINS Z=n_1607 A=n_535 B=n_421 VSS=VSS VDD=VDD
Xg121015 AND2X1 $PINS Z=n_1605 A=n_514 B=n_315 VSS=VSS VDD=VDD
Xg121016 NAND2X1 $PINS Z=n_1599 A=n_833 B=n_392 VSS=VSS VDD=VDD
Xg121017 NAND2X1 $PINS Z=n_1597 A=n_532 B=n_404 VSS=VSS VDD=VDD
Xg121018 NAND2X1 $PINS Z=n_1593 A=n_637 B=n_305 VSS=VSS VDD=VDD
Xg121019 NAND2X1 $PINS Z=n_1591 A=n_648 B=n_248 VSS=VSS VDD=VDD
Xg121020 NAND2X1 $PINS Z=n_1587 A=n_532 B=n_284 VSS=VSS VDD=VDD
Xg121021 NAND2X1 $PINS Z=n_1582 A=n_855 B=n_324 VSS=VSS VDD=VDD
Xg121022 NAND2X1 $PINS Z=n_1581 A=n_627 B=n_435 VSS=VSS VDD=VDD
Xg121023 NAND2X1 $PINS Z=n_1580 A=n_405 B=n_860 VSS=VSS VDD=VDD
Xg121024 NAND2X1 $PINS Z=n_1579 A=n_605 B=n_394 VSS=VSS VDD=VDD
Xg121025 NAND2X1 $PINS Z=n_1578 A=n_619 B=n_437 VSS=VSS VDD=VDD
Xg121026 NAND2X1 $PINS Z=n_1576 A=n_494 B=n_443 VSS=VSS VDD=VDD
Xg121027 NAND2X1 $PINS Z=n_1572 A=n_542 B=n_324 VSS=VSS VDD=VDD
Xg121028 NAND2X1 $PINS Z=n_1569 A=n_665 B=n_325 VSS=VSS VDD=VDD
Xg121029 NAND2X1 $PINS Z=n_1555 A=n_821 B=n_444 VSS=VSS VDD=VDD
Xg121030 NAND2X1 $PINS Z=n_1456 A=n_546 B=n_248 VSS=VSS VDD=VDD
Xg121031 NAND2X1 $PINS Z=n_1444 A=n_833 B=n_308 VSS=VSS VDD=VDD
Xg121032 NAND2X1 $PINS Z=n_1422 A=n_642 B=n_265 VSS=VSS VDD=VDD
Xg121033 NAND2X1 $PINS Z=n_1421 A=n_284 B=n_494 VSS=VSS VDD=VDD
Xg121034 NAND2X1 $PINS Z=n_1419 A=n_577 B=n_284 VSS=VSS VDD=VDD
Xg121035 NAND2X1 $PINS Z=n_1417 A=n_526 B=n_372 VSS=VSS VDD=VDD
Xg121036 NAND2X1 $PINS Z=n_1414 A=n_624 B=n_324 VSS=VSS VDD=VDD
Xg121037 NAND2X1 $PINS Z=n_1413 A=n_495 B=n_278 VSS=VSS VDD=VDD
Xg121038 NAND2X1 $PINS Z=n_1410 A=n_540 B=n_405 VSS=VSS VDD=VDD
Xg121039 NAND2X1 $PINS Z=n_1409 A=n_498 B=n_308 VSS=VSS VDD=VDD
Xg121040 NAND2X1 $PINS Z=n_1403 A=n_541 B=n_258 VSS=VSS VDD=VDD
Xg121041 NAND2X1 $PINS Z=n_1398 A=n_504 B=n_315 VSS=VSS VDD=VDD
Xg121042 NAND2X1 $PINS Z=n_1397 A=n_695 B=n_432 VSS=VSS VDD=VDD
Xg121043 NAND2X1 $PINS Z=n_1394 A=n_495 B=n_435 VSS=VSS VDD=VDD
Xg121044 NAND2X1 $PINS Z=n_1393 A=n_853 B=n_392 VSS=VSS VDD=VDD
Xg121045 NAND2X1 $PINS Z=n_1390 A=n_547 B=n_317 VSS=VSS VDD=VDD
Xg121046 NAND2X1 $PINS Z=n_1385 A=n_767 B=n_391 VSS=VSS VDD=VDD
Xg121047 NAND2X1 $PINS Z=n_1375 A=n_672 B=n_402 VSS=VSS VDD=VDD
Xg121048 NAND2X1 $PINS Z=n_1366 A=n_394 B=n_855 VSS=VSS VDD=VDD
Xg121049 NAND2X1 $PINS Z=n_1350 A=n_397 B=n_737 VSS=VSS VDD=VDD
Xg121050 NAND2X1 $PINS Z=n_1338 A=n_537 B=n_267 VSS=VSS VDD=VDD
Xg121051 NAND2X1 $PINS Z=n_1328 A=n_710 B=n_253 VSS=VSS VDD=VDD
Xg121052 NAND2X1 $PINS Z=n_1319 A=n_738 B=n_424 VSS=VSS VDD=VDD
Xg121053 NAND2X1 $PINS Z=n_1318 A=n_541 B=n_309 VSS=VSS VDD=VDD
Xg121054 NAND2X1 $PINS Z=n_1306 A=n_326 B=n_512 VSS=VSS VDD=VDD
Xg121055 NAND2X1 $PINS Z=n_1300 A=n_546 B=n_312 VSS=VSS VDD=VDD
Xg121056 NAND2X1 $PINS Z=n_1295 A=n_648 B=n_399 VSS=VSS VDD=VDD
Xg121057 NAND2X1 $PINS Z=n_1293 A=n_458 B=n_639 VSS=VSS VDD=VDD
Xg121058 NAND2X1 $PINS Z=n_1291 A=n_544 B=n_444 VSS=VSS VDD=VDD
Xg121059 NAND2X1 $PINS Z=n_1289 A=n_627 B=n_405 VSS=VSS VDD=VDD
Xg121060 NAND2X1 $PINS Z=n_1285 A=n_738 B=n_265 VSS=VSS VDD=VDD
Xg121061 NAND2X1 $PINS Z=n_1276 A=n_295 B=n_722 VSS=VSS VDD=VDD
Xg121062 NAND2X1 $PINS Z=n_1274 A=n_633 B=n_318 VSS=VSS VDD=VDD
Xg121063 NAND2X1 $PINS Z=n_1269 A=n_836 B=n_372 VSS=VSS VDD=VDD
Xg121064 NAND2X1 $PINS Z=n_1260 A=n_537 B=n_258 VSS=VSS VDD=VDD
Xg121065 NAND2X1 $PINS Z=n_1242 A=n_315 B=n_482 VSS=VSS VDD=VDD
Xg121066 NAND2X1 $PINS Z=n_1233 A=n_722 B=n_401 VSS=VSS VDD=VDD
Xg121067 NAND2X1 $PINS Z=n_1227 A=n_321 B=n_540 VSS=VSS VDD=VDD
Xg121068 NAND2X1 $PINS Z=n_1218 A=n_498 B=n_437 VSS=VSS VDD=VDD
Xg121069 NAND2X1 $PINS Z=n_1214 A=n_514 B=n_396 VSS=VSS VDD=VDD
Xg121070 NAND2X1 $PINS Z=n_1208 A=n_853 B=n_286 VSS=VSS VDD=VDD
Xg121071 AND2X1 $PINS Z=n_1204 A=n_246 B=n_473 VSS=VSS VDD=VDD
Xg121072 NAND2X1 $PINS Z=n_1202 A=n_738 B=n_392 VSS=VSS VDD=VDD
Xg121073 NAND2X1 $PINS Z=n_1181 A=n_544 B=n_424 VSS=VSS VDD=VDD
Xg121074 AND2X1 $PINS Z=n_1164 A=n_190 B=n_479 VSS=VSS VDD=VDD
Xg121075 AND2X1 $PINS Z=n_1163 A=n_190 B=csm_inst_round_counter[1] VSS=VSS
+ VDD=VDD
Xg121076 NAND2X1 $PINS Z=n_1162 A=n_476 B=n_479 VSS=VSS VDD=VDD
Xg121077 NOR2X1 $PINS Z=n_1158 A=FE_DBTN2_csm_inst_round_counter_0 B=n_470
+ VSS=VSS VDD=VDD
Xg121078 NOR2X1 $PINS Z=n_1156 A=csm_inst_round_counter[0] B=n_470 VSS=VSS
+ VDD=VDD
Xg121079 AND2X1 $PINS Z=n_1149 A=n_476 B=n_477 VSS=VSS VDD=VDD
Xg121080 AND2X1 $PINS Z=n_1126 A=n_472 B=n_193 VSS=VSS VDD=VDD
Xg121081 NAND2X1 $PINS Z=n_1119 A=n_190 B=n_477 VSS=VSS VDD=VDD
Xg121082 AND2X1 $PINS Z=n_1108 A=n_473 B=n_193 VSS=VSS VDD=VDD
Xg121083 NOR2X1 $PINS Z=n_1101 A=FE_DBTN1_csm_inst_mode B=n_470 VSS=VSS VDD=VDD
Xg121084 NOR2X1 $PINS Z=n_1085 A=FE_DBTN1_csm_inst_mode B=n_80 VSS=VSS VDD=VDD
Xg121085 NOR2X1 $PINS Z=n_131 A=csm_inst_round_counter[2] B=n_478 VSS=VSS
+ VDD=VDD
Xg121086 NOR2X1 $PINS Z=n_126 A=csm_inst_mode B=n_470 VSS=VSS VDD=VDD
Xg121087 NAND2X1 $PINS Z=n_1062 A=n_246 B=n_190 VSS=VSS VDD=VDD
Xg121088 NAND2X1 $PINS Z=n_119 A=n_479 B=n_473 VSS=VSS VDD=VDD
Xg121090 AND2X1 $PINS Z=n_116 A=n_479 B=n_472 VSS=VSS VDD=VDD
Xg121091 AND2X1 $PINS Z=n_106 A=n_196 B=FE_DBTN2_csm_inst_round_counter_0
+ VSS=VSS VDD=VDD
Xg121092 NOR2X1 $PINS Z=n_1033 A=FE_DBTN2_csm_inst_round_counter_0 B=n_218
+ VSS=VSS VDD=VDD
Xg121093 NAND2X1 $PINS Z=n_890 A=n_197 B=FE_DBTN2_csm_inst_round_counter_0
+ VSS=VSS VDD=VDD
Xg121094 AND2X1 $PINS Z=n_1024 A=n_196 B=csm_inst_round_counter[0] VSS=VSS
+ VDD=VDD
Xg121095 OR2X1 $PINS Z=n_87 A=n_157 B=n_247 VSS=VSS VDD=VDD
Xg121096 NOR2X1 $PINS Z=n_84 A=csm_inst_state[0] B=n_487 VSS=VSS VDD=VDD
Xg121097 OR2X1 $PINS Z=n_1009 A=n_157 B=n_487 VSS=VSS VDD=VDD
Xg121098 INVX2 $PINS Z=n_487 A=n_484 VSS=VSS VDD=VDD
Xg121099 INVX2 $PINS Z=n_478 A=n_479 VSS=VSS VDD=VDD
Xg121106 INVX2 $PINS Z=n_470 A=n_82 VSS=VSS VDD=VDD
Xg121116 INVX2 $PINS Z=n_80 A=n_81 VSS=VSS VDD=VDD
Xg121117 NOR2X1 $PINS Z=n_467 A=spi_inst_bit_count[6] B=n_159 VSS=VSS VDD=VDD
Xg121118 NOR2X1 $PINS Z=n_465 A=start_encrypt B=n_179 VSS=VSS VDD=VDD
Xg121121 NAND2X1 $PINS Z=n_888 A=csm_inst_round_counter[3] B=key_reg[63]
+ VSS=VSS VDD=VDD
Xg121122 NAND2X1 $PINS Z=n_886 A=csm_inst_round_counter[3] B=key_reg[33]
+ VSS=VSS VDD=VDD
Xg121123 NAND2X1 $PINS Z=n_883 A=csm_inst_round_counter[3] B=key_reg[61]
+ VSS=VSS VDD=VDD
Xg121124 NAND2X1 $PINS Z=n_860 A=n_57 B=key_reg[15] VSS=VSS VDD=VDD
Xg121125 NAND2X1 $PINS Z=n_859 A=n_57 B=key_reg[25] VSS=VSS VDD=VDD
Xg121126 NAND2X1 $PINS Z=n_855 A=n_57 B=key_reg[50] VSS=VSS VDD=VDD
Xg121127 NAND2X1 $PINS Z=n_853 A=n_57 B=key_reg[13] VSS=VSS VDD=VDD
Xg121128 NAND2X1 $PINS Z=n_846 A=n_57 B=key_reg[61] VSS=VSS VDD=VDD
Xg121129 NAND2X1 $PINS Z=n_836 A=n_57 B=key_reg[44] VSS=VSS VDD=VDD
Xg121130 NAND2X1 $PINS Z=n_833 A=n_57 B=key_reg[5] VSS=VSS VDD=VDD
Xg121131 NAND2X1 $PINS Z=n_821 A=n_57 B=key_reg[38] VSS=VSS VDD=VDD
Xg121132 NAND2X1 $PINS Z=n_780 A=n_57 B=key_reg[47] VSS=VSS VDD=VDD
Xg121133 NAND2X1 $PINS Z=n_767 A=n_57 B=key_reg[19] VSS=VSS VDD=VDD
Xg121134 NAND2X1 $PINS Z=n_743 A=n_57 B=key_reg[28] VSS=VSS VDD=VDD
Xg121135 NAND2X1 $PINS Z=n_738 A=n_57 B=key_reg[62] VSS=VSS VDD=VDD
Xg121136 NAND2X1 $PINS Z=n_737 A=n_57 B=key_reg[30] VSS=VSS VDD=VDD
Xg121137 NAND2X1 $PINS Z=n_728 A=n_57 B=key_reg[53] VSS=VSS VDD=VDD
Xg121138 NAND2X1 $PINS Z=n_722 A=n_57 B=key_reg[14] VSS=VSS VDD=VDD
Xg121139 NAND2X1 $PINS Z=n_721 A=n_57 B=key_reg[36] VSS=VSS VDD=VDD
Xg121140 NAND2X1 $PINS Z=n_710 A=n_57 B=key_reg[45] VSS=VSS VDD=VDD
Xg121141 NAND2X1 $PINS Z=n_695 A=n_57 B=key_reg[55] VSS=VSS VDD=VDD
Xg121142 NAND2X1 $PINS Z=n_674 A=n_57 B=key_reg[52] VSS=VSS VDD=VDD
Xg121143 NAND2X1 $PINS Z=n_672 A=n_57 B=key_reg[58] VSS=VSS VDD=VDD
Xg121144 NAND2X1 $PINS Z=n_665 A=n_57 B=key_reg[39] VSS=VSS VDD=VDD
Xg121145 NAND2X1 $PINS Z=n_648 A=n_57 B=key_reg[26] VSS=VSS VDD=VDD
Xg121146 NAND2X1 $PINS Z=n_642 A=n_57 B=key_reg[54] VSS=VSS VDD=VDD
Xg121147 NAND2X1 $PINS Z=n_639 A=n_57 B=key_reg[1] VSS=VSS VDD=VDD
Xg121148 NAND2X1 $PINS Z=n_637 A=n_57 B=key_reg[22] VSS=VSS VDD=VDD
Xg121149 NAND2X1 $PINS Z=n_633 A=n_57 B=key_reg[33] VSS=VSS VDD=VDD
Xg121150 NAND2X1 $PINS Z=n_627 A=n_57 B=key_reg[23] VSS=VSS VDD=VDD
Xg121151 NAND2X1 $PINS Z=n_624 A=n_57 B=key_reg[42] VSS=VSS VDD=VDD
Xg121152 NAND2X1 $PINS Z=n_619 A=n_57 B=key_reg[29] VSS=VSS VDD=VDD
Xg121153 NAND2X1 $PINS Z=n_605 A=n_57 B=key_reg[3] VSS=VSS VDD=VDD
Xg121154 NAND2X1 $PINS Z=n_603 A=n_57 B=key_reg[17] VSS=VSS VDD=VDD
Xg121155 NAND2X1 $PINS Z=n_593 A=n_57 B=key_reg[11] VSS=VSS VDD=VDD
Xg121156 NAND2X1 $PINS Z=n_577 A=n_57 B=key_reg[20] VSS=VSS VDD=VDD
Xg121157 NAND2X1 $PINS Z=n_547 A=n_57 B=key_reg[2] VSS=VSS VDD=VDD
Xg121158 NAND2X1 $PINS Z=n_546 A=n_57 B=key_reg[18] VSS=VSS VDD=VDD
Xg121159 NAND2X1 $PINS Z=n_544 A=n_57 B=key_reg[46] VSS=VSS VDD=VDD
Xg121160 NAND2X1 $PINS Z=n_542 A=n_57 B=key_reg[34] VSS=VSS VDD=VDD
Xg121161 NAND2X1 $PINS Z=n_541 A=n_57 B=key_reg[35] VSS=VSS VDD=VDD
Xg121162 NAND2X1 $PINS Z=n_540 A=n_57 B=key_reg[7] VSS=VSS VDD=VDD
Xg121163 NAND2X1 $PINS Z=n_539 A=n_57 B=key_reg[37] VSS=VSS VDD=VDD
Xg121164 NAND2X1 $PINS Z=n_537 A=n_57 B=key_reg[51] VSS=VSS VDD=VDD
Xg121165 NAND2X1 $PINS Z=n_536 A=n_57 B=key_reg[6] VSS=VSS VDD=VDD
Xg121166 NAND2X1 $PINS Z=n_535 A=n_57 B=key_reg[60] VSS=VSS VDD=VDD
Xg121167 NAND2X1 $PINS Z=n_532 A=n_57 B=key_reg[12] VSS=VSS VDD=VDD
Xg121168 NAND2X1 $PINS Z=n_526 A=n_57 B=key_reg[59] VSS=VSS VDD=VDD
Xg121169 NAND2X1 $PINS Z=n_525 A=n_57 B=key_reg[63] VSS=VSS VDD=VDD
Xg121170 NAND2X1 $PINS Z=n_515 A=n_57 B=key_reg[10] VSS=VSS VDD=VDD
Xg121171 NAND2X1 $PINS Z=n_514 A=n_57 B=key_reg[49] VSS=VSS VDD=VDD
Xg121172 NAND2X1 $PINS Z=n_512 A=n_57 B=key_reg[27] VSS=VSS VDD=VDD
Xg121173 NAND2X1 $PINS Z=n_507 A=n_57 B=key_reg[43] VSS=VSS VDD=VDD
Xg121174 NAND2X1 $PINS Z=n_504 A=n_57 B=key_reg[41] VSS=VSS VDD=VDD
Xg121175 NAND2X1 $PINS Z=n_500 A=n_57 B=key_reg[9] VSS=VSS VDD=VDD
Xg121176 NAND2X1 $PINS Z=n_498 A=n_57 B=key_reg[21] VSS=VSS VDD=VDD
Xg121177 NAND2X1 $PINS Z=n_495 A=n_57 B=key_reg[31] VSS=VSS VDD=VDD
Xg121178 NAND2X1 $PINS Z=n_494 A=n_57 B=key_reg[4] VSS=VSS VDD=VDD
Xg121179 NOR2X1 $PINS Z=n_484 A=n_177 B=csm_inst_state[2] VSS=VSS VDD=VDD
Xg121180 NAND2X1 $PINS Z=n_482 A=n_57 B=key_reg[57] VSS=VSS VDD=VDD
Xg121181 NOR2X1 $PINS Z=n_479 A=n_165 B=csm_inst_mode VSS=VSS VDD=VDD
Xg121182 NOR2X1 $PINS Z=n_477 A=FE_DBTN1_csm_inst_mode
+ B=csm_inst_round_counter[1] VSS=VSS VDD=VDD
Xg121183 NOR2X1 $PINS Z=n_476 A=FE_DBTN2_csm_inst_round_counter_0
+ B=csm_inst_round_counter[2] VSS=VSS VDD=VDD
Xg121184 NOR2X1 $PINS Z=n_473 A=FE_DBTN2_csm_inst_round_counter_0 B=n_167
+ VSS=VSS VDD=VDD
Xg121185 NOR2X1 $PINS Z=n_472 A=n_167 B=csm_inst_round_counter[0] VSS=VSS
+ VDD=VDD
Xg121186 NOR2X1 $PINS Z=n_82 A=n_167 B=csm_inst_round_counter[1] VSS=VSS
+ VDD=VDD
Xg121187 NOR2X1 $PINS Z=n_81 A=n_165 B=csm_inst_round_counter[2] VSS=VSS
+ VDD=VDD
Xg121188 INVX2 $PINS Z=n_327 A=n_330 VSS=VSS VDD=VDD
Xg121189 INVX2 $PINS Z=n_197 A=n_218 VSS=VSS VDD=VDD
Xg121198 INVX2 $PINS Z=n_188 A=n_79 VSS=VSS VDD=VDD
Xg121208 NOR2X1 $PINS Z=n_187 A=start_decrypt B=crypt VSS=VSS VDD=VDD
Xg121209 NOR2X1 $PINS Z=n_186 A=spi_inst_bit_count[3] B=spi_inst_bit_count[4]
+ VSS=VSS VDD=VDD
Xg121210 NAND2X1 $PINS Z=n_184 A=active B=transaction_state[1] VSS=VSS VDD=VDD
Xg121211 NOR2X1 $PINS Z=n_182 A=spi_inst_bit_count[1] B=spi_inst_bit_count[2]
+ VSS=VSS VDD=VDD
Xg121212 OR2X1 $PINS Z=n_180 A=csm_inst_state[2] B=csm_inst_state[0] VSS=VSS
+ VDD=VDD
Xg121213 NOR2X1 $PINS Z=n_463 A=n_168 B=n_175 VSS=VSS VDD=VDD
Xg121214 NAND2X1 $PINS Z=n_458 A=csm_inst_round_counter[3] B=key_reg[42]
+ VSS=VSS VDD=VDD
Xg121215 NAND2X1 $PINS Z=n_455 A=csm_inst_round_counter[3] B=key_reg[45]
+ VSS=VSS VDD=VDD
Xg121216 NAND2X1 $PINS Z=n_454 A=csm_inst_round_counter[3] B=key_reg[55]
+ VSS=VSS VDD=VDD
Xg121217 NAND2X1 $PINS Z=n_444 A=csm_inst_round_counter[3] B=key_reg[28]
+ VSS=VSS VDD=VDD
Xg121218 NAND2X1 $PINS Z=n_443 A=csm_inst_round_counter[3] B=key_reg[14]
+ VSS=VSS VDD=VDD
Xg121219 NAND2X1 $PINS Z=n_437 A=csm_inst_round_counter[3] B=key_reg[47]
+ VSS=VSS VDD=VDD
Xg121220 NAND2X1 $PINS Z=n_435 A=csm_inst_round_counter[3] B=key_reg[5] VSS=VSS
+ VDD=VDD
Xg121221 NAND2X1 $PINS Z=n_432 A=csm_inst_round_counter[3] B=key_reg[37]
+ VSS=VSS VDD=VDD
Xg121222 NAND2X1 $PINS Z=n_424 A=csm_inst_round_counter[3] B=key_reg[7] VSS=VSS
+ VDD=VDD
Xg121223 NAND2X1 $PINS Z=n_421 A=csm_inst_round_counter[3] B=key_reg[50]
+ VSS=VSS VDD=VDD
Xg121224 NAND2X1 $PINS Z=n_405 A=csm_inst_round_counter[3] B=key_reg[62]
+ VSS=VSS VDD=VDD
Xg121225 NAND2X1 $PINS Z=n_404 A=csm_inst_round_counter[3] B=key_reg[22]
+ VSS=VSS VDD=VDD
Xg121226 NAND2X1 $PINS Z=n_402 A=csm_inst_round_counter[3] B=key_reg[17]
+ VSS=VSS VDD=VDD
Xg121227 NAND2X1 $PINS Z=n_401 A=csm_inst_round_counter[3] B=key_reg[53]
+ VSS=VSS VDD=VDD
Xg121228 NAND2X1 $PINS Z=n_400 A=csm_inst_round_counter[3] B=key_reg[3] VSS=VSS
+ VDD=VDD
Xg121229 NAND2X1 $PINS Z=n_399 A=csm_inst_round_counter[3] B=key_reg[52]
+ VSS=VSS VDD=VDD
Xg121230 NAND2X1 $PINS Z=n_398 A=csm_inst_round_counter[3] B=key_reg[29]
+ VSS=VSS VDD=VDD
Xg121231 NAND2X1 $PINS Z=n_397 A=csm_inst_round_counter[3] B=key_reg[20]
+ VSS=VSS VDD=VDD
Xg121232 NAND2X1 $PINS Z=n_396 A=csm_inst_round_counter[3] B=key_reg[27]
+ VSS=VSS VDD=VDD
Xg121233 NAND2X1 $PINS Z=n_394 A=csm_inst_round_counter[3] B=key_reg[9] VSS=VSS
+ VDD=VDD
Xg121234 NAND2X1 $PINS Z=n_393 A=csm_inst_round_counter[3] B=key_reg[2] VSS=VSS
+ VDD=VDD
Xg121235 NAND2X1 $PINS Z=n_392 A=csm_inst_round_counter[3] B=key_reg[23]
+ VSS=VSS VDD=VDD
Xg121236 NAND2X1 $PINS Z=n_391 A=csm_inst_round_counter[3] B=key_reg[25]
+ VSS=VSS VDD=VDD
Xg121237 NAND2X1 $PINS Z=n_389 A=csm_inst_round_counter[3] B=key_reg[1] VSS=VSS
+ VDD=VDD
Xg121238 NAND2X1 $PINS Z=n_372 A=csm_inst_round_counter[3] B=key_reg[18]
+ VSS=VSS VDD=VDD
Xg121239 NOR2X1 $PINS Z=n_330 A=start_encrypt B=start_decrypt VSS=VSS VDD=VDD
Xg121240 NAND2X1 $PINS Z=n_326 A=csm_inst_round_counter[3] B=key_reg[49]
+ VSS=VSS VDD=VDD
Xg121241 NAND2X1 $PINS Z=n_325 A=csm_inst_round_counter[3] B=key_reg[13]
+ VSS=VSS VDD=VDD
Xg121242 NAND2X1 $PINS Z=n_324 A=csm_inst_round_counter[3] B=key_reg[60]
+ VSS=VSS VDD=VDD
Xg121243 NAND2X1 $PINS Z=n_321 A=csm_inst_round_counter[3] B=key_reg[46]
+ VSS=VSS VDD=VDD
Xg121244 NAND2X1 $PINS Z=n_318 A=csm_inst_round_counter[3] B=key_reg[11]
+ VSS=VSS VDD=VDD
Xg121245 NAND2X1 $PINS Z=n_317 A=csm_inst_round_counter[3] B=key_reg[43]
+ VSS=VSS VDD=VDD
Xg121246 NAND2X1 $PINS Z=n_315 A=csm_inst_round_counter[3] B=key_reg[35]
+ VSS=VSS VDD=VDD
Xg121247 NAND2X1 $PINS Z=n_314 A=csm_inst_round_counter[3] B=key_reg[54]
+ VSS=VSS VDD=VDD
Xg121248 NAND2X1 $PINS Z=n_313 A=csm_inst_round_counter[3] B=key_reg[34]
+ VSS=VSS VDD=VDD
Xg121249 NAND2X1 $PINS Z=n_312 A=csm_inst_round_counter[3] B=key_reg[59]
+ VSS=VSS VDD=VDD
Xg121250 NAND2X1 $PINS Z=n_311 A=csm_inst_round_counter[3] B=key_reg[36]
+ VSS=VSS VDD=VDD
Xg121251 NAND2X1 $PINS Z=n_309 A=csm_inst_round_counter[3] B=key_reg[41]
+ VSS=VSS VDD=VDD
Xg121252 NAND2X1 $PINS Z=n_308 A=csm_inst_round_counter[3] B=key_reg[31]
+ VSS=VSS VDD=VDD
Xg121253 NAND2X1 $PINS Z=n_307 A=csm_inst_round_counter[3] B=key_reg[51]
+ VSS=VSS VDD=VDD
Xg121254 NAND2X1 $PINS Z=n_305 A=csm_inst_round_counter[3] B=key_reg[12]
+ VSS=VSS VDD=VDD
Xg121255 NAND2X1 $PINS Z=n_295 A=csm_inst_round_counter[3] B=key_reg[4] VSS=VSS
+ VDD=VDD
Xg121256 NAND2X1 $PINS Z=n_286 A=csm_inst_round_counter[3] B=key_reg[39]
+ VSS=VSS VDD=VDD
Xg121257 NAND2X1 $PINS Z=n_284 A=csm_inst_round_counter[3] B=key_reg[30]
+ VSS=VSS VDD=VDD
Xg121258 NAND2X1 $PINS Z=n_281 A=csm_inst_round_counter[3] B=key_reg[38]
+ VSS=VSS VDD=VDD
Xg121259 NAND2X1 $PINS Z=n_278 A=csm_inst_round_counter[3] B=key_reg[21]
+ VSS=VSS VDD=VDD
Xg121260 NAND2X1 $PINS Z=n_271 A=csm_inst_round_counter[3] B=key_reg[19]
+ VSS=VSS VDD=VDD
Xg121261 NAND2X1 $PINS Z=n_267 A=csm_inst_round_counter[3] B=key_reg[10]
+ VSS=VSS VDD=VDD
Xg121262 NAND2X1 $PINS Z=n_265 A=csm_inst_round_counter[3] B=key_reg[15]
+ VSS=VSS VDD=VDD
Xg121263 NAND2X1 $PINS Z=n_258 A=csm_inst_round_counter[3] B=key_reg[57]
+ VSS=VSS VDD=VDD
Xg121264 NAND2X1 $PINS Z=n_253 A=csm_inst_round_counter[3] B=key_reg[6] VSS=VSS
+ VDD=VDD
Xg121265 NAND2X1 $PINS Z=n_251 A=csm_inst_round_counter[3] B=key_reg[58]
+ VSS=VSS VDD=VDD
Xg121266 NAND2X1 $PINS Z=n_250 A=csm_inst_round_counter[3] B=key_reg[26]
+ VSS=VSS VDD=VDD
Xg121267 NAND2X1 $PINS Z=n_248 A=csm_inst_round_counter[3] B=key_reg[44]
+ VSS=VSS VDD=VDD
Xg121268 OR2X1 $PINS Z=n_247 A=csm_inst_state[2] B=csm_inst_state[1] VSS=VSS
+ VDD=VDD
Xg121269 NOR2X1 $PINS Z=n_246 A=csm_inst_mode B=csm_inst_round_counter[1]
+ VSS=VSS VDD=VDD
Xg121270 NOR2X1 $PINS Z=n_231 A=csm_inst_round_counter[0]
+ B=csm_inst_round_counter[3] VSS=VSS VDD=VDD
Xg121271 NAND2X1 $PINS Z=n_218 A=csm_inst_round_counter[2]
+ B=csm_inst_round_counter[1] VSS=VSS VDD=VDD
Xg121272 NOR2X1 $PINS Z=n_196 A=csm_inst_round_counter[2]
+ B=csm_inst_round_counter[1] VSS=VSS VDD=VDD
Xg121273 NOR2X1 $PINS Z=n_195 A=FE_DBTN2_csm_inst_round_counter_0
+ B=csm_inst_round_counter[3] VSS=VSS VDD=VDD
Xg121274 NOR2X1 $PINS Z=n_194 A=n_57 B=csm_inst_round_counter[0] VSS=VSS
+ VDD=VDD
Xg121275 NOR2X1 $PINS Z=n_193 A=FE_DBTN1_csm_inst_mode B=n_165 VSS=VSS VDD=VDD
Xg121276 NOR2X1 $PINS Z=n_191 A=FE_DBTN2_csm_inst_round_counter_0 B=n_57
+ VSS=VSS VDD=VDD
Xg121277 NOR2X1 $PINS Z=n_190 A=csm_inst_round_counter[2]
+ B=csm_inst_round_counter[0] VSS=VSS VDD=VDD
Xg121278 OR2X1 $PINS Z=n_79 A=done_encrypt B=done_decrypt VSS=VSS VDD=VDD
Xg121279 INVX2 $PINS Z=n_179 A=crypt VSS=VSS VDD=VDD
Xg121280 INVX2 $PINS Z=n_177 A=csm_inst_state[1] VSS=VSS VDD=VDD
Xg121282 INVX2 $PINS Z=n_175 A=spi_inst_bit_count[1] VSS=VSS VDD=VDD
Xg121283 INVX2 $PINS Z=n_173 A=transaction_state[0] VSS=VSS VDD=VDD
Xg121284 INVX2 $PINS Z=n_168 A=spi_inst_bit_count[0] VSS=VSS VDD=VDD
Xg121285 INVX2 $PINS Z=n_167 A=csm_inst_round_counter[2] VSS=VSS VDD=VDD
Xg121286 INVX2 $PINS Z=n_165 A=csm_inst_round_counter[1] VSS=VSS VDD=VDD
Xg121386 INVX4 $PINS Z=n_57 A=csm_inst_round_counter[3] VSS=VSS VDD=VDD
Xg121388 INVX2 $PINS Z=n_161 A=active VSS=VSS VDD=VDD
Xg121389 INVX2 $PINS Z=n_160 A=spi_inst_bit_count[3] VSS=VSS VDD=VDD
Xg121390 INVX2 $PINS Z=n_159 A=spi_inst_bit_count[5] VSS=VSS VDD=VDD
Xg121391 INVX2 $PINS Z=n_158 A=transaction_state[1] VSS=VSS VDD=VDD
Xg121392 INVX2 $PINS Z=n_157 A=csm_inst_state[0] VSS=VSS VDD=VDD
Xg121453 INVX2 $PINS Z=n_152 A=rst VSS=VSS VDD=VDD
Xdrc_bufs121518 INVX2 $PINS Z=n_135 A=n_4791 VSS=VSS VDD=VDD
Xg2 NAND2X1 $PINS Z=n_1 A=n_246 B=n_476 VSS=VSS VDD=VDD
Xg121571 MUX2X1 $PINS Z=n_0 A=crypt B=spi_rx_data[0] S=n_6158 VSS=VSS VDD=VDD
Xg121574 OR2X1 $PINS Z=n_8055 A=n_8054 B=n_7315 VSS=VSS VDD=VDD
Xg3 AND2X1 $PINS Z=n_8054 A=n_7247 B=n_7359 VSS=VSS VDD=VDD
Xg121575 NAND3X1 $PINS Z=n_8057 A=n_8056 B=n_6898 C=n_6909 VSS=VSS VDD=VDD
Xg121576 NOR2X1 $PINS Z=n_8056 A=n_7203 B=n_7319 VSS=VSS VDD=VDD
Xg121577 OR2X1 $PINS Z=n_8059 A=n_8058 B=n_7327 VSS=VSS VDD=VDD
Xg121578 AND2X1 $PINS Z=n_8058 A=n_7083 B=n_6905 VSS=VSS VDD=VDD
Xg121579 OR2X1 $PINS Z=n_8061 A=n_8060 B=n_7220 VSS=VSS VDD=VDD
Xg121580 AND2X1 $PINS Z=n_8060 A=n_6971 B=n_6942 VSS=VSS VDD=VDD
Xg121581 OR2X1 $PINS Z=n_8063 A=n_8062 B=n_6007 VSS=VSS VDD=VDD
Xg121582 NAND3X1 $PINS Z=n_8062 A=n_6516 B=n_5924 C=n_5022 VSS=VSS VDD=VDD
Xg121583 OR2X1 $PINS Z=n_8065 A=n_8064 B=n_5415 VSS=VSS VDD=VDD
Xg121584 AND2X1 $PINS Z=n_8064 A=n_3332 B=n_473 VSS=VSS VDD=VDD
Xg121585 NAND3X1 $PINS Z=n_8067 A=n_8066 B=spi_inst_active C=spi_inst_sclk_prev
+ VSS=VSS VDD=VDD
Xg121586 NOR2X1 $PINS Z=n_8066 A=spi_inst_sclk_sync2 B=spi_inst_bit_count[6]
+ VSS=VSS VDD=VDD
.ENDS

.SUBCKT top_pad clk rst sclk cs_n mosi miso
Xcore TopModule $PINS clk=clk_PAD rst=rst_PAD sclk=sclk_PAD cs_n=cs_n_PAD
+ mosi=mosi_PAD miso=miso_PAD VDD=VDD VSS=VSS
Xcorner0 pad_corner $PINS VSS=VSS VDD=VDD
Xcorner1 pad_corner $PINS VSS=VSS VDD=VDD
Xcorner2 pad_corner $PINS VSS=VSS VDD=VDD
Xcorner3 pad_corner $PINS VSS=VSS VDD=VDD
Xvdd0 pad_vdd $PINS VSS=VSS VDD=VDD
Xvss0 pad_gnd $PINS VSS=VSS VDD=VDD
Xclk_pad pad_in $PINS DataIn=clk_PAD pad=clk VSS=VSS VDD=VDD
Xcs_n_pad pad_in $PINS DataIn=cs_n_PAD pad=cs_n VSS=VSS VDD=VDD
Xmiso_pad pad_out $PINS pad=miso DataOut=miso_PAD VSS=VSS VDD=VDD
Xmosi_pad pad_in $PINS DataIn=mosi_PAD pad=mosi VSS=VSS VDD=VDD
Xrst_pad pad_in $PINS DataIn=rst_PAD pad=rst VSS=VSS VDD=VDD
Xsclk_pad pad_in $PINS DataIn=sclk_PAD pad=sclk VSS=VSS VDD=VDD
.ENDS
