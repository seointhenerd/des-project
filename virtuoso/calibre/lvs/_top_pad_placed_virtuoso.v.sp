$ Spice netlist generated by v2lvs
$ v2021.2_37.20    Tue Jun 1 14:42:15 PDT 2021
*.BUSDELIMITER [

.SUBCKT TopModule clk rst sclk cs_n mosi miso VDD VSS
XDIODE_14 ANTENNA $PINS A=n_3864 VSS=VSS VDD=VDD
XDIODE_13 ANTENNA $PINS A=sclk VSS=VSS VDD=VDD
XDIODE_12 ANTENNA $PINS A=sclk VSS=VSS VDD=VDD
XDIODE_11 ANTENNA $PINS A=clk VSS=VSS VDD=VDD
XDIODE_10 ANTENNA $PINS A=clk VSS=VSS VDD=VDD
XDIODE_9 ANTENNA $PINS A=n_3986 VSS=VSS VDD=VDD
XDIODE_8 ANTENNA $PINS A=n_3835 VSS=VSS VDD=VDD
XDIODE_7 ANTENNA $PINS A=n_3905 VSS=VSS VDD=VDD
XDIODE_6 ANTENNA $PINS A=n_3937 VSS=VSS VDD=VDD
XDIODE_5 ANTENNA $PINS A=n_3971 VSS=VSS VDD=VDD
XDIODE_4 ANTENNA $PINS A=n_3971 VSS=VSS VDD=VDD
XDIODE_3 ANTENNA $PINS A=n_3864 VSS=VSS VDD=VDD
XDIODE_2 ANTENNA $PINS A=n_3864 VSS=VSS VDD=VDD
XDIODE_1 ANTENNA $PINS A=n_3855 VSS=VSS VDD=VDD
XCTS_csf_buf_00160 BUFX1 $PINS Z=CTS_74 A=CTS_27 VSS=VSS VDD=VDD
XCTS_csf_buf_00159 BUFX1 $PINS Z=CTS_29 A=CTS_27 VSS=VSS VDD=VDD
XCTS_ccl_a_buf_00120 BUFX1 $PINS Z=CTS_27 A=CTS_75 VSS=VSS VDD=VDD
XCTS_ccl_a_buf_00116 BUFX1 $PINS Z=CTS_73 A=CTS_75 VSS=VSS VDD=VDD
XCTS_ccl_a_buf_00150 BUFX1 $PINS Z=CTS_75 A=CTS_76 VSS=VSS VDD=VDD
XCTS_cdb_buf_00170 BUFX1 $PINS Z=CTS_76 A=clk VSS=VSS VDD=VDD
XCTS_ccl_a_buf_00106 BUFX1 $PINS Z=CTS_72 A=CTS_67 VSS=VSS VDD=VDD
XCTS_cdb_buf_00167 BUFX1 $PINS Z=CTS_67 A=clk VSS=VSS VDD=VDD
XCTS_ccl_a_buf_00132 BUFX1 $PINS Z=CTS_61 A=CTS_57 VSS=VSS VDD=VDD
XCTS_cdb_buf_00173 BUFX1 $PINS Z=CTS_57 A=CTS_71 VSS=VSS VDD=VDD
XCTS_ccl_a_buf_00142 BUFX1 $PINS Z=CTS_60 A=CTS_71 VSS=VSS VDD=VDD
XCTS_ccl_a_buf_00141 BUFX1 $PINS Z=CTS_59 A=CTS_71 VSS=VSS VDD=VDD
XCTS_ccl_a_buf_00134 BUFX1 $PINS Z=CTS_58 A=CTS_71 VSS=VSS VDD=VDD
XCTS_ccl_a_buf_00133 BUFX1 $PINS Z=CTS_63 A=CTS_71 VSS=VSS VDD=VDD
XCTS_ccl_a_buf_00131 BUFX1 $PINS Z=CTS_70 A=CTS_71 VSS=VSS VDD=VDD
XCTS_ccl_a_buf_00156 BUFX1 $PINS Z=CTS_71 A=clk VSS=VSS VDD=VDD
XCTS_ccl_a_buf_00140 BUFX1 $PINS Z=CTS_53 A=CTS_54 VSS=VSS VDD=VDD
XCTS_cdb_buf_00172 BUFX1 $PINS Z=CTS_54 A=CTS_69 VSS=VSS VDD=VDD
XCTS_ccl_a_buf_00136 BUFX1 $PINS Z=CTS_52 A=CTS_69 VSS=VSS VDD=VDD
XCTS_ccl_a_buf_00124 BUFX1 $PINS Z=CTS_51 A=CTS_69 VSS=VSS VDD=VDD
XCTS_ccl_a_buf_00123 BUFX1 $PINS Z=CTS_56 A=CTS_69 VSS=VSS VDD=VDD
XCTS_ccl_a_buf_00115 BUFX1 $PINS Z=CTS_68 A=CTS_69 VSS=VSS VDD=VDD
XCTS_ccl_a_buf_00155 BUFX1 $PINS Z=CTS_69 A=clk VSS=VSS VDD=VDD
XCTS_ccl_a_buf_00139 BUFX1 $PINS Z=CTS_47 A=CTS_48 VSS=VSS VDD=VDD
XCTS_cdb_buf_00171 BUFX1 $PINS Z=CTS_48 A=CTS_66 VSS=VSS VDD=VDD
XCTS_ccl_a_buf_00128 BUFX1 $PINS Z=CTS_46 A=CTS_66 VSS=VSS VDD=VDD
XCTS_ccl_a_buf_00127 BUFX1 $PINS Z=CTS_50 A=CTS_66 VSS=VSS VDD=VDD
XCTS_ccl_a_buf_00118 BUFX1 $PINS Z=CTS_65 A=CTS_66 VSS=VSS VDD=VDD
XCTS_ccl_a_buf_00154 BUFX1 $PINS Z=CTS_66 A=clk VSS=VSS VDD=VDD
XCTS_ccl_a_buf_00138 BUFX1 $PINS Z=CTS_42 A=CTS_43 VSS=VSS VDD=VDD
XCTS_ccl_a_buf_00126 BUFX1 $PINS Z=CTS_41 A=CTS_43 VSS=VSS VDD=VDD
XCTS_ccl_a_buf_00122 BUFX1 $PINS Z=CTS_45 A=CTS_43 VSS=VSS VDD=VDD
XCTS_ccl_a_buf_00121 BUFX1 $PINS Z=CTS_64 A=CTS_43 VSS=VSS VDD=VDD
XCTS_ccl_a_buf_00153 BUFX1 $PINS Z=CTS_43 A=clk VSS=VSS VDD=VDD
XCTS_ccl_a_buf_00137 BUFX1 $PINS Z=CTS_37 A=CTS_38 VSS=VSS VDD=VDD
XCTS_ccl_a_buf_00135 BUFX1 $PINS Z=CTS_36 A=CTS_38 VSS=VSS VDD=VDD
XCTS_ccl_a_buf_00130 BUFX1 $PINS Z=CTS_40 A=CTS_38 VSS=VSS VDD=VDD
XCTS_ccl_a_buf_00129 BUFX1 $PINS Z=CTS_62 A=CTS_38 VSS=VSS VDD=VDD
XCTS_ccl_a_buf_00152 BUFX1 $PINS Z=CTS_38 A=clk VSS=VSS VDD=VDD
XCTS_ccl_a_buf_00125 BUFX1 $PINS Z=CTS_32 A=CTS_33 VSS=VSS VDD=VDD
XCTS_ccl_a_buf_00111 BUFX1 $PINS Z=CTS_31 A=CTS_33 VSS=VSS VDD=VDD
XCTS_ccl_a_buf_00110 BUFX1 $PINS Z=CTS_30 A=CTS_33 VSS=VSS VDD=VDD
XCTS_ccl_a_buf_00109 BUFX1 $PINS Z=CTS_35 A=CTS_33 VSS=VSS VDD=VDD
XCTS_ccl_a_buf_00108 BUFX1 $PINS Z=CTS_55 A=CTS_33 VSS=VSS VDD=VDD
XCTS_ccl_a_buf_00151 BUFX1 $PINS Z=CTS_33 A=clk VSS=VSS VDD=VDD
XCTS_ccl_a_buf_00119 BUFX1 $PINS Z=CTS_49 A=CTS_26 VSS=VSS VDD=VDD
XCTS_ccl_a_buf_00149 BUFX1 $PINS Z=CTS_26 A=clk VSS=VSS VDD=VDD
XCTS_ccl_a_buf_00117 BUFX1 $PINS Z=CTS_21 A=CTS_22 VSS=VSS VDD=VDD
XCTS_ccl_a_buf_00114 BUFX1 $PINS Z=CTS_20 A=CTS_22 VSS=VSS VDD=VDD
XCTS_ccl_a_buf_00107 BUFX1 $PINS Z=CTS_24 A=CTS_22 VSS=VSS VDD=VDD
XCTS_ccl_a_buf_00105 BUFX1 $PINS Z=CTS_44 A=CTS_22 VSS=VSS VDD=VDD
XCTS_ccl_a_buf_00148 BUFX1 $PINS Z=CTS_22 A=clk VSS=VSS VDD=VDD
XCTS_ccl_a_buf_00113 BUFX1 $PINS Z=CTS_16 A=CTS_17 VSS=VSS VDD=VDD
XCTS_ccl_a_buf_00112 BUFX1 $PINS Z=CTS_19 A=CTS_17 VSS=VSS VDD=VDD
XCTS_ccl_a_buf_00100 BUFX1 $PINS Z=CTS_34 A=CTS_17 VSS=VSS VDD=VDD
XCTS_cdb_buf_00169 BUFX1 $PINS Z=CTS_17 A=CTS_39 VSS=VSS VDD=VDD
XCTS_ccl_a_buf_00147 BUFX1 $PINS Z=CTS_39 A=clk VSS=VSS VDD=VDD
XCTS_ccl_a_buf_00103 BUFX1 $PINS Z=CTS_12 A=CTS_13 VSS=VSS VDD=VDD
XCTS_ccl_a_buf_00102 BUFX1 $PINS Z=CTS_15 A=CTS_13 VSS=VSS VDD=VDD
XCTS_ccl_a_buf_00091 BUFX1 $PINS Z=CTS_28 A=CTS_13 VSS=VSS VDD=VDD
XCTS_ccl_a_buf_00145 BUFX1 $PINS Z=CTS_13 A=clk VSS=VSS VDD=VDD
XCTS_ccl_a_buf_00101 BUFX1 $PINS Z=CTS_8 A=CTS_9 VSS=VSS VDD=VDD
XCTS_ccl_a_buf_00095 BUFX1 $PINS Z=CTS_7 A=CTS_9 VSS=VSS VDD=VDD
XCTS_ccl_a_buf_00094 BUFX1 $PINS Z=CTS_6 A=CTS_9 VSS=VSS VDD=VDD
XCTS_ccl_a_buf_00093 BUFX1 $PINS Z=CTS_11 A=CTS_9 VSS=VSS VDD=VDD
XCTS_ccl_a_buf_00092 BUFX1 $PINS Z=CTS_25 A=CTS_9 VSS=VSS VDD=VDD
XCTS_ccl_a_buf_00144 BUFX1 $PINS Z=CTS_9 A=clk VSS=VSS VDD=VDD
XCTS_ccl_a_buf_00099 BUFX1 $PINS Z=CTS_2 A=CTS_3 VSS=VSS VDD=VDD
XCTS_ccl_a_buf_00098 BUFX1 $PINS Z=CTS_1 A=CTS_3 VSS=VSS VDD=VDD
XCTS_ccl_a_buf_00097 BUFX1 $PINS Z=CTS_5 A=CTS_3 VSS=VSS VDD=VDD
XCTS_ccl_a_buf_00096 BUFX1 $PINS Z=CTS_23 A=CTS_3 VSS=VSS VDD=VDD
XCTS_ccl_a_buf_00143 BUFX1 $PINS Z=CTS_3 A=clk VSS=VSS VDD=VDD
XCTS_cdb_buf_00166 BUFX1 $PINS Z=CTS_14 A=CTS_18 VSS=VSS VDD=VDD
XCTS_ccl_a_buf_00104 BUFX1 $PINS Z=CTS_18 A=clk VSS=VSS VDD=VDD
XCTS_cdb_buf_00164 BUFX1 $PINS Z=CTS_4 A=CTS_10 VSS=VSS VDD=VDD
XCTS_ccl_a_buf_00090 BUFX1 $PINS Z=CTS_10 A=clk VSS=VSS VDD=VDD
Xcs_meta_reg DFFQSRX1 $PINS Q=cs_meta CLK=CTS_4 D=cs_n RESETB=n_29 SETB=VDD
+ VSS=VSS VDD=VDD
Xcs_prev_reg DFFQSRX1 $PINS Q=cs_prev CLK=CTS_4 D=cs_sync RESETB=n_29 SETB=VDD
+ VSS=VSS VDD=VDD
Xcs_rise_delayed_reg DFFQSRX1 $PINS Q=cs_rise_delayed CLK=CTS_4 D=n_5941
+ RESETB=VDD SETB=n_29 VSS=VSS VDD=VDD
Xcs_sync_reg DFFQSRX1 $PINS Q=cs_sync CLK=CTS_4 D=cs_meta RESETB=n_29 SETB=VDD
+ VSS=VSS VDD=VDD
Xspi_inst_miso_q_reg DFFQSRX1 $PINS Q=spi_inst_miso_q CLK=n_5883 D=n_6052
+ RESETB=VDD SETB=n_29 VSS=VSS VDD=VDD
Xspi_inst_shreg_out_reg[1] DFFQSRX1 $PINS Q=spi_inst_shreg_out[1] CLK=n_5883
+ D=n_5964 RESETB=VDD SETB=n_29 VSS=VSS VDD=VDD
Xspi_inst_shreg_out_reg[2] DFFQSRX1 $PINS Q=spi_inst_shreg_out[2] CLK=n_5883
+ D=n_5969 RESETB=VDD SETB=n_29 VSS=VSS VDD=VDD
Xspi_inst_shreg_out_reg[3] DFFQSRX1 $PINS Q=spi_inst_shreg_out[3] CLK=n_5883
+ D=n_5972 RESETB=VDD SETB=n_29 VSS=VSS VDD=VDD
Xspi_inst_shreg_out_reg[4] DFFQSRX1 $PINS Q=spi_inst_shreg_out[4] CLK=n_5883
+ D=n_5973 RESETB=VDD SETB=n_29 VSS=VSS VDD=VDD
Xspi_inst_shreg_out_reg[5] DFFQSRX1 $PINS Q=spi_inst_shreg_out[5] CLK=n_5883
+ D=n_5974 RESETB=VDD SETB=n_29 VSS=VSS VDD=VDD
Xspi_inst_shreg_out_reg[6] DFFQSRX1 $PINS Q=spi_inst_shreg_out[6] CLK=n_5883
+ D=n_5975 RESETB=VDD SETB=n_29 VSS=VSS VDD=VDD
Xspi_inst_shreg_out_reg[7] DFFQSRX1 $PINS Q=spi_inst_shreg_out[7] CLK=n_5883
+ D=n_5976 RESETB=VDD SETB=n_29 VSS=VSS VDD=VDD
Xspi_inst_shreg_out_reg[8] DFFQSRX1 $PINS Q=spi_inst_shreg_out[8] CLK=n_5883
+ D=n_5977 RESETB=VDD SETB=n_29 VSS=VSS VDD=VDD
Xspi_inst_shreg_out_reg[9] DFFQSRX1 $PINS Q=spi_inst_shreg_out[9] CLK=n_5883
+ D=n_5979 RESETB=VDD SETB=n_29 VSS=VSS VDD=VDD
Xspi_inst_shreg_out_reg[10] DFFQSRX1 $PINS Q=spi_inst_shreg_out[10] CLK=n_5883
+ D=n_5980 RESETB=VDD SETB=n_29 VSS=VSS VDD=VDD
Xspi_inst_shreg_out_reg[11] DFFQSRX1 $PINS Q=spi_inst_shreg_out[11] CLK=n_5883
+ D=n_5981 RESETB=VDD SETB=n_29 VSS=VSS VDD=VDD
Xspi_inst_shreg_out_reg[12] DFFQSRX1 $PINS Q=spi_inst_shreg_out[12] CLK=n_5883
+ D=n_5982 RESETB=VDD SETB=n_29 VSS=VSS VDD=VDD
Xspi_inst_shreg_out_reg[13] DFFQSRX1 $PINS Q=spi_inst_shreg_out[13] CLK=n_5883
+ D=n_5984 RESETB=VDD SETB=n_29 VSS=VSS VDD=VDD
Xspi_inst_shreg_out_reg[14] DFFQSRX1 $PINS Q=spi_inst_shreg_out[14] CLK=n_5883
+ D=n_5985 RESETB=VDD SETB=n_29 VSS=VSS VDD=VDD
Xspi_inst_shreg_out_reg[15] DFFQSRX1 $PINS Q=spi_inst_shreg_out[15] CLK=n_5883
+ D=n_5986 RESETB=VDD SETB=n_29 VSS=VSS VDD=VDD
Xspi_inst_shreg_out_reg[16] DFFQSRX1 $PINS Q=spi_inst_shreg_out[16] CLK=n_5883
+ D=n_5987 RESETB=VDD SETB=n_29 VSS=VSS VDD=VDD
Xspi_inst_shreg_out_reg[17] DFFQSRX1 $PINS Q=spi_inst_shreg_out[17] CLK=n_5883
+ D=n_5988 RESETB=VDD SETB=n_29 VSS=VSS VDD=VDD
Xspi_inst_shreg_out_reg[18] DFFQSRX1 $PINS Q=spi_inst_shreg_out[18] CLK=n_5883
+ D=n_5989 RESETB=VDD SETB=n_29 VSS=VSS VDD=VDD
Xspi_inst_shreg_out_reg[19] DFFQSRX1 $PINS Q=spi_inst_shreg_out[19] CLK=n_5883
+ D=n_5990 RESETB=VDD SETB=n_29 VSS=VSS VDD=VDD
Xspi_inst_shreg_out_reg[20] DFFQSRX1 $PINS Q=spi_inst_shreg_out[20] CLK=n_5883
+ D=n_5991 RESETB=VDD SETB=n_29 VSS=VSS VDD=VDD
Xspi_inst_shreg_out_reg[21] DFFQSRX1 $PINS Q=spi_inst_shreg_out[21] CLK=n_5883
+ D=n_5992 RESETB=VDD SETB=n_29 VSS=VSS VDD=VDD
Xspi_inst_shreg_out_reg[22] DFFQSRX1 $PINS Q=spi_inst_shreg_out[22] CLK=n_5883
+ D=n_5993 RESETB=VDD SETB=n_29 VSS=VSS VDD=VDD
Xspi_inst_shreg_out_reg[23] DFFQSRX1 $PINS Q=spi_inst_shreg_out[23] CLK=n_5883
+ D=n_5994 RESETB=VDD SETB=n_29 VSS=VSS VDD=VDD
Xspi_inst_shreg_out_reg[24] DFFQSRX1 $PINS Q=spi_inst_shreg_out[24] CLK=n_5883
+ D=n_5995 RESETB=VDD SETB=n_29 VSS=VSS VDD=VDD
Xspi_inst_shreg_out_reg[25] DFFQSRX1 $PINS Q=spi_inst_shreg_out[25] CLK=n_5883
+ D=n_5996 RESETB=VDD SETB=n_29 VSS=VSS VDD=VDD
Xspi_inst_shreg_out_reg[26] DFFQSRX1 $PINS Q=spi_inst_shreg_out[26] CLK=n_5883
+ D=n_5997 RESETB=VDD SETB=n_29 VSS=VSS VDD=VDD
Xspi_inst_shreg_out_reg[27] DFFQSRX1 $PINS Q=spi_inst_shreg_out[27] CLK=n_5883
+ D=n_5998 RESETB=VDD SETB=n_29 VSS=VSS VDD=VDD
Xspi_inst_shreg_out_reg[28] DFFQSRX1 $PINS Q=spi_inst_shreg_out[28] CLK=n_5883
+ D=n_5999 RESETB=VDD SETB=n_29 VSS=VSS VDD=VDD
Xspi_inst_shreg_out_reg[29] DFFQSRX1 $PINS Q=spi_inst_shreg_out[29] CLK=n_5883
+ D=n_6000 RESETB=VDD SETB=n_29 VSS=VSS VDD=VDD
Xspi_inst_shreg_out_reg[30] DFFQSRX1 $PINS Q=spi_inst_shreg_out[30] CLK=n_5883
+ D=n_6001 RESETB=VDD SETB=n_29 VSS=VSS VDD=VDD
Xspi_inst_shreg_out_reg[31] DFFQSRX1 $PINS Q=spi_inst_shreg_out[31] CLK=n_5883
+ D=n_6002 RESETB=VDD SETB=n_29 VSS=VSS VDD=VDD
Xspi_inst_shreg_out_reg[32] DFFQSRX1 $PINS Q=spi_inst_shreg_out[32] CLK=n_5883
+ D=n_6005 RESETB=VDD SETB=n_29 VSS=VSS VDD=VDD
Xspi_inst_shreg_out_reg[33] DFFQSRX1 $PINS Q=spi_inst_shreg_out[33] CLK=n_5883
+ D=n_6006 RESETB=VDD SETB=n_29 VSS=VSS VDD=VDD
Xspi_inst_shreg_out_reg[34] DFFQSRX1 $PINS Q=spi_inst_shreg_out[34] CLK=n_5883
+ D=n_6008 RESETB=VDD SETB=n_29 VSS=VSS VDD=VDD
Xspi_inst_shreg_out_reg[35] DFFQSRX1 $PINS Q=spi_inst_shreg_out[35] CLK=n_5883
+ D=n_6011 RESETB=VDD SETB=n_29 VSS=VSS VDD=VDD
Xspi_inst_shreg_out_reg[36] DFFQSRX1 $PINS Q=spi_inst_shreg_out[36] CLK=n_5883
+ D=n_6014 RESETB=VDD SETB=n_29 VSS=VSS VDD=VDD
Xspi_inst_shreg_out_reg[37] DFFQSRX1 $PINS Q=spi_inst_shreg_out[37] CLK=n_5883
+ D=n_6015 RESETB=VDD SETB=n_29 VSS=VSS VDD=VDD
Xspi_inst_shreg_out_reg[38] DFFQSRX1 $PINS Q=spi_inst_shreg_out[38] CLK=n_5883
+ D=n_6016 RESETB=VDD SETB=n_29 VSS=VSS VDD=VDD
Xspi_inst_shreg_out_reg[39] DFFQSRX1 $PINS Q=spi_inst_shreg_out[39] CLK=n_5883
+ D=n_6017 RESETB=VDD SETB=n_29 VSS=VSS VDD=VDD
Xspi_inst_shreg_out_reg[40] DFFQSRX1 $PINS Q=spi_inst_shreg_out[40] CLK=n_5883
+ D=n_6021 RESETB=VDD SETB=n_29 VSS=VSS VDD=VDD
Xspi_inst_shreg_out_reg[41] DFFQSRX1 $PINS Q=spi_inst_shreg_out[41] CLK=n_5883
+ D=n_6022 RESETB=VDD SETB=n_29 VSS=VSS VDD=VDD
Xspi_inst_shreg_out_reg[42] DFFQSRX1 $PINS Q=spi_inst_shreg_out[42] CLK=n_5883
+ D=n_6023 RESETB=VDD SETB=n_29 VSS=VSS VDD=VDD
Xspi_inst_shreg_out_reg[43] DFFQSRX1 $PINS Q=spi_inst_shreg_out[43] CLK=n_5883
+ D=n_6025 RESETB=VDD SETB=n_29 VSS=VSS VDD=VDD
Xspi_inst_shreg_out_reg[44] DFFQSRX1 $PINS Q=spi_inst_shreg_out[44] CLK=n_5883
+ D=n_6031 RESETB=VDD SETB=n_29 VSS=VSS VDD=VDD
Xspi_inst_shreg_out_reg[45] DFFQSRX1 $PINS Q=spi_inst_shreg_out[45] CLK=n_5883
+ D=n_6033 RESETB=VDD SETB=n_29 VSS=VSS VDD=VDD
Xspi_inst_shreg_out_reg[46] DFFQSRX1 $PINS Q=spi_inst_shreg_out[46] CLK=n_5883
+ D=n_6034 RESETB=VDD SETB=n_29 VSS=VSS VDD=VDD
Xspi_inst_shreg_out_reg[47] DFFQSRX1 $PINS Q=spi_inst_shreg_out[47] CLK=n_5883
+ D=n_6035 RESETB=VDD SETB=n_29 VSS=VSS VDD=VDD
Xspi_inst_shreg_out_reg[48] DFFQSRX1 $PINS Q=spi_inst_shreg_out[48] CLK=n_5883
+ D=n_6036 RESETB=VDD SETB=n_29 VSS=VSS VDD=VDD
Xspi_inst_shreg_out_reg[49] DFFQSRX1 $PINS Q=spi_inst_shreg_out[49] CLK=n_5883
+ D=n_6037 RESETB=VDD SETB=n_29 VSS=VSS VDD=VDD
Xspi_inst_shreg_out_reg[50] DFFQSRX1 $PINS Q=spi_inst_shreg_out[50] CLK=n_5883
+ D=n_6038 RESETB=VDD SETB=n_29 VSS=VSS VDD=VDD
Xspi_inst_shreg_out_reg[51] DFFQSRX1 $PINS Q=spi_inst_shreg_out[51] CLK=n_5883
+ D=n_6039 RESETB=VDD SETB=n_29 VSS=VSS VDD=VDD
Xspi_inst_shreg_out_reg[52] DFFQSRX1 $PINS Q=spi_inst_shreg_out[52] CLK=n_5883
+ D=n_6040 RESETB=VDD SETB=n_29 VSS=VSS VDD=VDD
Xspi_inst_shreg_out_reg[53] DFFQSRX1 $PINS Q=spi_inst_shreg_out[53] CLK=n_5883
+ D=n_6041 RESETB=VDD SETB=n_29 VSS=VSS VDD=VDD
Xspi_inst_shreg_out_reg[54] DFFQSRX1 $PINS Q=spi_inst_shreg_out[54] CLK=n_5883
+ D=n_6042 RESETB=VDD SETB=n_29 VSS=VSS VDD=VDD
Xspi_inst_shreg_out_reg[55] DFFQSRX1 $PINS Q=spi_inst_shreg_out[55] CLK=n_5883
+ D=n_6043 RESETB=VDD SETB=n_29 VSS=VSS VDD=VDD
Xspi_inst_shreg_out_reg[56] DFFQSRX1 $PINS Q=spi_inst_shreg_out[56] CLK=n_5883
+ D=n_6044 RESETB=VDD SETB=n_29 VSS=VSS VDD=VDD
Xspi_inst_shreg_out_reg[57] DFFQSRX1 $PINS Q=spi_inst_shreg_out[57] CLK=n_5883
+ D=n_6045 RESETB=VDD SETB=n_29 VSS=VSS VDD=VDD
Xspi_inst_shreg_out_reg[58] DFFQSRX1 $PINS Q=spi_inst_shreg_out[58] CLK=n_5883
+ D=n_6046 RESETB=VDD SETB=n_29 VSS=VSS VDD=VDD
Xspi_inst_shreg_out_reg[59] DFFQSRX1 $PINS Q=spi_inst_shreg_out[59] CLK=n_5883
+ D=n_6047 RESETB=VDD SETB=n_29 VSS=VSS VDD=VDD
Xspi_inst_shreg_out_reg[60] DFFQSRX1 $PINS Q=spi_inst_shreg_out[60] CLK=n_5883
+ D=n_6048 RESETB=VDD SETB=n_29 VSS=VSS VDD=VDD
Xspi_inst_shreg_out_reg[61] DFFQSRX1 $PINS Q=spi_inst_shreg_out[61] CLK=n_5883
+ D=n_6049 RESETB=VDD SETB=n_29 VSS=VSS VDD=VDD
Xspi_inst_shreg_out_reg[62] DFFQSRX1 $PINS Q=spi_inst_shreg_out[62] CLK=n_5883
+ D=n_6050 RESETB=VDD SETB=n_29 VSS=VSS VDD=VDD
Xspi_inst_shreg_out_reg[63] DFFQSRX1 $PINS Q=spi_inst_shreg_out[63] CLK=n_5883
+ D=n_6051 RESETB=VDD SETB=n_29 VSS=VSS VDD=VDD
Xspi_tx_data_reg[0] DFFQSRX1 $PINS Q=spi_tx_data[0] CLK=CTS_65 D=n_5897
+ RESETB=VDD SETB=n_29 VSS=VSS VDD=VDD
Xspi_tx_data_reg[1] DFFQSRX1 $PINS Q=spi_tx_data[1] CLK=CTS_65 D=n_5948
+ RESETB=VDD SETB=n_29 VSS=VSS VDD=VDD
Xspi_tx_data_reg[2] DFFQSRX1 $PINS Q=spi_tx_data[2] CLK=CTS_65 D=n_5955
+ RESETB=VDD SETB=n_29 VSS=VSS VDD=VDD
Xspi_tx_data_reg[3] DFFQSRX1 $PINS Q=spi_tx_data[3] CLK=CTS_46 D=n_5942
+ RESETB=VDD SETB=n_29 VSS=VSS VDD=VDD
Xspi_tx_data_reg[4] DFFQSRX1 $PINS Q=spi_tx_data[4] CLK=CTS_50 D=n_5909
+ RESETB=VDD SETB=n_29 VSS=VSS VDD=VDD
Xspi_tx_data_reg[5] DFFQSRX1 $PINS Q=spi_tx_data[5] CLK=CTS_50 D=n_5958
+ RESETB=VDD SETB=n_29 VSS=VSS VDD=VDD
Xspi_tx_data_reg[6] DFFQSRX1 $PINS Q=spi_tx_data[6] CLK=CTS_50 D=n_5901
+ RESETB=VDD SETB=n_29 VSS=VSS VDD=VDD
Xspi_tx_data_reg[7] DFFQSRX1 $PINS Q=spi_tx_data[7] CLK=CTS_46 D=n_5916
+ RESETB=VDD SETB=n_29 VSS=VSS VDD=VDD
Xspi_tx_data_reg[8] DFFQSRX1 $PINS Q=spi_tx_data[8] CLK=CTS_46 D=n_5937
+ RESETB=VDD SETB=n_29 VSS=VSS VDD=VDD
Xspi_tx_data_reg[9] DFFQSRX1 $PINS Q=spi_tx_data[9] CLK=CTS_50 D=n_5957
+ RESETB=VDD SETB=n_29 VSS=VSS VDD=VDD
Xspi_tx_data_reg[10] DFFQSRX1 $PINS Q=spi_tx_data[10] CLK=CTS_37 D=n_5936
+ RESETB=VDD SETB=n_29 VSS=VSS VDD=VDD
Xspi_tx_data_reg[11] DFFQSRX1 $PINS Q=spi_tx_data[11] CLK=CTS_62 D=n_5938
+ RESETB=VDD SETB=n_29 VSS=VSS VDD=VDD
Xspi_tx_data_reg[12] DFFQSRX1 $PINS Q=spi_tx_data[12] CLK=CTS_62 D=n_5907
+ RESETB=VDD SETB=n_29 VSS=VSS VDD=VDD
Xspi_tx_data_reg[13] DFFQSRX1 $PINS Q=spi_tx_data[13] CLK=CTS_62 D=n_5934
+ RESETB=VDD SETB=n_29 VSS=VSS VDD=VDD
Xspi_tx_data_reg[14] DFFQSRX1 $PINS Q=spi_tx_data[14] CLK=CTS_36 D=n_5951
+ RESETB=VDD SETB=n_29 VSS=VSS VDD=VDD
Xspi_tx_data_reg[15] DFFQSRX1 $PINS Q=spi_tx_data[15] CLK=CTS_49 D=n_5933
+ RESETB=VDD SETB=n_29 VSS=VSS VDD=VDD
Xspi_tx_data_reg[16] DFFQSRX1 $PINS Q=spi_tx_data[16] CLK=CTS_53 D=n_5950
+ RESETB=VDD SETB=n_29 VSS=VSS VDD=VDD
Xspi_tx_data_reg[17] DFFQSRX1 $PINS Q=spi_tx_data[17] CLK=CTS_60 D=n_5930
+ RESETB=VDD SETB=n_29 VSS=VSS VDD=VDD
Xspi_tx_data_reg[18] DFFQSRX1 $PINS Q=spi_tx_data[18] CLK=CTS_60 D=n_5926
+ RESETB=VDD SETB=n_29 VSS=VSS VDD=VDD
Xspi_tx_data_reg[19] DFFQSRX1 $PINS Q=spi_tx_data[19] CLK=CTS_60 D=n_5931
+ RESETB=VDD SETB=n_29 VSS=VSS VDD=VDD
Xspi_tx_data_reg[20] DFFQSRX1 $PINS Q=spi_tx_data[20] CLK=CTS_60 D=n_5905
+ RESETB=VDD SETB=n_29 VSS=VSS VDD=VDD
Xspi_tx_data_reg[21] DFFQSRX1 $PINS Q=spi_tx_data[21] CLK=CTS_60 D=n_5924
+ RESETB=VDD SETB=n_29 VSS=VSS VDD=VDD
Xspi_tx_data_reg[22] DFFQSRX1 $PINS Q=spi_tx_data[22] CLK=CTS_53 D=n_5929
+ RESETB=VDD SETB=n_29 VSS=VSS VDD=VDD
Xspi_tx_data_reg[23] DFFQSRX1 $PINS Q=spi_tx_data[23] CLK=CTS_52 D=n_5935
+ RESETB=VDD SETB=n_29 VSS=VSS VDD=VDD
Xspi_tx_data_reg[24] DFFQSRX1 $PINS Q=spi_tx_data[24] CLK=CTS_56 D=n_5925
+ RESETB=VDD SETB=n_29 VSS=VSS VDD=VDD
Xspi_tx_data_reg[25] DFFQSRX1 $PINS Q=spi_tx_data[25] CLK=CTS_49 D=n_5927
+ RESETB=VDD SETB=n_29 VSS=VSS VDD=VDD
Xspi_tx_data_reg[26] DFFQSRX1 $PINS Q=spi_tx_data[26] CLK=CTS_36 D=n_5940
+ RESETB=VDD SETB=n_29 VSS=VSS VDD=VDD
Xspi_tx_data_reg[27] DFFQSRX1 $PINS Q=spi_tx_data[27] CLK=CTS_40 D=n_5913
+ RESETB=VDD SETB=n_29 VSS=VSS VDD=VDD
Xspi_tx_data_reg[28] DFFQSRX1 $PINS Q=spi_tx_data[28] CLK=CTS_40 D=n_5904
+ RESETB=VDD SETB=n_29 VSS=VSS VDD=VDD
Xspi_tx_data_reg[29] DFFQSRX1 $PINS Q=spi_tx_data[29] CLK=CTS_36 D=n_5945
+ RESETB=VDD SETB=n_29 VSS=VSS VDD=VDD
Xspi_tx_data_reg[30] DFFQSRX1 $PINS Q=spi_tx_data[30] CLK=CTS_53 D=n_5947
+ RESETB=VDD SETB=n_29 VSS=VSS VDD=VDD
Xspi_tx_data_reg[31] DFFQSRX1 $PINS Q=spi_tx_data[31] CLK=CTS_59 D=n_5923
+ RESETB=VDD SETB=n_29 VSS=VSS VDD=VDD
Xspi_tx_data_reg[32] DFFQSRX1 $PINS Q=spi_tx_data[32] CLK=CTS_58 D=n_5896
+ RESETB=VDD SETB=n_29 VSS=VSS VDD=VDD
Xspi_tx_data_reg[33] DFFQSRX1 $PINS Q=spi_tx_data[33] CLK=CTS_63 D=n_5953
+ RESETB=VDD SETB=n_29 VSS=VSS VDD=VDD
Xspi_tx_data_reg[34] DFFQSRX1 $PINS Q=spi_tx_data[34] CLK=CTS_63 D=n_5892
+ RESETB=VDD SETB=n_29 VSS=VSS VDD=VDD
Xspi_tx_data_reg[35] DFFQSRX1 $PINS Q=spi_tx_data[35] CLK=CTS_63 D=n_5900
+ RESETB=VDD SETB=n_29 VSS=VSS VDD=VDD
Xspi_tx_data_reg[36] DFFQSRX1 $PINS Q=spi_tx_data[36] CLK=CTS_70 D=n_5902
+ RESETB=VDD SETB=n_29 VSS=VSS VDD=VDD
Xspi_tx_data_reg[37] DFFQSRX1 $PINS Q=spi_tx_data[37] CLK=CTS_70 D=n_5906
+ RESETB=VDD SETB=n_29 VSS=VSS VDD=VDD
Xspi_tx_data_reg[38] DFFQSRX1 $PINS Q=spi_tx_data[38] CLK=CTS_60 D=n_5922
+ RESETB=VDD SETB=n_29 VSS=VSS VDD=VDD
Xspi_tx_data_reg[39] DFFQSRX1 $PINS Q=spi_tx_data[39] CLK=CTS_60 D=n_5908
+ RESETB=VDD SETB=n_29 VSS=VSS VDD=VDD
Xspi_tx_data_reg[40] DFFQSRX1 $PINS Q=spi_tx_data[40] CLK=CTS_60 D=n_5914
+ RESETB=VDD SETB=n_29 VSS=VSS VDD=VDD
Xspi_tx_data_reg[41] DFFQSRX1 $PINS Q=spi_tx_data[41] CLK=CTS_59 D=n_5943
+ RESETB=VDD SETB=n_29 VSS=VSS VDD=VDD
Xspi_tx_data_reg[42] DFFQSRX1 $PINS Q=spi_tx_data[42] CLK=CTS_59 D=n_5895
+ RESETB=VDD SETB=n_29 VSS=VSS VDD=VDD
Xspi_tx_data_reg[43] DFFQSRX1 $PINS Q=spi_tx_data[43] CLK=CTS_59 D=n_5894
+ RESETB=VDD SETB=n_29 VSS=VSS VDD=VDD
Xspi_tx_data_reg[44] DFFQSRX1 $PINS Q=spi_tx_data[44] CLK=CTS_52 D=n_5903
+ RESETB=VDD SETB=n_29 VSS=VSS VDD=VDD
Xspi_tx_data_reg[45] DFFQSRX1 $PINS Q=spi_tx_data[45] CLK=CTS_52 D=n_5893
+ RESETB=VDD SETB=n_29 VSS=VSS VDD=VDD
Xspi_tx_data_reg[46] DFFQSRX1 $PINS Q=spi_tx_data[46] CLK=CTS_52 D=n_5920
+ RESETB=VDD SETB=n_29 VSS=VSS VDD=VDD
Xspi_tx_data_reg[47] DFFQSRX1 $PINS Q=spi_tx_data[47] CLK=CTS_52 D=n_5891
+ RESETB=VDD SETB=n_29 VSS=VSS VDD=VDD
Xspi_tx_data_reg[48] DFFQSRX1 $PINS Q=spi_tx_data[48] CLK=CTS_59 D=n_5899
+ RESETB=VDD SETB=n_29 VSS=VSS VDD=VDD
Xspi_tx_data_reg[49] DFFQSRX1 $PINS Q=spi_tx_data[49] CLK=CTS_59 D=n_5932
+ RESETB=VDD SETB=n_29 VSS=VSS VDD=VDD
Xspi_tx_data_reg[50] DFFQSRX1 $PINS Q=spi_tx_data[50] CLK=CTS_59 D=n_5919
+ RESETB=VDD SETB=n_29 VSS=VSS VDD=VDD
Xspi_tx_data_reg[51] DFFQSRX1 $PINS Q=spi_tx_data[51] CLK=CTS_61 D=n_5952
+ RESETB=VDD SETB=n_29 VSS=VSS VDD=VDD
Xspi_tx_data_reg[52] DFFQSRX1 $PINS Q=spi_tx_data[52] CLK=CTS_53 D=n_5917
+ RESETB=VDD SETB=n_29 VSS=VSS VDD=VDD
Xspi_tx_data_reg[53] DFFQSRX1 $PINS Q=spi_tx_data[53] CLK=CTS_53 D=n_5915
+ RESETB=VDD SETB=n_29 VSS=VSS VDD=VDD
Xspi_tx_data_reg[54] DFFQSRX1 $PINS Q=spi_tx_data[54] CLK=CTS_40 D=n_5946
+ RESETB=VDD SETB=n_29 VSS=VSS VDD=VDD
Xspi_tx_data_reg[55] DFFQSRX1 $PINS Q=spi_tx_data[55] CLK=CTS_62 D=n_5956
+ RESETB=VDD SETB=n_29 VSS=VSS VDD=VDD
Xspi_tx_data_reg[56] DFFQSRX1 $PINS Q=spi_tx_data[56] CLK=CTS_37 D=n_5898
+ RESETB=VDD SETB=n_29 VSS=VSS VDD=VDD
Xspi_tx_data_reg[57] DFFQSRX1 $PINS Q=spi_tx_data[57] CLK=CTS_41 D=n_5910
+ RESETB=VDD SETB=n_29 VSS=VSS VDD=VDD
Xspi_tx_data_reg[58] DFFQSRX1 $PINS Q=spi_tx_data[58] CLK=CTS_41 D=n_5944
+ RESETB=VDD SETB=n_29 VSS=VSS VDD=VDD
Xspi_tx_data_reg[59] DFFQSRX1 $PINS Q=spi_tx_data[59] CLK=CTS_41 D=n_5890
+ RESETB=VDD SETB=n_29 VSS=VSS VDD=VDD
Xspi_tx_data_reg[60] DFFQSRX1 $PINS Q=spi_tx_data[60] CLK=CTS_50 D=n_5912
+ RESETB=VDD SETB=n_29 VSS=VSS VDD=VDD
Xspi_tx_data_reg[61] DFFQSRX1 $PINS Q=spi_tx_data[61] CLK=CTS_50 D=n_5918
+ RESETB=VDD SETB=n_29 VSS=VSS VDD=VDD
Xspi_tx_data_reg[62] DFFQSRX1 $PINS Q=spi_tx_data[62] CLK=CTS_41 D=n_5954
+ RESETB=VDD SETB=n_29 VSS=VSS VDD=VDD
Xspi_tx_data_reg[63] DFFQSRX1 $PINS Q=spi_tx_data[63] CLK=CTS_41 D=n_5911
+ RESETB=VDD SETB=n_29 VSS=VSS VDD=VDD
Xtrigger_operation_reg DFFQSRX1 $PINS Q=trigger_operation CLK=CTS_14 D=n_5968
+ RESETB=VDD SETB=n_29 VSS=VSS VDD=VDD
Xg87874 AND2X1 $PINS Z=miso A=spi_inst_miso_q B=n_30 VSS=VSS VDD=VDD
Xg87876 MUX2X1 $PINS Z=n_6052 A=spi_inst_shreg_out[63] B=spi_tx_data[63] S=cs_n
+ VSS=VSS VDD=VDD
Xg87878 MUX2X1 $PINS Z=n_6051 A=spi_inst_shreg_out[62] B=spi_tx_data[62] S=cs_n
+ VSS=VSS VDD=VDD
Xg87880 MUX2X1 $PINS Z=n_6050 A=spi_inst_shreg_out[61] B=spi_tx_data[61] S=cs_n
+ VSS=VSS VDD=VDD
Xg87882 MUX2X1 $PINS Z=n_6049 A=spi_inst_shreg_out[60] B=spi_tx_data[60] S=cs_n
+ VSS=VSS VDD=VDD
Xg87884 MUX2X1 $PINS Z=n_6048 A=spi_inst_shreg_out[59] B=spi_tx_data[59] S=cs_n
+ VSS=VSS VDD=VDD
Xg87886 MUX2X1 $PINS Z=n_6047 A=spi_inst_shreg_out[58] B=spi_tx_data[58] S=cs_n
+ VSS=VSS VDD=VDD
Xg87888 MUX2X1 $PINS Z=n_6046 A=spi_inst_shreg_out[57] B=spi_tx_data[57] S=cs_n
+ VSS=VSS VDD=VDD
Xg87890 MUX2X1 $PINS Z=n_6045 A=spi_inst_shreg_out[56] B=spi_tx_data[56] S=cs_n
+ VSS=VSS VDD=VDD
Xg87892 MUX2X1 $PINS Z=n_6044 A=spi_inst_shreg_out[55] B=spi_tx_data[55] S=cs_n
+ VSS=VSS VDD=VDD
Xg87894 MUX2X1 $PINS Z=n_6043 A=spi_inst_shreg_out[54] B=spi_tx_data[54] S=cs_n
+ VSS=VSS VDD=VDD
Xg87896 MUX2X1 $PINS Z=n_6042 A=spi_inst_shreg_out[53] B=spi_tx_data[53] S=cs_n
+ VSS=VSS VDD=VDD
Xg87898 MUX2X1 $PINS Z=n_6041 A=spi_inst_shreg_out[52] B=spi_tx_data[52] S=cs_n
+ VSS=VSS VDD=VDD
Xg87900 MUX2X1 $PINS Z=n_6040 A=spi_inst_shreg_out[51] B=spi_tx_data[51] S=cs_n
+ VSS=VSS VDD=VDD
Xg87902 MUX2X1 $PINS Z=n_6039 A=spi_inst_shreg_out[50] B=spi_tx_data[50] S=cs_n
+ VSS=VSS VDD=VDD
Xg87904 MUX2X1 $PINS Z=n_6038 A=spi_inst_shreg_out[49] B=spi_tx_data[49] S=cs_n
+ VSS=VSS VDD=VDD
Xg87906 MUX2X1 $PINS Z=n_6037 A=spi_inst_shreg_out[48] B=spi_tx_data[48] S=cs_n
+ VSS=VSS VDD=VDD
Xg87908 MUX2X1 $PINS Z=n_6036 A=spi_inst_shreg_out[47] B=spi_tx_data[47] S=cs_n
+ VSS=VSS VDD=VDD
Xg87910 MUX2X1 $PINS Z=n_6035 A=spi_inst_shreg_out[46] B=spi_tx_data[46] S=cs_n
+ VSS=VSS VDD=VDD
Xg87912 MUX2X1 $PINS Z=n_6034 A=spi_inst_shreg_out[45] B=spi_tx_data[45] S=cs_n
+ VSS=VSS VDD=VDD
Xg87914 MUX2X1 $PINS Z=n_6033 A=spi_inst_shreg_out[44] B=spi_tx_data[44] S=cs_n
+ VSS=VSS VDD=VDD
Xg87916 MUX2X1 $PINS Z=n_6031 A=spi_inst_shreg_out[43] B=spi_tx_data[43] S=cs_n
+ VSS=VSS VDD=VDD
Xg87918 MUX2X1 $PINS Z=n_6025 A=spi_inst_shreg_out[42] B=spi_tx_data[42] S=cs_n
+ VSS=VSS VDD=VDD
Xg87920 MUX2X1 $PINS Z=n_6023 A=spi_inst_shreg_out[41] B=spi_tx_data[41] S=cs_n
+ VSS=VSS VDD=VDD
Xg87922 MUX2X1 $PINS Z=n_6022 A=spi_inst_shreg_out[40] B=spi_tx_data[40] S=cs_n
+ VSS=VSS VDD=VDD
Xg87924 MUX2X1 $PINS Z=n_6021 A=spi_inst_shreg_out[39] B=spi_tx_data[39] S=cs_n
+ VSS=VSS VDD=VDD
Xg87926 MUX2X1 $PINS Z=n_6017 A=spi_inst_shreg_out[38] B=spi_tx_data[38] S=cs_n
+ VSS=VSS VDD=VDD
Xg87928 MUX2X1 $PINS Z=n_6016 A=spi_inst_shreg_out[37] B=spi_tx_data[37] S=cs_n
+ VSS=VSS VDD=VDD
Xg87930 MUX2X1 $PINS Z=n_6015 A=spi_inst_shreg_out[36] B=spi_tx_data[36] S=cs_n
+ VSS=VSS VDD=VDD
Xg87932 MUX2X1 $PINS Z=n_6014 A=spi_inst_shreg_out[35] B=spi_tx_data[35] S=cs_n
+ VSS=VSS VDD=VDD
Xg87934 MUX2X1 $PINS Z=n_6011 A=spi_inst_shreg_out[34] B=spi_tx_data[34] S=cs_n
+ VSS=VSS VDD=VDD
Xg87936 MUX2X1 $PINS Z=n_6008 A=spi_inst_shreg_out[33] B=spi_tx_data[33] S=cs_n
+ VSS=VSS VDD=VDD
Xg87938 MUX2X1 $PINS Z=n_6006 A=spi_inst_shreg_out[32] B=spi_tx_data[32] S=cs_n
+ VSS=VSS VDD=VDD
Xg87940 MUX2X1 $PINS Z=n_6005 A=spi_inst_shreg_out[31] B=spi_tx_data[31] S=cs_n
+ VSS=VSS VDD=VDD
Xg87942 MUX2X1 $PINS Z=n_6002 A=spi_inst_shreg_out[30] B=spi_tx_data[30] S=cs_n
+ VSS=VSS VDD=VDD
Xg87944 MUX2X1 $PINS Z=n_6001 A=spi_inst_shreg_out[29] B=spi_tx_data[29] S=cs_n
+ VSS=VSS VDD=VDD
Xg87946 MUX2X1 $PINS Z=n_6000 A=spi_inst_shreg_out[28] B=spi_tx_data[28] S=cs_n
+ VSS=VSS VDD=VDD
Xg87948 MUX2X1 $PINS Z=n_5999 A=spi_inst_shreg_out[27] B=spi_tx_data[27] S=cs_n
+ VSS=VSS VDD=VDD
Xg87950 MUX2X1 $PINS Z=n_5998 A=spi_inst_shreg_out[26] B=spi_tx_data[26] S=cs_n
+ VSS=VSS VDD=VDD
Xg87952 MUX2X1 $PINS Z=n_5997 A=spi_inst_shreg_out[25] B=spi_tx_data[25] S=cs_n
+ VSS=VSS VDD=VDD
Xg87954 MUX2X1 $PINS Z=n_5996 A=spi_inst_shreg_out[24] B=spi_tx_data[24] S=cs_n
+ VSS=VSS VDD=VDD
Xg87956 MUX2X1 $PINS Z=n_5995 A=spi_inst_shreg_out[23] B=spi_tx_data[23] S=cs_n
+ VSS=VSS VDD=VDD
Xg87958 MUX2X1 $PINS Z=n_5994 A=spi_inst_shreg_out[22] B=spi_tx_data[22] S=cs_n
+ VSS=VSS VDD=VDD
Xg87960 MUX2X1 $PINS Z=n_5993 A=spi_inst_shreg_out[21] B=spi_tx_data[21] S=cs_n
+ VSS=VSS VDD=VDD
Xg87962 MUX2X1 $PINS Z=n_5992 A=spi_inst_shreg_out[20] B=spi_tx_data[20] S=cs_n
+ VSS=VSS VDD=VDD
Xg87964 MUX2X1 $PINS Z=n_5991 A=spi_inst_shreg_out[19] B=spi_tx_data[19] S=cs_n
+ VSS=VSS VDD=VDD
Xg87966 MUX2X1 $PINS Z=n_5990 A=spi_inst_shreg_out[18] B=spi_tx_data[18] S=cs_n
+ VSS=VSS VDD=VDD
Xg87968 MUX2X1 $PINS Z=n_5989 A=spi_inst_shreg_out[17] B=spi_tx_data[17] S=cs_n
+ VSS=VSS VDD=VDD
Xg87970 MUX2X1 $PINS Z=n_5988 A=spi_inst_shreg_out[16] B=spi_tx_data[16] S=cs_n
+ VSS=VSS VDD=VDD
Xg87972 MUX2X1 $PINS Z=n_5987 A=spi_inst_shreg_out[15] B=spi_tx_data[15] S=cs_n
+ VSS=VSS VDD=VDD
Xg87974 MUX2X1 $PINS Z=n_5986 A=spi_inst_shreg_out[14] B=spi_tx_data[14] S=cs_n
+ VSS=VSS VDD=VDD
Xg87976 MUX2X1 $PINS Z=n_5985 A=spi_inst_shreg_out[13] B=spi_tx_data[13] S=cs_n
+ VSS=VSS VDD=VDD
Xg87978 MUX2X1 $PINS Z=n_5984 A=spi_inst_shreg_out[12] B=spi_tx_data[12] S=cs_n
+ VSS=VSS VDD=VDD
Xg87980 MUX2X1 $PINS Z=n_5982 A=spi_inst_shreg_out[11] B=spi_tx_data[11] S=cs_n
+ VSS=VSS VDD=VDD
Xg87982 MUX2X1 $PINS Z=n_5981 A=spi_inst_shreg_out[10] B=spi_tx_data[10] S=cs_n
+ VSS=VSS VDD=VDD
Xg87984 MUX2X1 $PINS Z=n_5980 A=spi_inst_shreg_out[9] B=spi_tx_data[9] S=cs_n
+ VSS=VSS VDD=VDD
Xg87986 MUX2X1 $PINS Z=n_5979 A=spi_inst_shreg_out[8] B=spi_tx_data[8] S=cs_n
+ VSS=VSS VDD=VDD
Xg87988 MUX2X1 $PINS Z=n_5977 A=spi_inst_shreg_out[7] B=spi_tx_data[7] S=cs_n
+ VSS=VSS VDD=VDD
Xg87990 MUX2X1 $PINS Z=n_5976 A=spi_inst_shreg_out[6] B=spi_tx_data[6] S=cs_n
+ VSS=VSS VDD=VDD
Xg87992 MUX2X1 $PINS Z=n_5975 A=spi_inst_shreg_out[5] B=spi_tx_data[5] S=cs_n
+ VSS=VSS VDD=VDD
Xg87994 MUX2X1 $PINS Z=n_5974 A=spi_inst_shreg_out[4] B=spi_tx_data[4] S=cs_n
+ VSS=VSS VDD=VDD
Xg87996 MUX2X1 $PINS Z=n_5973 A=spi_inst_shreg_out[3] B=spi_tx_data[3] S=cs_n
+ VSS=VSS VDD=VDD
Xg87998 MUX2X1 $PINS Z=n_5972 A=spi_inst_shreg_out[2] B=spi_tx_data[2] S=cs_n
+ VSS=VSS VDD=VDD
Xg88000 MUX2X1 $PINS Z=n_5969 A=spi_inst_shreg_out[1] B=spi_tx_data[1] S=cs_n
+ VSS=VSS VDD=VDD
Xg88004 NOR2X1 $PINS Z=n_5968 A=n_5885 B=n_6054 VSS=VSS VDD=VDD
Xg88005 NAND2X1 $PINS Z=n_6054 A=n_5884 B=cs_rise_delayed VSS=VSS VDD=VDD
Xg88006 AND2X1 $PINS Z=n_5964 A=spi_tx_data[0] B=cs_n VSS=VSS VDD=VDD
Xg88072 AND2X1 $PINS Z=n_5958 A=n_5889 B=des_output[5] VSS=VSS VDD=VDD
Xg88073 AND2X1 $PINS Z=n_5957 A=n_5889 B=des_output[9] VSS=VSS VDD=VDD
Xg88074 AND2X1 $PINS Z=n_5956 A=n_5889 B=des_output[55] VSS=VSS VDD=VDD
Xg88075 AND2X1 $PINS Z=n_5955 A=n_5889 B=des_output[2] VSS=VSS VDD=VDD
Xg88076 AND2X1 $PINS Z=n_5954 A=n_5889 B=des_output[62] VSS=VSS VDD=VDD
Xg88077 AND2X1 $PINS Z=n_5953 A=n_5889 B=des_output[33] VSS=VSS VDD=VDD
Xg88078 AND2X1 $PINS Z=n_5952 A=n_5889 B=des_output[51] VSS=VSS VDD=VDD
Xg88079 AND2X1 $PINS Z=n_5951 A=n_5889 B=des_output[14] VSS=VSS VDD=VDD
Xg88080 AND2X1 $PINS Z=n_5950 A=n_5889 B=des_output[16] VSS=VSS VDD=VDD
Xg88081 AND2X1 $PINS Z=n_5948 A=n_5889 B=des_output[1] VSS=VSS VDD=VDD
Xg88082 AND2X1 $PINS Z=n_5947 A=n_5889 B=des_output[30] VSS=VSS VDD=VDD
Xg88083 AND2X1 $PINS Z=n_5946 A=n_5889 B=des_output[54] VSS=VSS VDD=VDD
Xg88084 AND2X1 $PINS Z=n_5945 A=n_5889 B=des_output[29] VSS=VSS VDD=VDD
Xg88085 AND2X1 $PINS Z=n_5944 A=n_5889 B=des_output[58] VSS=VSS VDD=VDD
Xg88086 AND2X1 $PINS Z=n_5943 A=n_5889 B=des_output[41] VSS=VSS VDD=VDD
Xg88087 AND2X1 $PINS Z=n_5942 A=n_5889 B=des_output[3] VSS=VSS VDD=VDD
Xg88088 NOR2X1 $PINS Z=n_5941 A=cs_prev B=n_5888 VSS=VSS VDD=VDD
Xg88089 AND2X1 $PINS Z=n_5940 A=n_5889 B=des_output[26] VSS=VSS VDD=VDD
Xg88090 AND2X1 $PINS Z=n_5938 A=n_5889 B=des_output[11] VSS=VSS VDD=VDD
Xg88091 AND2X1 $PINS Z=n_5937 A=n_5889 B=des_output[8] VSS=VSS VDD=VDD
Xg88092 AND2X1 $PINS Z=n_5936 A=n_5889 B=des_output[10] VSS=VSS VDD=VDD
Xg88093 AND2X1 $PINS Z=n_5935 A=n_5889 B=des_output[23] VSS=VSS VDD=VDD
Xg88094 AND2X1 $PINS Z=n_5934 A=n_5889 B=des_output[13] VSS=VSS VDD=VDD
Xg88095 AND2X1 $PINS Z=n_5933 A=n_5889 B=des_output[15] VSS=VSS VDD=VDD
Xg88096 AND2X1 $PINS Z=n_5932 A=n_5889 B=des_output[49] VSS=VSS VDD=VDD
Xg88097 AND2X1 $PINS Z=n_5931 A=n_5889 B=des_output[19] VSS=VSS VDD=VDD
Xg88098 AND2X1 $PINS Z=n_5930 A=n_5889 B=des_output[17] VSS=VSS VDD=VDD
Xg88099 AND2X1 $PINS Z=n_5929 A=n_5889 B=des_output[22] VSS=VSS VDD=VDD
Xg88100 AND2X1 $PINS Z=n_5927 A=n_5889 B=des_output[25] VSS=VSS VDD=VDD
Xg88101 AND2X1 $PINS Z=n_5926 A=n_5889 B=des_output[18] VSS=VSS VDD=VDD
Xg88102 AND2X1 $PINS Z=n_5925 A=n_5889 B=des_output[24] VSS=VSS VDD=VDD
Xg88103 AND2X1 $PINS Z=n_5924 A=n_5889 B=des_output[21] VSS=VSS VDD=VDD
Xg88104 AND2X1 $PINS Z=n_5923 A=n_5889 B=des_output[31] VSS=VSS VDD=VDD
Xg88105 AND2X1 $PINS Z=n_5922 A=n_5889 B=des_output[38] VSS=VSS VDD=VDD
Xg88106 AND2X1 $PINS Z=n_5920 A=n_5889 B=des_output[46] VSS=VSS VDD=VDD
Xg88107 AND2X1 $PINS Z=n_5919 A=n_5889 B=des_output[50] VSS=VSS VDD=VDD
Xg88108 AND2X1 $PINS Z=n_5918 A=n_5889 B=des_output[61] VSS=VSS VDD=VDD
Xg88109 AND2X1 $PINS Z=n_5917 A=n_5889 B=des_output[52] VSS=VSS VDD=VDD
Xg88110 AND2X1 $PINS Z=n_5916 A=n_5889 B=des_output[7] VSS=VSS VDD=VDD
Xg88111 AND2X1 $PINS Z=n_5915 A=n_5889 B=des_output[53] VSS=VSS VDD=VDD
Xg88112 AND2X1 $PINS Z=n_5914 A=n_5889 B=des_output[40] VSS=VSS VDD=VDD
Xg88113 AND2X1 $PINS Z=n_5913 A=n_5889 B=des_output[27] VSS=VSS VDD=VDD
Xg88114 AND2X1 $PINS Z=n_5912 A=n_5889 B=des_output[60] VSS=VSS VDD=VDD
Xg88115 AND2X1 $PINS Z=n_5911 A=n_5889 B=des_output[63] VSS=VSS VDD=VDD
Xg88116 AND2X1 $PINS Z=n_5910 A=n_5889 B=des_output[57] VSS=VSS VDD=VDD
Xg88117 AND2X1 $PINS Z=n_5909 A=n_5889 B=des_output[4] VSS=VSS VDD=VDD
Xg88118 AND2X1 $PINS Z=n_5908 A=n_5889 B=des_output[39] VSS=VSS VDD=VDD
Xg88119 AND2X1 $PINS Z=n_5907 A=n_5889 B=des_output[12] VSS=VSS VDD=VDD
Xg88120 AND2X1 $PINS Z=n_5906 A=n_5889 B=des_output[37] VSS=VSS VDD=VDD
Xg88121 AND2X1 $PINS Z=n_5905 A=n_5889 B=des_output[20] VSS=VSS VDD=VDD
Xg88122 AND2X1 $PINS Z=n_5904 A=n_5889 B=des_output[28] VSS=VSS VDD=VDD
Xg88123 AND2X1 $PINS Z=n_5903 A=n_5889 B=des_output[44] VSS=VSS VDD=VDD
Xg88124 AND2X1 $PINS Z=n_5902 A=n_5889 B=des_output[36] VSS=VSS VDD=VDD
Xg88125 AND2X1 $PINS Z=n_5901 A=n_5889 B=des_output[6] VSS=VSS VDD=VDD
Xg88126 AND2X1 $PINS Z=n_5900 A=n_5889 B=des_output[35] VSS=VSS VDD=VDD
Xg88127 AND2X1 $PINS Z=n_5899 A=n_5889 B=des_output[48] VSS=VSS VDD=VDD
Xg88128 AND2X1 $PINS Z=n_5898 A=n_5889 B=des_output[56] VSS=VSS VDD=VDD
Xg88129 AND2X1 $PINS Z=n_5897 A=n_5889 B=des_output[0] VSS=VSS VDD=VDD
Xg88130 AND2X1 $PINS Z=n_5896 A=n_5889 B=des_output[32] VSS=VSS VDD=VDD
Xg88131 AND2X1 $PINS Z=n_5895 A=n_5889 B=des_output[42] VSS=VSS VDD=VDD
Xg88132 AND2X1 $PINS Z=n_5894 A=n_5889 B=des_output[43] VSS=VSS VDD=VDD
Xg88133 AND2X1 $PINS Z=n_5893 A=n_5889 B=des_output[45] VSS=VSS VDD=VDD
Xg88134 AND2X1 $PINS Z=n_5892 A=n_5889 B=des_output[34] VSS=VSS VDD=VDD
Xg88135 AND2X1 $PINS Z=n_5891 A=n_5889 B=des_output[47] VSS=VSS VDD=VDD
Xg88136 AND2X1 $PINS Z=n_5890 A=n_5889 B=des_output[59] VSS=VSS VDD=VDD
Xg88138 NOR2X1 $PINS Z=n_5889 A=n_5885 B=n_5887 VSS=VSS VDD=VDD
Xg88139 INVX2 $PINS Z=n_5888 A=cs_sync VSS=VSS VDD=VDD
Xg88141 OR2X1 $PINS Z=n_5887 A=n_5884 B=n_5886 VSS=VSS VDD=VDD
Xg88143 NOR2X1 $PINS Z=n_5886 A=done_decrypt_latched B=done_encrypt_latched
+ VSS=VSS VDD=VDD
Xg88144 INVX2 $PINS Z=n_5885 A=transaction_state[1] VSS=VSS VDD=VDD
Xg88145 INVX2 $PINS Z=n_5884 A=transaction_state[0] VSS=VSS VDD=VDD
Xg88146 INVX2 $PINS Z=n_5883 A=sclk VSS=VSS VDD=VDD
Xg88147 INVX2 $PINS Z=n_29 A=rst VSS=VSS VDD=VDD
Xactive_reg DFFQSRX1 $PINS Q=active CLK=CTS_28 D=n_1212 RESETB=VDD SETB=n_29
+ VSS=VSS VDD=VDD
Xcrypt_reg DFFQSRX1 $PINS Q=crypt CLK=CTS_14 D=n_6062 RESETB=VDD SETB=n_29
+ VSS=VSS VDD=VDD
Xcsm_inst_done_decrypt_reg DFFQSRX1 $PINS Q=done_decrypt CLK=CTS_28 D=n_2547
+ RESETB=VDD SETB=n_29 VSS=VSS VDD=VDD
Xcsm_inst_done_encrypt_reg DFFQSRX1 $PINS Q=done_encrypt CLK=CTS_28 D=n_2748
+ RESETB=VDD SETB=n_29 VSS=VSS VDD=VDD
Xcsm_inst_left_reg_reg[0] DFFQSRX1 $PINS Q=csm_inst_left_reg[0] CLK=CTS_42
+ D=n_2844 RESETB=VDD SETB=n_29 VSS=VSS VDD=VDD
Xcsm_inst_left_reg_reg[1] DFFQSRX1 $PINS Q=csm_inst_left_reg[1] CLK=CTS_32
+ D=n_2988 RESETB=VDD SETB=n_29 VSS=VSS VDD=VDD
Xcsm_inst_left_reg_reg[2] DFFQSRX1 $PINS Q=csm_inst_left_reg[2] CLK=CTS_32
+ D=n_2986 RESETB=VDD SETB=n_29 VSS=VSS VDD=VDD
Xcsm_inst_left_reg_reg[3] DFFQSRX1 $PINS Q=csm_inst_left_reg[3] CLK=CTS_73
+ D=n_2983 RESETB=VDD SETB=n_29 VSS=VSS VDD=VDD
Xcsm_inst_left_reg_reg[4] DFFQSRX1 $PINS Q=csm_inst_left_reg[4] CLK=CTS_51
+ D=n_2979 RESETB=VDD SETB=n_29 VSS=VSS VDD=VDD
Xcsm_inst_left_reg_reg[5] DFFQSRX1 $PINS Q=csm_inst_left_reg[5] CLK=CTS_58
+ D=n_2938 RESETB=VDD SETB=n_29 VSS=VSS VDD=VDD
Xcsm_inst_left_reg_reg[6] DFFQSRX1 $PINS Q=csm_inst_left_reg[6] CLK=CTS_47
+ D=n_2905 RESETB=VDD SETB=n_29 VSS=VSS VDD=VDD
Xcsm_inst_left_reg_reg[7] DFFQSRX1 $PINS Q=csm_inst_left_reg[7] CLK=CTS_72
+ D=n_2897 RESETB=VDD SETB=n_29 VSS=VSS VDD=VDD
Xcsm_inst_left_reg_reg[8] DFFQSRX1 $PINS Q=csm_inst_left_reg[8] CLK=CTS_42
+ D=n_2886 RESETB=VDD SETB=n_29 VSS=VSS VDD=VDD
Xcsm_inst_left_reg_reg[9] DFFQSRX1 $PINS Q=csm_inst_left_reg[9] CLK=CTS_32
+ D=n_2884 RESETB=VDD SETB=n_29 VSS=VSS VDD=VDD
Xcsm_inst_left_reg_reg[10] DFFQSRX1 $PINS Q=csm_inst_left_reg[10] CLK=CTS_58
+ D=n_2843 RESETB=VDD SETB=n_29 VSS=VSS VDD=VDD
Xcsm_inst_left_reg_reg[11] DFFQSRX1 $PINS Q=csm_inst_left_reg[11] CLK=CTS_29
+ D=n_2840 RESETB=VDD SETB=n_29 VSS=VSS VDD=VDD
Xcsm_inst_left_reg_reg[12] DFFQSRX1 $PINS Q=csm_inst_left_reg[12] CLK=CTS_45
+ D=n_2839 RESETB=VDD SETB=n_29 VSS=VSS VDD=VDD
Xcsm_inst_left_reg_reg[13] DFFQSRX1 $PINS Q=csm_inst_left_reg[13] CLK=CTS_29
+ D=n_2980 RESETB=VDD SETB=n_29 VSS=VSS VDD=VDD
Xcsm_inst_left_reg_reg[14] DFFQSRX1 $PINS Q=csm_inst_left_reg[14] CLK=CTS_64
+ D=n_2984 RESETB=VDD SETB=n_29 VSS=VSS VDD=VDD
Xcsm_inst_left_reg_reg[15] DFFQSRX1 $PINS Q=csm_inst_left_reg[15] CLK=CTS_47
+ D=n_2990 RESETB=VDD SETB=n_29 VSS=VSS VDD=VDD
Xcsm_inst_left_reg_reg[16] DFFQSRX1 $PINS Q=csm_inst_left_reg[16] CLK=CTS_47
+ D=n_2989 RESETB=VDD SETB=n_29 VSS=VSS VDD=VDD
Xcsm_inst_left_reg_reg[17] DFFQSRX1 $PINS Q=csm_inst_left_reg[17] CLK=CTS_32
+ D=n_2985 RESETB=VDD SETB=n_29 VSS=VSS VDD=VDD
Xcsm_inst_left_reg_reg[18] DFFQSRX1 $PINS Q=csm_inst_left_reg[18] CLK=CTS_68
+ D=n_2982 RESETB=VDD SETB=n_29 VSS=VSS VDD=VDD
Xcsm_inst_left_reg_reg[19] DFFQSRX1 $PINS Q=csm_inst_left_reg[19] CLK=CTS_32
+ D=n_2981 RESETB=VDD SETB=n_29 VSS=VSS VDD=VDD
Xcsm_inst_left_reg_reg[20] DFFQSRX1 $PINS Q=csm_inst_left_reg[20] CLK=CTS_45
+ D=n_2976 RESETB=VDD SETB=n_29 VSS=VSS VDD=VDD
Xcsm_inst_left_reg_reg[21] DFFQSRX1 $PINS Q=csm_inst_left_reg[21] CLK=CTS_73
+ D=n_2974 RESETB=VDD SETB=n_29 VSS=VSS VDD=VDD
Xcsm_inst_left_reg_reg[22] DFFQSRX1 $PINS Q=csm_inst_left_reg[22] CLK=CTS_64
+ D=n_2973 RESETB=VDD SETB=n_29 VSS=VSS VDD=VDD
Xcsm_inst_left_reg_reg[23] DFFQSRX1 $PINS Q=csm_inst_left_reg[23] CLK=CTS_42
+ D=n_2940 RESETB=VDD SETB=n_29 VSS=VSS VDD=VDD
Xcsm_inst_left_reg_reg[24] DFFQSRX1 $PINS Q=csm_inst_left_reg[24] CLK=CTS_42
+ D=n_2875 RESETB=VDD SETB=n_29 VSS=VSS VDD=VDD
Xcsm_inst_left_reg_reg[25] DFFQSRX1 $PINS Q=csm_inst_left_reg[25] CLK=CTS_45
+ D=n_2904 RESETB=VDD SETB=n_29 VSS=VSS VDD=VDD
Xcsm_inst_left_reg_reg[26] DFFQSRX1 $PINS Q=csm_inst_left_reg[26] CLK=CTS_56
+ D=n_2902 RESETB=VDD SETB=n_29 VSS=VSS VDD=VDD
Xcsm_inst_left_reg_reg[27] DFFQSRX1 $PINS Q=csm_inst_left_reg[27] CLK=CTS_29
+ D=n_2890 RESETB=VDD SETB=n_29 VSS=VSS VDD=VDD
Xcsm_inst_left_reg_reg[28] DFFQSRX1 $PINS Q=csm_inst_left_reg[28] CLK=CTS_58
+ D=n_2888 RESETB=VDD SETB=n_29 VSS=VSS VDD=VDD
Xcsm_inst_left_reg_reg[29] DFFQSRX1 $PINS Q=csm_inst_left_reg[29] CLK=CTS_68
+ D=n_2885 RESETB=VDD SETB=n_29 VSS=VSS VDD=VDD
Xcsm_inst_left_reg_reg[30] DFFQSRX1 $PINS Q=csm_inst_left_reg[30] CLK=CTS_36
+ D=n_2874 RESETB=VDD SETB=n_29 VSS=VSS VDD=VDD
Xcsm_inst_left_reg_reg[31] DFFQSRX1 $PINS Q=csm_inst_left_reg[31] CLK=CTS_72
+ D=n_2860 RESETB=VDD SETB=n_29 VSS=VSS VDD=VDD
Xcsm_inst_mode_reg DFFQSRX1 $PINS Q=csm_inst_mode CLK=CTS_28 D=n_3518
+ RESETB=VDD SETB=n_29 VSS=VSS VDD=VDD
Xcsm_inst_output_text_reg[0] DFFQSRX1 $PINS Q=des_output[0] CLK=CTS_47 D=n_1920
+ RESETB=VDD SETB=n_29 VSS=VSS VDD=VDD
Xcsm_inst_output_text_reg[1] DFFQSRX1 $PINS Q=des_output[1] CLK=CTS_65 D=n_1914
+ RESETB=VDD SETB=n_29 VSS=VSS VDD=VDD
Xcsm_inst_output_text_reg[2] DFFQSRX1 $PINS Q=des_output[2] CLK=CTS_46 D=n_1912
+ RESETB=VDD SETB=n_29 VSS=VSS VDD=VDD
Xcsm_inst_output_text_reg[3] DFFQSRX1 $PINS Q=des_output[3] CLK=CTS_47 D=n_1909
+ RESETB=VDD SETB=n_29 VSS=VSS VDD=VDD
Xcsm_inst_output_text_reg[4] DFFQSRX1 $PINS Q=des_output[4] CLK=CTS_42 D=n_1906
+ RESETB=VDD SETB=n_29 VSS=VSS VDD=VDD
Xcsm_inst_output_text_reg[5] DFFQSRX1 $PINS Q=des_output[5] CLK=CTS_42 D=n_1902
+ RESETB=VDD SETB=n_29 VSS=VSS VDD=VDD
Xcsm_inst_output_text_reg[6] DFFQSRX1 $PINS Q=des_output[6] CLK=CTS_42 D=n_1900
+ RESETB=VDD SETB=n_29 VSS=VSS VDD=VDD
Xcsm_inst_output_text_reg[7] DFFQSRX1 $PINS Q=des_output[7] CLK=CTS_65 D=n_1899
+ RESETB=VDD SETB=n_29 VSS=VSS VDD=VDD
Xcsm_inst_output_text_reg[8] DFFQSRX1 $PINS Q=des_output[8] CLK=CTS_46 D=n_1894
+ RESETB=VDD SETB=n_29 VSS=VSS VDD=VDD
Xcsm_inst_output_text_reg[9] DFFQSRX1 $PINS Q=des_output[9] CLK=CTS_50 D=n_1891
+ RESETB=VDD SETB=n_29 VSS=VSS VDD=VDD
Xcsm_inst_output_text_reg[10] DFFQSRX1 $PINS Q=des_output[10] CLK=CTS_37
+ D=n_1885 RESETB=VDD SETB=n_29 VSS=VSS VDD=VDD
Xcsm_inst_output_text_reg[11] DFFQSRX1 $PINS Q=des_output[11] CLK=CTS_37
+ D=n_1880 RESETB=VDD SETB=n_29 VSS=VSS VDD=VDD
Xcsm_inst_output_text_reg[12] DFFQSRX1 $PINS Q=des_output[12] CLK=CTS_37
+ D=n_1863 RESETB=VDD SETB=n_29 VSS=VSS VDD=VDD
Xcsm_inst_output_text_reg[13] DFFQSRX1 $PINS Q=des_output[13] CLK=CTS_37
+ D=n_1861 RESETB=VDD SETB=n_29 VSS=VSS VDD=VDD
Xcsm_inst_output_text_reg[14] DFFQSRX1 $PINS Q=des_output[14] CLK=CTS_36
+ D=n_1858 RESETB=VDD SETB=n_29 VSS=VSS VDD=VDD
Xcsm_inst_output_text_reg[15] DFFQSRX1 $PINS Q=des_output[15] CLK=CTS_49
+ D=n_1855 RESETB=VDD SETB=n_29 VSS=VSS VDD=VDD
Xcsm_inst_output_text_reg[16] DFFQSRX1 $PINS Q=des_output[16] CLK=CTS_32
+ D=n_1852 RESETB=VDD SETB=n_29 VSS=VSS VDD=VDD
Xcsm_inst_output_text_reg[17] DFFQSRX1 $PINS Q=des_output[17] CLK=CTS_58
+ D=n_2104 RESETB=VDD SETB=n_29 VSS=VSS VDD=VDD
Xcsm_inst_output_text_reg[18] DFFQSRX1 $PINS Q=des_output[18] CLK=CTS_63
+ D=n_2123 RESETB=VDD SETB=n_29 VSS=VSS VDD=VDD
Xcsm_inst_output_text_reg[19] DFFQSRX1 $PINS Q=des_output[19] CLK=CTS_74
+ D=n_2124 RESETB=VDD SETB=n_29 VSS=VSS VDD=VDD
Xcsm_inst_output_text_reg[20] DFFQSRX1 $PINS Q=des_output[20] CLK=CTS_63
+ D=n_2132 RESETB=VDD SETB=n_29 VSS=VSS VDD=VDD
Xcsm_inst_output_text_reg[21] DFFQSRX1 $PINS Q=des_output[21] CLK=CTS_63
+ D=n_2150 RESETB=VDD SETB=n_29 VSS=VSS VDD=VDD
Xcsm_inst_output_text_reg[22] DFFQSRX1 $PINS Q=des_output[22] CLK=CTS_52
+ D=n_2171 RESETB=VDD SETB=n_29 VSS=VSS VDD=VDD
Xcsm_inst_output_text_reg[23] DFFQSRX1 $PINS Q=des_output[23] CLK=CTS_56
+ D=n_1924 RESETB=VDD SETB=n_29 VSS=VSS VDD=VDD
Xcsm_inst_output_text_reg[24] DFFQSRX1 $PINS Q=des_output[24] CLK=CTS_52
+ D=n_2173 RESETB=VDD SETB=n_29 VSS=VSS VDD=VDD
Xcsm_inst_output_text_reg[25] DFFQSRX1 $PINS Q=des_output[25] CLK=CTS_49
+ D=n_2176 RESETB=VDD SETB=n_29 VSS=VSS VDD=VDD
Xcsm_inst_output_text_reg[26] DFFQSRX1 $PINS Q=des_output[26] CLK=CTS_36
+ D=n_2092 RESETB=VDD SETB=n_29 VSS=VSS VDD=VDD
Xcsm_inst_output_text_reg[27] DFFQSRX1 $PINS Q=des_output[27] CLK=CTS_40
+ D=n_2091 RESETB=VDD SETB=n_29 VSS=VSS VDD=VDD
Xcsm_inst_output_text_reg[28] DFFQSRX1 $PINS Q=des_output[28] CLK=CTS_40
+ D=n_1865 RESETB=VDD SETB=n_29 VSS=VSS VDD=VDD
Xcsm_inst_output_text_reg[29] DFFQSRX1 $PINS Q=des_output[29] CLK=CTS_40
+ D=n_1952 RESETB=VDD SETB=n_29 VSS=VSS VDD=VDD
Xcsm_inst_output_text_reg[30] DFFQSRX1 $PINS Q=des_output[30] CLK=CTS_51
+ D=n_1922 RESETB=VDD SETB=n_29 VSS=VSS VDD=VDD
Xcsm_inst_output_text_reg[31] DFFQSRX1 $PINS Q=des_output[31] CLK=CTS_58
+ D=n_2082 RESETB=VDD SETB=n_29 VSS=VSS VDD=VDD
Xcsm_inst_output_text_reg[32] DFFQSRX1 $PINS Q=des_output[32] CLK=CTS_58
+ D=n_2080 RESETB=VDD SETB=n_29 VSS=VSS VDD=VDD
Xcsm_inst_output_text_reg[33] DFFQSRX1 $PINS Q=des_output[33] CLK=CTS_74
+ D=n_2078 RESETB=VDD SETB=n_29 VSS=VSS VDD=VDD
Xcsm_inst_output_text_reg[34] DFFQSRX1 $PINS Q=des_output[34] CLK=CTS_74
+ D=n_2071 RESETB=VDD SETB=n_29 VSS=VSS VDD=VDD
Xcsm_inst_output_text_reg[35] DFFQSRX1 $PINS Q=des_output[35] CLK=CTS_74
+ D=n_2105 RESETB=VDD SETB=n_29 VSS=VSS VDD=VDD
Xcsm_inst_output_text_reg[36] DFFQSRX1 $PINS Q=des_output[36] CLK=CTS_70
+ D=n_2026 RESETB=VDD SETB=n_29 VSS=VSS VDD=VDD
Xcsm_inst_output_text_reg[37] DFFQSRX1 $PINS Q=des_output[37] CLK=CTS_51
+ D=n_2012 RESETB=VDD SETB=n_29 VSS=VSS VDD=VDD
Xcsm_inst_output_text_reg[38] DFFQSRX1 $PINS Q=des_output[38] CLK=CTS_58
+ D=n_2002 RESETB=VDD SETB=n_29 VSS=VSS VDD=VDD
Xcsm_inst_output_text_reg[39] DFFQSRX1 $PINS Q=des_output[39] CLK=CTS_63
+ D=n_1995 RESETB=VDD SETB=n_29 VSS=VSS VDD=VDD
Xcsm_inst_output_text_reg[40] DFFQSRX1 $PINS Q=des_output[40] CLK=CTS_70
+ D=n_1990 RESETB=VDD SETB=n_29 VSS=VSS VDD=VDD
Xcsm_inst_output_text_reg[41] DFFQSRX1 $PINS Q=des_output[41] CLK=CTS_61
+ D=n_1984 RESETB=VDD SETB=n_29 VSS=VSS VDD=VDD
Xcsm_inst_output_text_reg[42] DFFQSRX1 $PINS Q=des_output[42] CLK=CTS_70
+ D=n_2153 RESETB=VDD SETB=n_29 VSS=VSS VDD=VDD
Xcsm_inst_output_text_reg[43] DFFQSRX1 $PINS Q=des_output[43] CLK=CTS_70
+ D=n_1964 RESETB=VDD SETB=n_29 VSS=VSS VDD=VDD
Xcsm_inst_output_text_reg[44] DFFQSRX1 $PINS Q=des_output[44] CLK=CTS_56
+ D=n_1956 RESETB=VDD SETB=n_29 VSS=VSS VDD=VDD
Xcsm_inst_output_text_reg[45] DFFQSRX1 $PINS Q=des_output[45] CLK=CTS_56
+ D=n_2133 RESETB=VDD SETB=n_29 VSS=VSS VDD=VDD
Xcsm_inst_output_text_reg[46] DFFQSRX1 $PINS Q=des_output[46] CLK=CTS_49
+ D=n_1948 RESETB=VDD SETB=n_29 VSS=VSS VDD=VDD
Xcsm_inst_output_text_reg[47] DFFQSRX1 $PINS Q=des_output[47] CLK=CTS_56
+ D=n_1943 RESETB=VDD SETB=n_29 VSS=VSS VDD=VDD
Xcsm_inst_output_text_reg[48] DFFQSRX1 $PINS Q=des_output[48] CLK=CTS_61
+ D=n_1942 RESETB=VDD SETB=n_29 VSS=VSS VDD=VDD
Xcsm_inst_output_text_reg[49] DFFQSRX1 $PINS Q=des_output[49] CLK=CTS_61
+ D=n_1941 RESETB=VDD SETB=n_29 VSS=VSS VDD=VDD
Xcsm_inst_output_text_reg[50] DFFQSRX1 $PINS Q=des_output[50] CLK=CTS_70
+ D=n_1940 RESETB=VDD SETB=n_29 VSS=VSS VDD=VDD
Xcsm_inst_output_text_reg[51] DFFQSRX1 $PINS Q=des_output[51] CLK=CTS_51
+ D=n_1905 RESETB=VDD SETB=n_29 VSS=VSS VDD=VDD
Xcsm_inst_output_text_reg[52] DFFQSRX1 $PINS Q=des_output[52] CLK=CTS_51
+ D=n_1917 RESETB=VDD SETB=n_29 VSS=VSS VDD=VDD
Xcsm_inst_output_text_reg[53] DFFQSRX1 $PINS Q=des_output[53] CLK=CTS_51
+ D=n_1939 RESETB=VDD SETB=n_29 VSS=VSS VDD=VDD
Xcsm_inst_output_text_reg[54] DFFQSRX1 $PINS Q=des_output[54] CLK=CTS_40
+ D=n_2160 RESETB=VDD SETB=n_29 VSS=VSS VDD=VDD
Xcsm_inst_output_text_reg[55] DFFQSRX1 $PINS Q=des_output[55] CLK=CTS_62
+ D=n_1923 RESETB=VDD SETB=n_29 VSS=VSS VDD=VDD
Xcsm_inst_output_text_reg[56] DFFQSRX1 $PINS Q=des_output[56] CLK=CTS_64
+ D=n_2093 RESETB=VDD SETB=n_29 VSS=VSS VDD=VDD
Xcsm_inst_output_text_reg[57] DFFQSRX1 $PINS Q=des_output[57] CLK=CTS_64
+ D=n_2180 RESETB=VDD SETB=n_29 VSS=VSS VDD=VDD
Xcsm_inst_output_text_reg[58] DFFQSRX1 $PINS Q=des_output[58] CLK=CTS_64
+ D=n_1916 RESETB=VDD SETB=n_29 VSS=VSS VDD=VDD
Xcsm_inst_output_text_reg[59] DFFQSRX1 $PINS Q=des_output[59] CLK=CTS_41
+ D=n_1931 RESETB=VDD SETB=n_29 VSS=VSS VDD=VDD
Xcsm_inst_output_text_reg[60] DFFQSRX1 $PINS Q=des_output[60] CLK=CTS_46
+ D=n_1911 RESETB=VDD SETB=n_29 VSS=VSS VDD=VDD
Xcsm_inst_output_text_reg[61] DFFQSRX1 $PINS Q=des_output[61] CLK=CTS_50
+ D=n_2081 RESETB=VDD SETB=n_29 VSS=VSS VDD=VDD
Xcsm_inst_output_text_reg[62] DFFQSRX1 $PINS Q=des_output[62] CLK=CTS_41
+ D=n_1929 RESETB=VDD SETB=n_29 VSS=VSS VDD=VDD
Xcsm_inst_output_text_reg[63] DFFQSRX1 $PINS Q=des_output[63] CLK=CTS_41
+ D=n_1926 RESETB=VDD SETB=n_29 VSS=VSS VDD=VDD
Xcsm_inst_right_reg_reg[0] DFFQSRX1 $PINS Q=csm_inst_right_reg[0] CLK=CTS_21
+ D=n_5873 RESETB=VDD SETB=n_29 VSS=VSS VDD=VDD
Xcsm_inst_right_reg_reg[1] DFFQSRX1 $PINS Q=csm_inst_right_reg[1] CLK=CTS_32
+ D=n_5838 RESETB=VDD SETB=n_29 VSS=VSS VDD=VDD
Xcsm_inst_right_reg_reg[2] DFFQSRX1 $PINS Q=csm_inst_right_reg[2] CLK=CTS_51
+ D=n_5840 RESETB=VDD SETB=n_29 VSS=VSS VDD=VDD
Xcsm_inst_right_reg_reg[3] DFFQSRX1 $PINS Q=csm_inst_right_reg[3] CLK=CTS_19
+ D=n_5877 RESETB=VDD SETB=n_29 VSS=VSS VDD=VDD
Xcsm_inst_right_reg_reg[4] DFFQSRX1 $PINS Q=csm_inst_right_reg[4] CLK=CTS_49
+ D=n_5812 RESETB=VDD SETB=n_29 VSS=VSS VDD=VDD
Xcsm_inst_right_reg_reg[5] DFFQSRX1 $PINS Q=csm_inst_right_reg[5] CLK=CTS_31
+ D=n_5874 RESETB=VDD SETB=n_29 VSS=VSS VDD=VDD
Xcsm_inst_right_reg_reg[6] DFFQSRX1 $PINS Q=csm_inst_right_reg[6] CLK=CTS_72
+ D=n_5847 RESETB=VDD SETB=n_29 VSS=VSS VDD=VDD
Xcsm_inst_right_reg_reg[7] DFFQSRX1 $PINS Q=csm_inst_right_reg[7] CLK=CTS_21
+ D=n_5791 RESETB=VDD SETB=n_29 VSS=VSS VDD=VDD
Xcsm_inst_right_reg_reg[8] DFFQSRX1 $PINS Q=csm_inst_right_reg[8] CLK=CTS_44
+ D=n_5843 RESETB=VDD SETB=n_29 VSS=VSS VDD=VDD
Xcsm_inst_right_reg_reg[9] DFFQSRX1 $PINS Q=csm_inst_right_reg[9] CLK=CTS_68
+ D=n_5870 RESETB=VDD SETB=n_29 VSS=VSS VDD=VDD
Xcsm_inst_right_reg_reg[10] DFFQSRX1 $PINS Q=csm_inst_right_reg[10] CLK=CTS_31
+ D=n_5876 RESETB=VDD SETB=n_29 VSS=VSS VDD=VDD
Xcsm_inst_right_reg_reg[11] DFFQSRX1 $PINS Q=csm_inst_right_reg[11] CLK=CTS_73
+ D=n_5872 RESETB=VDD SETB=n_29 VSS=VSS VDD=VDD
Xcsm_inst_right_reg_reg[12] DFFQSRX1 $PINS Q=csm_inst_right_reg[12] CLK=CTS_20
+ D=n_5868 RESETB=VDD SETB=n_29 VSS=VSS VDD=VDD
Xcsm_inst_right_reg_reg[13] DFFQSRX1 $PINS Q=csm_inst_right_reg[13] CLK=CTS_73
+ D=n_5802 RESETB=VDD SETB=n_29 VSS=VSS VDD=VDD
Xcsm_inst_right_reg_reg[14] DFFQSRX1 $PINS Q=csm_inst_right_reg[14] CLK=CTS_45
+ D=n_5820 RESETB=VDD SETB=n_29 VSS=VSS VDD=VDD
Xcsm_inst_right_reg_reg[15] DFFQSRX1 $PINS Q=csm_inst_right_reg[15] CLK=CTS_44
+ D=n_5827 RESETB=VDD SETB=n_29 VSS=VSS VDD=VDD
Xcsm_inst_right_reg_reg[16] DFFQSRX1 $PINS Q=csm_inst_right_reg[16] CLK=CTS_44
+ D=n_5855 RESETB=VDD SETB=n_29 VSS=VSS VDD=VDD
Xcsm_inst_right_reg_reg[17] DFFQSRX1 $PINS Q=csm_inst_right_reg[17] CLK=CTS_31
+ D=n_5826 RESETB=VDD SETB=n_29 VSS=VSS VDD=VDD
Xcsm_inst_right_reg_reg[18] DFFQSRX1 $PINS Q=csm_inst_right_reg[18] CLK=CTS_56
+ D=n_5789 RESETB=VDD SETB=n_29 VSS=VSS VDD=VDD
Xcsm_inst_right_reg_reg[19] DFFQSRX1 $PINS Q=csm_inst_right_reg[19] CLK=CTS_49
+ D=n_5798 RESETB=VDD SETB=n_29 VSS=VSS VDD=VDD
Xcsm_inst_right_reg_reg[20] DFFQSRX1 $PINS Q=csm_inst_right_reg[20] CLK=CTS_24
+ D=n_5857 RESETB=VDD SETB=n_29 VSS=VSS VDD=VDD
Xcsm_inst_right_reg_reg[21] DFFQSRX1 $PINS Q=csm_inst_right_reg[21] CLK=CTS_73
+ D=n_5788 RESETB=VDD SETB=n_29 VSS=VSS VDD=VDD
Xcsm_inst_right_reg_reg[22] DFFQSRX1 $PINS Q=csm_inst_right_reg[22] CLK=CTS_45
+ D=n_5869 RESETB=VDD SETB=n_29 VSS=VSS VDD=VDD
Xcsm_inst_right_reg_reg[23] DFFQSRX1 $PINS Q=csm_inst_right_reg[23] CLK=CTS_64
+ D=n_5841 RESETB=VDD SETB=n_29 VSS=VSS VDD=VDD
Xcsm_inst_right_reg_reg[24] DFFQSRX1 $PINS Q=csm_inst_right_reg[24] CLK=CTS_64
+ D=n_5821 RESETB=VDD SETB=n_29 VSS=VSS VDD=VDD
Xcsm_inst_right_reg_reg[25] DFFQSRX1 $PINS Q=csm_inst_right_reg[25] CLK=CTS_24
+ D=n_5837 RESETB=VDD SETB=n_29 VSS=VSS VDD=VDD
Xcsm_inst_right_reg_reg[26] DFFQSRX1 $PINS Q=csm_inst_right_reg[26] CLK=CTS_68
+ D=n_5803 RESETB=VDD SETB=n_29 VSS=VSS VDD=VDD
Xcsm_inst_right_reg_reg[27] DFFQSRX1 $PINS Q=csm_inst_right_reg[27] CLK=CTS_29
+ D=n_5839 RESETB=VDD SETB=n_29 VSS=VSS VDD=VDD
Xcsm_inst_right_reg_reg[28] DFFQSRX1 $PINS Q=csm_inst_right_reg[28] CLK=CTS_73
+ D=n_5772 RESETB=VDD SETB=n_29 VSS=VSS VDD=VDD
Xcsm_inst_right_reg_reg[29] DFFQSRX1 $PINS Q=csm_inst_right_reg[29] CLK=CTS_68
+ D=n_5804 RESETB=VDD SETB=n_29 VSS=VSS VDD=VDD
Xcsm_inst_right_reg_reg[30] DFFQSRX1 $PINS Q=csm_inst_right_reg[30] CLK=CTS_49
+ D=n_5829 RESETB=VDD SETB=n_29 VSS=VSS VDD=VDD
Xcsm_inst_right_reg_reg[31] DFFQSRX1 $PINS Q=csm_inst_right_reg[31] CLK=CTS_72
+ D=n_5871 RESETB=VDD SETB=n_29 VSS=VSS VDD=VDD
Xcsm_inst_round_counter_reg[0] DFFQSRX1 $PINS Q=csm_inst_round_counter[0]
+ CLK=CTS_12 D=n_2200 RESETB=VDD SETB=n_29 VSS=VSS VDD=VDD
Xcsm_inst_round_counter_reg[1] DFFQSRX1 $PINS Q=csm_inst_round_counter[1]
+ CLK=CTS_12 D=n_3309 RESETB=VDD SETB=n_29 VSS=VSS VDD=VDD
Xcsm_inst_round_counter_reg[2] DFFQSRX1 $PINS Q=csm_inst_round_counter[2]
+ CLK=CTS_12 D=n_3308 RESETB=VDD SETB=n_29 VSS=VSS VDD=VDD
Xcsm_inst_round_counter_reg[3] DFFQSRX1 $PINS Q=csm_inst_round_counter[3]
+ CLK=CTS_15 D=n_3442 RESETB=VDD SETB=n_29 VSS=VSS VDD=VDD
Xcsm_inst_state_reg[0] DFFQSRX1 $PINS Q=csm_inst_state[0] CLK=CTS_14 D=n_3000
+ RESETB=VDD SETB=n_29 VSS=VSS VDD=VDD
Xcsm_inst_state_reg[1] DFFQSRX1 $PINS Q=csm_inst_state[1] CLK=CTS_25 D=n_27
+ RESETB=VDD SETB=n_29 VSS=VSS VDD=VDD
Xcsm_inst_state_reg[2] DFFQSRX1 $PINS Q=csm_inst_state[2] CLK=CTS_14 D=n_2595
+ RESETB=VDD SETB=n_29 VSS=VSS VDD=VDD
Xdata_reg_reg[0] DFFQSRX1 $PINS Q=data_reg[0] CLK=CTS_8 D=n_2079 RESETB=VDD
+ SETB=n_29 VSS=VSS VDD=VDD
Xdata_reg_reg[1] DFFQSRX1 $PINS Q=data_reg[1] CLK=CTS_15 D=n_2077 RESETB=VDD
+ SETB=n_29 VSS=VSS VDD=VDD
Xdata_reg_reg[2] DFFQSRX1 $PINS Q=data_reg[2] CLK=CTS_8 D=n_1936 RESETB=VDD
+ SETB=n_29 VSS=VSS VDD=VDD
Xdata_reg_reg[3] DFFQSRX1 $PINS Q=data_reg[3] CLK=CTS_15 D=n_2067 RESETB=VDD
+ SETB=n_29 VSS=VSS VDD=VDD
Xdata_reg_reg[4] DFFQSRX1 $PINS Q=data_reg[4] CLK=CTS_8 D=n_2037 RESETB=VDD
+ SETB=n_29 VSS=VSS VDD=VDD
Xdata_reg_reg[5] DFFQSRX1 $PINS Q=data_reg[5] CLK=CTS_8 D=n_2066 RESETB=VDD
+ SETB=n_29 VSS=VSS VDD=VDD
Xdata_reg_reg[6] DFFQSRX1 $PINS Q=data_reg[6] CLK=CTS_11 D=n_2065 RESETB=VDD
+ SETB=n_29 VSS=VSS VDD=VDD
Xdata_reg_reg[7] DFFQSRX1 $PINS Q=data_reg[7] CLK=CTS_11 D=n_2060 RESETB=VDD
+ SETB=n_29 VSS=VSS VDD=VDD
Xdata_reg_reg[8] DFFQSRX1 $PINS Q=data_reg[8] CLK=CTS_65 D=n_2056 RESETB=VDD
+ SETB=n_29 VSS=VSS VDD=VDD
Xdata_reg_reg[9] DFFQSRX1 $PINS Q=data_reg[9] CLK=CTS_11 D=n_2055 RESETB=VDD
+ SETB=n_29 VSS=VSS VDD=VDD
Xdata_reg_reg[10] DFFQSRX1 $PINS Q=data_reg[10] CLK=CTS_21 D=n_2053 RESETB=VDD
+ SETB=n_29 VSS=VSS VDD=VDD
Xdata_reg_reg[11] DFFQSRX1 $PINS Q=data_reg[11] CLK=CTS_21 D=n_2049 RESETB=VDD
+ SETB=n_29 VSS=VSS VDD=VDD
Xdata_reg_reg[12] DFFQSRX1 $PINS Q=data_reg[12] CLK=CTS_44 D=n_1872 RESETB=VDD
+ SETB=n_29 VSS=VSS VDD=VDD
Xdata_reg_reg[13] DFFQSRX1 $PINS Q=data_reg[13] CLK=CTS_21 D=n_2044 RESETB=VDD
+ SETB=n_29 VSS=VSS VDD=VDD
Xdata_reg_reg[14] DFFQSRX1 $PINS Q=data_reg[14] CLK=CTS_20 D=n_2103 RESETB=VDD
+ SETB=n_29 VSS=VSS VDD=VDD
Xdata_reg_reg[15] DFFQSRX1 $PINS Q=data_reg[15] CLK=CTS_20 D=n_2038 RESETB=VDD
+ SETB=n_29 VSS=VSS VDD=VDD
Xdata_reg_reg[16] DFFQSRX1 $PINS Q=data_reg[16] CLK=CTS_31 D=n_2134 RESETB=VDD
+ SETB=n_29 VSS=VSS VDD=VDD
Xdata_reg_reg[17] DFFQSRX1 $PINS Q=data_reg[17] CLK=CTS_73 D=n_2030 RESETB=VDD
+ SETB=n_29 VSS=VSS VDD=VDD
Xdata_reg_reg[18] DFFQSRX1 $PINS Q=data_reg[18] CLK=CTS_16 D=n_1866 RESETB=VDD
+ SETB=n_29 VSS=VSS VDD=VDD
Xdata_reg_reg[19] DFFQSRX1 $PINS Q=data_reg[19] CLK=CTS_16 D=n_2025 RESETB=VDD
+ SETB=n_29 VSS=VSS VDD=VDD
Xdata_reg_reg[20] DFFQSRX1 $PINS Q=data_reg[20] CLK=CTS_16 D=n_1925 RESETB=VDD
+ SETB=n_29 VSS=VSS VDD=VDD
Xdata_reg_reg[21] DFFQSRX1 $PINS Q=data_reg[21] CLK=CTS_16 D=n_2024 RESETB=VDD
+ SETB=n_29 VSS=VSS VDD=VDD
Xdata_reg_reg[22] DFFQSRX1 $PINS Q=data_reg[22] CLK=CTS_55 D=n_2023 RESETB=VDD
+ SETB=n_29 VSS=VSS VDD=VDD
Xdata_reg_reg[23] DFFQSRX1 $PINS Q=data_reg[23] CLK=CTS_55 D=n_2018 RESETB=VDD
+ SETB=n_29 VSS=VSS VDD=VDD
Xdata_reg_reg[24] DFFQSRX1 $PINS Q=data_reg[24] CLK=CTS_68 D=n_2017 RESETB=VDD
+ SETB=n_29 VSS=VSS VDD=VDD
Xdata_reg_reg[25] DFFQSRX1 $PINS Q=data_reg[25] CLK=CTS_55 D=n_2016 RESETB=VDD
+ SETB=n_29 VSS=VSS VDD=VDD
Xdata_reg_reg[26] DFFQSRX1 $PINS Q=data_reg[26] CLK=CTS_20 D=n_1882 RESETB=VDD
+ SETB=n_29 VSS=VSS VDD=VDD
Xdata_reg_reg[27] DFFQSRX1 $PINS Q=data_reg[27] CLK=CTS_20 D=n_2007 RESETB=VDD
+ SETB=n_29 VSS=VSS VDD=VDD
Xdata_reg_reg[28] DFFQSRX1 $PINS Q=data_reg[28] CLK=CTS_24 D=n_2149 RESETB=VDD
+ SETB=n_29 VSS=VSS VDD=VDD
Xdata_reg_reg[29] DFFQSRX1 $PINS Q=data_reg[29] CLK=CTS_24 D=n_1856 RESETB=VDD
+ SETB=n_29 VSS=VSS VDD=VDD
Xdata_reg_reg[30] DFFQSRX1 $PINS Q=data_reg[30] CLK=CTS_35 D=n_2003 RESETB=VDD
+ SETB=n_29 VSS=VSS VDD=VDD
Xdata_reg_reg[31] DFFQSRX1 $PINS Q=data_reg[31] CLK=CTS_35 D=n_2001 RESETB=VDD
+ SETB=n_29 VSS=VSS VDD=VDD
Xdata_reg_reg[32] DFFQSRX1 $PINS Q=data_reg[32] CLK=CTS_19 D=n_2000 RESETB=VDD
+ SETB=n_29 VSS=VSS VDD=VDD
Xdata_reg_reg[33] DFFQSRX1 $PINS Q=data_reg[33] CLK=CTS_16 D=n_1999 RESETB=VDD
+ SETB=n_29 VSS=VSS VDD=VDD
Xdata_reg_reg[34] DFFQSRX1 $PINS Q=data_reg[34] CLK=CTS_16 D=n_2131 RESETB=VDD
+ SETB=n_29 VSS=VSS VDD=VDD
Xdata_reg_reg[35] DFFQSRX1 $PINS Q=data_reg[35] CLK=CTS_16 D=n_1998 RESETB=VDD
+ SETB=n_29 VSS=VSS VDD=VDD
Xdata_reg_reg[36] DFFQSRX1 $PINS Q=data_reg[36] CLK=CTS_30 D=n_2172 RESETB=VDD
+ SETB=n_29 VSS=VSS VDD=VDD
Xdata_reg_reg[37] DFFQSRX1 $PINS Q=data_reg[37] CLK=CTS_30 D=n_1997 RESETB=VDD
+ SETB=n_29 VSS=VSS VDD=VDD
Xdata_reg_reg[38] DFFQSRX1 $PINS Q=data_reg[38] CLK=CTS_19 D=n_1996 RESETB=VDD
+ SETB=n_29 VSS=VSS VDD=VDD
Xdata_reg_reg[39] DFFQSRX1 $PINS Q=data_reg[39] CLK=CTS_19 D=n_1994 RESETB=VDD
+ SETB=n_29 VSS=VSS VDD=VDD
Xdata_reg_reg[40] DFFQSRX1 $PINS Q=data_reg[40] CLK=CTS_31 D=n_1904 RESETB=VDD
+ SETB=n_29 VSS=VSS VDD=VDD
Xdata_reg_reg[41] DFFQSRX1 $PINS Q=data_reg[41] CLK=CTS_2 D=n_1913 RESETB=VDD
+ SETB=n_29 VSS=VSS VDD=VDD
Xdata_reg_reg[42] DFFQSRX1 $PINS Q=data_reg[42] CLK=CTS_30 D=n_1932 RESETB=VDD
+ SETB=n_29 VSS=VSS VDD=VDD
Xdata_reg_reg[43] DFFQSRX1 $PINS Q=data_reg[43] CLK=CTS_30 D=n_1993 RESETB=VDD
+ SETB=n_29 VSS=VSS VDD=VDD
Xdata_reg_reg[44] DFFQSRX1 $PINS Q=data_reg[44] CLK=CTS_35 D=n_1935 RESETB=VDD
+ SETB=n_29 VSS=VSS VDD=VDD
Xdata_reg_reg[45] DFFQSRX1 $PINS Q=data_reg[45] CLK=CTS_55 D=n_1989 RESETB=VDD
+ SETB=n_29 VSS=VSS VDD=VDD
Xdata_reg_reg[46] DFFQSRX1 $PINS Q=data_reg[46] CLK=CTS_55 D=n_2106 RESETB=VDD
+ SETB=n_29 VSS=VSS VDD=VDD
Xdata_reg_reg[47] DFFQSRX1 $PINS Q=data_reg[47] CLK=CTS_35 D=n_2085 RESETB=VDD
+ SETB=n_29 VSS=VSS VDD=VDD
Xdata_reg_reg[48] DFFQSRX1 $PINS Q=data_reg[48] CLK=CTS_31 D=n_2121 RESETB=VDD
+ SETB=n_29 VSS=VSS VDD=VDD
Xdata_reg_reg[49] DFFQSRX1 $PINS Q=data_reg[49] CLK=CTS_30 D=n_1910 RESETB=VDD
+ SETB=n_29 VSS=VSS VDD=VDD
Xdata_reg_reg[50] DFFQSRX1 $PINS Q=data_reg[50] CLK=CTS_30 D=n_1857 RESETB=VDD
+ SETB=n_29 VSS=VSS VDD=VDD
Xdata_reg_reg[51] DFFQSRX1 $PINS Q=data_reg[51] CLK=CTS_35 D=n_2114 RESETB=VDD
+ SETB=n_29 VSS=VSS VDD=VDD
Xdata_reg_reg[52] DFFQSRX1 $PINS Q=data_reg[52] CLK=CTS_35 D=n_1921 RESETB=VDD
+ SETB=n_29 VSS=VSS VDD=VDD
Xdata_reg_reg[53] DFFQSRX1 $PINS Q=data_reg[53] CLK=CTS_55 D=n_1982 RESETB=VDD
+ SETB=n_29 VSS=VSS VDD=VDD
Xdata_reg_reg[54] DFFQSRX1 $PINS Q=data_reg[54] CLK=CTS_24 D=n_1896 RESETB=VDD
+ SETB=n_29 VSS=VSS VDD=VDD
Xdata_reg_reg[55] DFFQSRX1 $PINS Q=data_reg[55] CLK=CTS_24 D=n_2145 RESETB=VDD
+ SETB=n_29 VSS=VSS VDD=VDD
Xdata_reg_reg[56] DFFQSRX1 $PINS Q=data_reg[56] CLK=CTS_72 D=n_1898 RESETB=VDD
+ SETB=n_29 VSS=VSS VDD=VDD
Xdata_reg_reg[57] DFFQSRX1 $PINS Q=data_reg[57] CLK=CTS_6 D=n_1981 RESETB=VDD
+ SETB=n_29 VSS=VSS VDD=VDD
Xdata_reg_reg[58] DFFQSRX1 $PINS Q=data_reg[58] CLK=CTS_72 D=n_1908 RESETB=VDD
+ SETB=n_29 VSS=VSS VDD=VDD
Xdata_reg_reg[59] DFFQSRX1 $PINS Q=data_reg[59] CLK=CTS_6 D=n_1980 RESETB=VDD
+ SETB=n_29 VSS=VSS VDD=VDD
Xdata_reg_reg[60] DFFQSRX1 $PINS Q=data_reg[60] CLK=CTS_72 D=n_1975 RESETB=VDD
+ SETB=n_29 VSS=VSS VDD=VDD
Xdata_reg_reg[61] DFFQSRX1 $PINS Q=data_reg[61] CLK=CTS_11 D=n_1974 RESETB=VDD
+ SETB=n_29 VSS=VSS VDD=VDD
Xdata_reg_reg[62] DFFQSRX1 $PINS Q=data_reg[62] CLK=CTS_44 D=n_2122 RESETB=VDD
+ SETB=n_29 VSS=VSS VDD=VDD
Xdata_reg_reg[63] DFFQSRX1 $PINS Q=data_reg[63] CLK=CTS_44 D=n_1970 RESETB=VDD
+ SETB=n_29 VSS=VSS VDD=VDD
Xdone_decrypt_latched_reg DFFQSRX1 $PINS Q=done_decrypt_latched CLK=CTS_14
+ D=n_393 RESETB=VDD SETB=n_29 VSS=VSS VDD=VDD
Xdone_encrypt_latched_reg DFFQSRX1 $PINS Q=done_encrypt_latched CLK=CTS_14
+ D=n_544 RESETB=VDD SETB=n_29 VSS=VSS VDD=VDD
Xkey_reg_reg[1] DFFQSRX1 $PINS Q=key_reg[1] CLK=CTS_12 D=n_872 RESETB=VDD
+ SETB=n_29 VSS=VSS VDD=VDD
Xkey_reg_reg[2] DFFQSRX1 $PINS Q=key_reg[2] CLK=CTS_15 D=n_916 RESETB=VDD
+ SETB=n_29 VSS=VSS VDD=VDD
Xkey_reg_reg[3] DFFQSRX1 $PINS Q=key_reg[3] CLK=CTS_15 D=n_871 RESETB=VDD
+ SETB=n_29 VSS=VSS VDD=VDD
Xkey_reg_reg[4] DFFQSRX1 $PINS Q=key_reg[4] CLK=CTS_15 D=n_1050 RESETB=VDD
+ SETB=n_29 VSS=VSS VDD=VDD
Xkey_reg_reg[5] DFFQSRX1 $PINS Q=key_reg[5] CLK=CTS_15 D=n_870 RESETB=VDD
+ SETB=n_29 VSS=VSS VDD=VDD
Xkey_reg_reg[6] DFFQSRX1 $PINS Q=key_reg[6] CLK=CTS_6 D=n_869 RESETB=VDD
+ SETB=n_29 VSS=VSS VDD=VDD
Xkey_reg_reg[7] DFFQSRX1 $PINS Q=key_reg[7] CLK=CTS_8 D=n_873 RESETB=VDD
+ SETB=n_29 VSS=VSS VDD=VDD
Xkey_reg_reg[9] DFFQSRX1 $PINS Q=key_reg[9] CLK=CTS_6 D=n_1070 RESETB=VDD
+ SETB=n_29 VSS=VSS VDD=VDD
Xkey_reg_reg[10] DFFQSRX1 $PINS Q=key_reg[10] CLK=CTS_25 D=n_868 RESETB=VDD
+ SETB=n_29 VSS=VSS VDD=VDD
Xkey_reg_reg[11] DFFQSRX1 $PINS Q=key_reg[11] CLK=CTS_7 D=n_1055 RESETB=VDD
+ SETB=n_29 VSS=VSS VDD=VDD
Xkey_reg_reg[12] DFFQSRX1 $PINS Q=key_reg[12] CLK=CTS_25 D=n_984 RESETB=VDD
+ SETB=n_29 VSS=VSS VDD=VDD
Xkey_reg_reg[13] DFFQSRX1 $PINS Q=key_reg[13] CLK=CTS_7 D=n_975 RESETB=VDD
+ SETB=n_29 VSS=VSS VDD=VDD
Xkey_reg_reg[14] DFFQSRX1 $PINS Q=key_reg[14] CLK=CTS_7 D=n_927 RESETB=VDD
+ SETB=n_29 VSS=VSS VDD=VDD
Xkey_reg_reg[15] DFFQSRX1 $PINS Q=key_reg[15] CLK=CTS_23 D=n_1105 RESETB=VDD
+ SETB=n_29 VSS=VSS VDD=VDD
Xkey_reg_reg[17] DFFQSRX1 $PINS Q=key_reg[17] CLK=CTS_1 D=n_874 RESETB=VDD
+ SETB=n_29 VSS=VSS VDD=VDD
Xkey_reg_reg[18] DFFQSRX1 $PINS Q=key_reg[18] CLK=CTS_2 D=n_1184 RESETB=VDD
+ SETB=n_29 VSS=VSS VDD=VDD
Xkey_reg_reg[19] DFFQSRX1 $PINS Q=key_reg[19] CLK=CTS_34 D=n_866 RESETB=VDD
+ SETB=n_29 VSS=VSS VDD=VDD
Xkey_reg_reg[20] DFFQSRX1 $PINS Q=key_reg[20] CLK=CTS_34 D=n_895 RESETB=VDD
+ SETB=n_29 VSS=VSS VDD=VDD
Xkey_reg_reg[21] DFFQSRX1 $PINS Q=key_reg[21] CLK=CTS_34 D=n_864 RESETB=VDD
+ SETB=n_29 VSS=VSS VDD=VDD
Xkey_reg_reg[22] DFFQSRX1 $PINS Q=key_reg[22] CLK=CTS_23 D=n_1028 RESETB=VDD
+ SETB=n_29 VSS=VSS VDD=VDD
Xkey_reg_reg[23] DFFQSRX1 $PINS Q=key_reg[23] CLK=CTS_23 D=n_850 RESETB=VDD
+ SETB=n_29 VSS=VSS VDD=VDD
Xkey_reg_reg[25] DFFQSRX1 $PINS Q=key_reg[25] CLK=CTS_5 D=n_1162 RESETB=VDD
+ SETB=n_29 VSS=VSS VDD=VDD
Xkey_reg_reg[26] DFFQSRX1 $PINS Q=key_reg[26] CLK=CTS_23 D=n_1011 RESETB=VDD
+ SETB=n_29 VSS=VSS VDD=VDD
Xkey_reg_reg[27] DFFQSRX1 $PINS Q=key_reg[27] CLK=CTS_23 D=n_1001 RESETB=VDD
+ SETB=n_29 VSS=VSS VDD=VDD
Xkey_reg_reg[28] DFFQSRX1 $PINS Q=key_reg[28] CLK=CTS_7 D=n_820 RESETB=VDD
+ SETB=n_29 VSS=VSS VDD=VDD
Xkey_reg_reg[29] DFFQSRX1 $PINS Q=key_reg[29] CLK=CTS_7 D=n_818 RESETB=VDD
+ SETB=n_29 VSS=VSS VDD=VDD
Xkey_reg_reg[30] DFFQSRX1 $PINS Q=key_reg[30] CLK=CTS_23 D=n_817 RESETB=VDD
+ SETB=n_29 VSS=VSS VDD=VDD
Xkey_reg_reg[31] DFFQSRX1 $PINS Q=key_reg[31] CLK=CTS_5 D=n_811 RESETB=VDD
+ SETB=n_29 VSS=VSS VDD=VDD
Xkey_reg_reg[33] DFFQSRX1 $PINS Q=key_reg[33] CLK=CTS_34 D=n_875 RESETB=VDD
+ SETB=n_29 VSS=VSS VDD=VDD
Xkey_reg_reg[34] DFFQSRX1 $PINS Q=key_reg[34] CLK=CTS_34 D=n_1008 RESETB=VDD
+ SETB=n_29 VSS=VSS VDD=VDD
Xkey_reg_reg[35] DFFQSRX1 $PINS Q=key_reg[35] CLK=CTS_34 D=n_998 RESETB=VDD
+ SETB=n_29 VSS=VSS VDD=VDD
Xkey_reg_reg[36] DFFQSRX1 $PINS Q=key_reg[36] CLK=CTS_1 D=n_1163 RESETB=VDD
+ SETB=n_29 VSS=VSS VDD=VDD
Xkey_reg_reg[37] DFFQSRX1 $PINS Q=key_reg[37] CLK=CTS_2 D=n_1058 RESETB=VDD
+ SETB=n_29 VSS=VSS VDD=VDD
Xkey_reg_reg[38] DFFQSRX1 $PINS Q=key_reg[38] CLK=CTS_2 D=n_1131 RESETB=VDD
+ SETB=n_29 VSS=VSS VDD=VDD
Xkey_reg_reg[39] DFFQSRX1 $PINS Q=key_reg[39] CLK=CTS_2 D=n_926 RESETB=VDD
+ SETB=n_29 VSS=VSS VDD=VDD
Xkey_reg_reg[41] DFFQSRX1 $PINS Q=key_reg[41] CLK=CTS_2 D=n_899 RESETB=VDD
+ SETB=n_29 VSS=VSS VDD=VDD
Xkey_reg_reg[42] DFFQSRX1 $PINS Q=key_reg[42] CLK=CTS_2 D=n_816 RESETB=VDD
+ SETB=n_29 VSS=VSS VDD=VDD
Xkey_reg_reg[43] DFFQSRX1 $PINS Q=key_reg[43] CLK=CTS_1 D=n_867 RESETB=VDD
+ SETB=n_29 VSS=VSS VDD=VDD
Xkey_reg_reg[44] DFFQSRX1 $PINS Q=key_reg[44] CLK=CTS_5 D=n_910 RESETB=VDD
+ SETB=n_29 VSS=VSS VDD=VDD
Xkey_reg_reg[45] DFFQSRX1 $PINS Q=key_reg[45] CLK=CTS_5 D=n_880 RESETB=VDD
+ SETB=n_29 VSS=VSS VDD=VDD
Xkey_reg_reg[46] DFFQSRX1 $PINS Q=key_reg[46] CLK=CTS_5 D=n_815 RESETB=VDD
+ SETB=n_29 VSS=VSS VDD=VDD
Xkey_reg_reg[47] DFFQSRX1 $PINS Q=key_reg[47] CLK=CTS_5 D=n_814 RESETB=VDD
+ SETB=n_29 VSS=VSS VDD=VDD
Xkey_reg_reg[49] DFFQSRX1 $PINS Q=key_reg[49] CLK=CTS_1 D=n_1223 RESETB=VDD
+ SETB=n_29 VSS=VSS VDD=VDD
Xkey_reg_reg[50] DFFQSRX1 $PINS Q=key_reg[50] CLK=CTS_1 D=n_1248 RESETB=VDD
+ SETB=n_29 VSS=VSS VDD=VDD
Xkey_reg_reg[51] DFFQSRX1 $PINS Q=key_reg[51] CLK=CTS_1 D=n_810 RESETB=VDD
+ SETB=n_29 VSS=VSS VDD=VDD
Xkey_reg_reg[52] DFFQSRX1 $PINS Q=key_reg[52] CLK=CTS_5 D=n_1189 RESETB=VDD
+ SETB=n_29 VSS=VSS VDD=VDD
Xkey_reg_reg[53] DFFQSRX1 $PINS Q=key_reg[53] CLK=CTS_23 D=n_922 RESETB=VDD
+ SETB=n_29 VSS=VSS VDD=VDD
Xkey_reg_reg[54] DFFQSRX1 $PINS Q=key_reg[54] CLK=CTS_7 D=n_809 RESETB=VDD
+ SETB=n_29 VSS=VSS VDD=VDD
Xkey_reg_reg[55] DFFQSRX1 $PINS Q=key_reg[55] CLK=CTS_7 D=n_808 RESETB=VDD
+ SETB=n_29 VSS=VSS VDD=VDD
Xkey_reg_reg[57] DFFQSRX1 $PINS Q=key_reg[57] CLK=CTS_25 D=n_806 RESETB=VDD
+ SETB=n_29 VSS=VSS VDD=VDD
Xkey_reg_reg[58] DFFQSRX1 $PINS Q=key_reg[58] CLK=CTS_6 D=n_805 RESETB=VDD
+ SETB=n_29 VSS=VSS VDD=VDD
Xkey_reg_reg[59] DFFQSRX1 $PINS Q=key_reg[59] CLK=CTS_6 D=n_804 RESETB=VDD
+ SETB=n_29 VSS=VSS VDD=VDD
Xkey_reg_reg[60] DFFQSRX1 $PINS Q=key_reg[60] CLK=CTS_6 D=n_803 RESETB=VDD
+ SETB=n_29 VSS=VSS VDD=VDD
Xkey_reg_reg[61] DFFQSRX1 $PINS Q=key_reg[61] CLK=CTS_11 D=n_876 RESETB=VDD
+ SETB=n_29 VSS=VSS VDD=VDD
Xkey_reg_reg[62] DFFQSRX1 $PINS Q=key_reg[62] CLK=CTS_25 D=n_802 RESETB=VDD
+ SETB=n_29 VSS=VSS VDD=VDD
Xkey_reg_reg[63] DFFQSRX1 $PINS Q=key_reg[63] CLK=CTS_25 D=n_882 RESETB=VDD
+ SETB=n_29 VSS=VSS VDD=VDD
Xspi_inst_bit_cnt_reg[0] DFFQSRX1 $PINS Q=spi_inst_bit_cnt[0] CLK=sclk D=n_232
+ RESETB=VDD SETB=n_29 VSS=VSS VDD=VDD
Xspi_inst_bit_cnt_reg[1] DFFQSRX1 $PINS Q=spi_inst_bit_cnt[1] CLK=sclk D=n_1737
+ RESETB=VDD SETB=n_29 VSS=VSS VDD=VDD
Xspi_inst_bit_cnt_reg[2] DFFQSRX1 $PINS Q=spi_inst_bit_cnt[2] CLK=sclk D=n_2766
+ RESETB=VDD SETB=n_29 VSS=VSS VDD=VDD
Xspi_inst_bit_cnt_reg[3] DFFQSRX1 $PINS Q=spi_inst_bit_cnt[3] CLK=sclk D=n_3094
+ RESETB=VDD SETB=n_29 VSS=VSS VDD=VDD
Xspi_inst_bit_cnt_reg[4] DFFQSRX1 $PINS Q=spi_inst_bit_cnt[4] CLK=sclk D=n_3551
+ RESETB=VDD SETB=n_29 VSS=VSS VDD=VDD
Xspi_inst_bit_cnt_reg[5] DFFQSRX1 $PINS Q=spi_inst_bit_cnt[5] CLK=sclk D=n_3620
+ RESETB=VDD SETB=n_29 VSS=VSS VDD=VDD
Xspi_inst_bit_cnt_reg[6] DFFQSRX1 $PINS Q=spi_inst_bit_cnt[6] CLK=sclk D=n_3694
+ RESETB=VDD SETB=n_29 VSS=VSS VDD=VDD
Xspi_inst_input_text_reg[0] DFFQSRX1 $PINS Q=spi_rx_data[0] CLK=sclk D=n_3785
+ RESETB=VDD SETB=n_29 VSS=VSS VDD=VDD
Xspi_inst_input_text_reg[1] DFFQSRX1 $PINS Q=spi_rx_data[1] CLK=sclk D=n_3784
+ RESETB=VDD SETB=n_29 VSS=VSS VDD=VDD
Xspi_inst_input_text_reg[2] DFFQSRX1 $PINS Q=spi_rx_data[2] CLK=sclk D=n_3783
+ RESETB=VDD SETB=n_29 VSS=VSS VDD=VDD
Xspi_inst_input_text_reg[3] DFFQSRX1 $PINS Q=spi_rx_data[3] CLK=sclk D=n_3782
+ RESETB=VDD SETB=n_29 VSS=VSS VDD=VDD
Xspi_inst_input_text_reg[4] DFFQSRX1 $PINS Q=spi_rx_data[4] CLK=sclk D=n_3780
+ RESETB=VDD SETB=n_29 VSS=VSS VDD=VDD
Xspi_inst_input_text_reg[5] DFFQSRX1 $PINS Q=spi_rx_data[5] CLK=sclk D=n_3777
+ RESETB=VDD SETB=n_29 VSS=VSS VDD=VDD
Xspi_inst_input_text_reg[6] DFFQSRX1 $PINS Q=spi_rx_data[6] CLK=sclk D=n_3712
+ RESETB=VDD SETB=n_29 VSS=VSS VDD=VDD
Xspi_inst_input_text_reg[7] DFFQSRX1 $PINS Q=spi_rx_data[7] CLK=sclk D=n_3776
+ RESETB=VDD SETB=n_29 VSS=VSS VDD=VDD
Xspi_inst_input_text_reg[8] DFFQSRX1 $PINS Q=spi_rx_data[8] CLK=sclk D=n_3775
+ RESETB=VDD SETB=n_29 VSS=VSS VDD=VDD
Xspi_inst_input_text_reg[9] DFFQSRX1 $PINS Q=spi_rx_data[9] CLK=sclk D=n_3773
+ RESETB=VDD SETB=n_29 VSS=VSS VDD=VDD
Xspi_inst_input_text_reg[10] DFFQSRX1 $PINS Q=spi_rx_data[10] CLK=sclk D=n_3714
+ RESETB=VDD SETB=n_29 VSS=VSS VDD=VDD
Xspi_inst_input_text_reg[11] DFFQSRX1 $PINS Q=spi_rx_data[11] CLK=sclk D=n_3805
+ RESETB=VDD SETB=n_29 VSS=VSS VDD=VDD
Xspi_inst_input_text_reg[12] DFFQSRX1 $PINS Q=spi_rx_data[12] CLK=sclk D=n_3740
+ RESETB=VDD SETB=n_29 VSS=VSS VDD=VDD
Xspi_inst_input_text_reg[13] DFFQSRX1 $PINS Q=spi_rx_data[13] CLK=sclk D=n_3771
+ RESETB=VDD SETB=n_29 VSS=VSS VDD=VDD
Xspi_inst_input_text_reg[14] DFFQSRX1 $PINS Q=spi_rx_data[14] CLK=sclk D=n_3770
+ RESETB=VDD SETB=n_29 VSS=VSS VDD=VDD
Xspi_inst_input_text_reg[15] DFFQSRX1 $PINS Q=spi_rx_data[15] CLK=sclk D=n_3769
+ RESETB=VDD SETB=n_29 VSS=VSS VDD=VDD
Xspi_inst_input_text_reg[16] DFFQSRX1 $PINS Q=spi_rx_data[16] CLK=sclk D=n_3711
+ RESETB=VDD SETB=n_29 VSS=VSS VDD=VDD
Xspi_inst_input_text_reg[17] DFFQSRX1 $PINS Q=spi_rx_data[17] CLK=sclk D=n_3768
+ RESETB=VDD SETB=n_29 VSS=VSS VDD=VDD
Xspi_inst_input_text_reg[18] DFFQSRX1 $PINS Q=spi_rx_data[18] CLK=sclk D=n_3767
+ RESETB=VDD SETB=n_29 VSS=VSS VDD=VDD
Xspi_inst_input_text_reg[19] DFFQSRX1 $PINS Q=spi_rx_data[19] CLK=sclk D=n_3766
+ RESETB=VDD SETB=n_29 VSS=VSS VDD=VDD
Xspi_inst_input_text_reg[20] DFFQSRX1 $PINS Q=spi_rx_data[20] CLK=sclk D=n_3765
+ RESETB=VDD SETB=n_29 VSS=VSS VDD=VDD
Xspi_inst_input_text_reg[21] DFFQSRX1 $PINS Q=spi_rx_data[21] CLK=sclk D=n_3764
+ RESETB=VDD SETB=n_29 VSS=VSS VDD=VDD
Xspi_inst_input_text_reg[22] DFFQSRX1 $PINS Q=spi_rx_data[22] CLK=sclk D=n_3763
+ RESETB=VDD SETB=n_29 VSS=VSS VDD=VDD
Xspi_inst_input_text_reg[23] DFFQSRX1 $PINS Q=spi_rx_data[23] CLK=sclk D=n_3762
+ RESETB=VDD SETB=n_29 VSS=VSS VDD=VDD
Xspi_inst_input_text_reg[24] DFFQSRX1 $PINS Q=spi_rx_data[24] CLK=sclk D=n_3761
+ RESETB=VDD SETB=n_29 VSS=VSS VDD=VDD
Xspi_inst_input_text_reg[25] DFFQSRX1 $PINS Q=spi_rx_data[25] CLK=sclk D=n_3758
+ RESETB=VDD SETB=n_29 VSS=VSS VDD=VDD
Xspi_inst_input_text_reg[26] DFFQSRX1 $PINS Q=spi_rx_data[26] CLK=sclk D=n_3757
+ RESETB=VDD SETB=n_29 VSS=VSS VDD=VDD
Xspi_inst_input_text_reg[27] DFFQSRX1 $PINS Q=spi_rx_data[27] CLK=sclk D=n_3756
+ RESETB=VDD SETB=n_29 VSS=VSS VDD=VDD
Xspi_inst_input_text_reg[28] DFFQSRX1 $PINS Q=spi_rx_data[28] CLK=sclk D=n_3754
+ RESETB=VDD SETB=n_29 VSS=VSS VDD=VDD
Xspi_inst_input_text_reg[29] DFFQSRX1 $PINS Q=spi_rx_data[29] CLK=sclk D=n_3753
+ RESETB=VDD SETB=n_29 VSS=VSS VDD=VDD
Xspi_inst_input_text_reg[30] DFFQSRX1 $PINS Q=spi_rx_data[30] CLK=sclk D=n_3752
+ RESETB=VDD SETB=n_29 VSS=VSS VDD=VDD
Xspi_inst_input_text_reg[31] DFFQSRX1 $PINS Q=spi_rx_data[31] CLK=sclk D=n_3751
+ RESETB=VDD SETB=n_29 VSS=VSS VDD=VDD
Xspi_inst_input_text_reg[32] DFFQSRX1 $PINS Q=spi_rx_data[32] CLK=sclk D=n_3750
+ RESETB=VDD SETB=n_29 VSS=VSS VDD=VDD
Xspi_inst_input_text_reg[33] DFFQSRX1 $PINS Q=spi_rx_data[33] CLK=sclk D=n_3748
+ RESETB=VDD SETB=n_29 VSS=VSS VDD=VDD
Xspi_inst_input_text_reg[34] DFFQSRX1 $PINS Q=spi_rx_data[34] CLK=sclk D=n_3747
+ RESETB=VDD SETB=n_29 VSS=VSS VDD=VDD
Xspi_inst_input_text_reg[35] DFFQSRX1 $PINS Q=spi_rx_data[35] CLK=sclk D=n_3745
+ RESETB=VDD SETB=n_29 VSS=VSS VDD=VDD
Xspi_inst_input_text_reg[36] DFFQSRX1 $PINS Q=spi_rx_data[36] CLK=sclk D=n_3744
+ RESETB=VDD SETB=n_29 VSS=VSS VDD=VDD
Xspi_inst_input_text_reg[37] DFFQSRX1 $PINS Q=spi_rx_data[37] CLK=sclk D=n_3743
+ RESETB=VDD SETB=n_29 VSS=VSS VDD=VDD
Xspi_inst_input_text_reg[38] DFFQSRX1 $PINS Q=spi_rx_data[38] CLK=sclk D=n_3742
+ RESETB=VDD SETB=n_29 VSS=VSS VDD=VDD
Xspi_inst_input_text_reg[39] DFFQSRX1 $PINS Q=spi_rx_data[39] CLK=sclk D=n_3741
+ RESETB=VDD SETB=n_29 VSS=VSS VDD=VDD
Xspi_inst_input_text_reg[40] DFFQSRX1 $PINS Q=spi_rx_data[40] CLK=sclk D=n_3772
+ RESETB=VDD SETB=n_29 VSS=VSS VDD=VDD
Xspi_inst_input_text_reg[41] DFFQSRX1 $PINS Q=spi_rx_data[41] CLK=sclk D=n_3739
+ RESETB=VDD SETB=n_29 VSS=VSS VDD=VDD
Xspi_inst_input_text_reg[42] DFFQSRX1 $PINS Q=spi_rx_data[42] CLK=sclk D=n_3738
+ RESETB=VDD SETB=n_29 VSS=VSS VDD=VDD
Xspi_inst_input_text_reg[43] DFFQSRX1 $PINS Q=spi_rx_data[43] CLK=sclk D=n_3737
+ RESETB=VDD SETB=n_29 VSS=VSS VDD=VDD
Xspi_inst_input_text_reg[44] DFFQSRX1 $PINS Q=spi_rx_data[44] CLK=sclk D=n_3736
+ RESETB=VDD SETB=n_29 VSS=VSS VDD=VDD
Xspi_inst_input_text_reg[45] DFFQSRX1 $PINS Q=spi_rx_data[45] CLK=sclk D=n_3735
+ RESETB=VDD SETB=n_29 VSS=VSS VDD=VDD
Xspi_inst_input_text_reg[46] DFFQSRX1 $PINS Q=spi_rx_data[46] CLK=sclk D=n_3734
+ RESETB=VDD SETB=n_29 VSS=VSS VDD=VDD
Xspi_inst_input_text_reg[47] DFFQSRX1 $PINS Q=spi_rx_data[47] CLK=sclk D=n_3733
+ RESETB=VDD SETB=n_29 VSS=VSS VDD=VDD
Xspi_inst_input_text_reg[48] DFFQSRX1 $PINS Q=spi_rx_data[48] CLK=sclk D=n_3730
+ RESETB=VDD SETB=n_29 VSS=VSS VDD=VDD
Xspi_inst_input_text_reg[49] DFFQSRX1 $PINS Q=spi_rx_data[49] CLK=sclk D=n_3728
+ RESETB=VDD SETB=n_29 VSS=VSS VDD=VDD
Xspi_inst_input_text_reg[50] DFFQSRX1 $PINS Q=spi_rx_data[50] CLK=sclk D=n_3727
+ RESETB=VDD SETB=n_29 VSS=VSS VDD=VDD
Xspi_inst_input_text_reg[51] DFFQSRX1 $PINS Q=spi_rx_data[51] CLK=sclk D=n_3726
+ RESETB=VDD SETB=n_29 VSS=VSS VDD=VDD
Xspi_inst_input_text_reg[52] DFFQSRX1 $PINS Q=spi_rx_data[52] CLK=sclk D=n_3725
+ RESETB=VDD SETB=n_29 VSS=VSS VDD=VDD
Xspi_inst_input_text_reg[53] DFFQSRX1 $PINS Q=spi_rx_data[53] CLK=sclk D=n_3724
+ RESETB=VDD SETB=n_29 VSS=VSS VDD=VDD
Xspi_inst_input_text_reg[54] DFFQSRX1 $PINS Q=spi_rx_data[54] CLK=sclk D=n_3723
+ RESETB=VDD SETB=n_29 VSS=VSS VDD=VDD
Xspi_inst_input_text_reg[55] DFFQSRX1 $PINS Q=spi_rx_data[55] CLK=sclk D=n_3722
+ RESETB=VDD SETB=n_29 VSS=VSS VDD=VDD
Xspi_inst_input_text_reg[56] DFFQSRX1 $PINS Q=spi_rx_data[56] CLK=sclk D=n_3721
+ RESETB=VDD SETB=n_29 VSS=VSS VDD=VDD
Xspi_inst_input_text_reg[57] DFFQSRX1 $PINS Q=spi_rx_data[57] CLK=sclk D=n_3720
+ RESETB=VDD SETB=n_29 VSS=VSS VDD=VDD
Xspi_inst_input_text_reg[58] DFFQSRX1 $PINS Q=spi_rx_data[58] CLK=sclk D=n_3713
+ RESETB=VDD SETB=n_29 VSS=VSS VDD=VDD
Xspi_inst_input_text_reg[59] DFFQSRX1 $PINS Q=spi_rx_data[59] CLK=sclk D=n_3719
+ RESETB=VDD SETB=n_29 VSS=VSS VDD=VDD
Xspi_inst_input_text_reg[60] DFFQSRX1 $PINS Q=spi_rx_data[60] CLK=sclk D=n_3718
+ RESETB=VDD SETB=n_29 VSS=VSS VDD=VDD
Xspi_inst_input_text_reg[61] DFFQSRX1 $PINS Q=spi_rx_data[61] CLK=sclk D=n_3717
+ RESETB=VDD SETB=n_29 VSS=VSS VDD=VDD
Xspi_inst_input_text_reg[62] DFFQSRX1 $PINS Q=spi_rx_data[62] CLK=sclk D=n_3716
+ RESETB=VDD SETB=n_29 VSS=VSS VDD=VDD
Xspi_inst_input_text_reg[63] DFFQSRX1 $PINS Q=spi_rx_data[63] CLK=sclk D=n_3715
+ RESETB=VDD SETB=n_29 VSS=VSS VDD=VDD
Xspi_inst_shreg_in_reg[0] DFFQSRX1 $PINS Q=spi_inst_shreg_in[0] CLK=sclk
+ D=n_366 RESETB=VDD SETB=n_29 VSS=VSS VDD=VDD
Xspi_inst_shreg_in_reg[1] DFFQSRX1 $PINS Q=spi_inst_shreg_in[1] CLK=sclk
+ D=n_391 RESETB=VDD SETB=n_29 VSS=VSS VDD=VDD
Xspi_inst_shreg_in_reg[2] DFFQSRX1 $PINS Q=spi_inst_shreg_in[2] CLK=sclk
+ D=n_388 RESETB=VDD SETB=n_29 VSS=VSS VDD=VDD
Xspi_inst_shreg_in_reg[3] DFFQSRX1 $PINS Q=spi_inst_shreg_in[3] CLK=sclk
+ D=n_331 RESETB=VDD SETB=n_29 VSS=VSS VDD=VDD
Xspi_inst_shreg_in_reg[4] DFFQSRX1 $PINS Q=spi_inst_shreg_in[4] CLK=sclk
+ D=n_349 RESETB=VDD SETB=n_29 VSS=VSS VDD=VDD
Xspi_inst_shreg_in_reg[5] DFFQSRX1 $PINS Q=spi_inst_shreg_in[5] CLK=sclk
+ D=n_334 RESETB=VDD SETB=n_29 VSS=VSS VDD=VDD
Xspi_inst_shreg_in_reg[6] DFFQSRX1 $PINS Q=spi_inst_shreg_in[6] CLK=sclk
+ D=n_367 RESETB=VDD SETB=n_29 VSS=VSS VDD=VDD
Xspi_inst_shreg_in_reg[7] DFFQSRX1 $PINS Q=spi_inst_shreg_in[7] CLK=sclk
+ D=n_404 RESETB=VDD SETB=n_29 VSS=VSS VDD=VDD
Xspi_inst_shreg_in_reg[8] DFFQSRX1 $PINS Q=spi_inst_shreg_in[8] CLK=sclk
+ D=n_317 RESETB=VDD SETB=n_29 VSS=VSS VDD=VDD
Xspi_inst_shreg_in_reg[9] DFFQSRX1 $PINS Q=spi_inst_shreg_in[9] CLK=sclk
+ D=n_345 RESETB=VDD SETB=n_29 VSS=VSS VDD=VDD
Xspi_inst_shreg_in_reg[10] DFFQSRX1 $PINS Q=spi_inst_shreg_in[10] CLK=sclk
+ D=n_332 RESETB=VDD SETB=n_29 VSS=VSS VDD=VDD
Xspi_inst_shreg_in_reg[11] DFFQSRX1 $PINS Q=spi_inst_shreg_in[11] CLK=sclk
+ D=n_329 RESETB=VDD SETB=n_29 VSS=VSS VDD=VDD
Xspi_inst_shreg_in_reg[12] DFFQSRX1 $PINS Q=spi_inst_shreg_in[12] CLK=sclk
+ D=n_319 RESETB=VDD SETB=n_29 VSS=VSS VDD=VDD
Xspi_inst_shreg_in_reg[13] DFFQSRX1 $PINS Q=spi_inst_shreg_in[13] CLK=sclk
+ D=n_399 RESETB=VDD SETB=n_29 VSS=VSS VDD=VDD
Xspi_inst_shreg_in_reg[14] DFFQSRX1 $PINS Q=spi_inst_shreg_in[14] CLK=sclk
+ D=n_374 RESETB=VDD SETB=n_29 VSS=VSS VDD=VDD
Xspi_inst_shreg_in_reg[15] DFFQSRX1 $PINS Q=spi_inst_shreg_in[15] CLK=sclk
+ D=n_397 RESETB=VDD SETB=n_29 VSS=VSS VDD=VDD
Xspi_inst_shreg_in_reg[16] DFFQSRX1 $PINS Q=spi_inst_shreg_in[16] CLK=sclk
+ D=n_363 RESETB=VDD SETB=n_29 VSS=VSS VDD=VDD
Xspi_inst_shreg_in_reg[17] DFFQSRX1 $PINS Q=spi_inst_shreg_in[17] CLK=sclk
+ D=n_403 RESETB=VDD SETB=n_29 VSS=VSS VDD=VDD
Xspi_inst_shreg_in_reg[18] DFFQSRX1 $PINS Q=spi_inst_shreg_in[18] CLK=sclk
+ D=n_350 RESETB=VDD SETB=n_29 VSS=VSS VDD=VDD
Xspi_inst_shreg_in_reg[19] DFFQSRX1 $PINS Q=spi_inst_shreg_in[19] CLK=sclk
+ D=n_396 RESETB=VDD SETB=n_29 VSS=VSS VDD=VDD
Xspi_inst_shreg_in_reg[20] DFFQSRX1 $PINS Q=spi_inst_shreg_in[20] CLK=sclk
+ D=n_384 RESETB=VDD SETB=n_29 VSS=VSS VDD=VDD
Xspi_inst_shreg_in_reg[21] DFFQSRX1 $PINS Q=spi_inst_shreg_in[21] CLK=sclk
+ D=n_340 RESETB=VDD SETB=n_29 VSS=VSS VDD=VDD
Xspi_inst_shreg_in_reg[22] DFFQSRX1 $PINS Q=spi_inst_shreg_in[22] CLK=sclk
+ D=n_394 RESETB=VDD SETB=n_29 VSS=VSS VDD=VDD
Xspi_inst_shreg_in_reg[23] DFFQSRX1 $PINS Q=spi_inst_shreg_in[23] CLK=sclk
+ D=n_383 RESETB=VDD SETB=n_29 VSS=VSS VDD=VDD
Xspi_inst_shreg_in_reg[24] DFFQSRX1 $PINS Q=spi_inst_shreg_in[24] CLK=sclk
+ D=n_320 RESETB=VDD SETB=n_29 VSS=VSS VDD=VDD
Xspi_inst_shreg_in_reg[25] DFFQSRX1 $PINS Q=spi_inst_shreg_in[25] CLK=sclk
+ D=n_336 RESETB=VDD SETB=n_29 VSS=VSS VDD=VDD
Xspi_inst_shreg_in_reg[26] DFFQSRX1 $PINS Q=spi_inst_shreg_in[26] CLK=sclk
+ D=n_408 RESETB=VDD SETB=n_29 VSS=VSS VDD=VDD
Xspi_inst_shreg_in_reg[27] DFFQSRX1 $PINS Q=spi_inst_shreg_in[27] CLK=sclk
+ D=n_381 RESETB=VDD SETB=n_29 VSS=VSS VDD=VDD
Xspi_inst_shreg_in_reg[28] DFFQSRX1 $PINS Q=spi_inst_shreg_in[28] CLK=sclk
+ D=n_389 RESETB=VDD SETB=n_29 VSS=VSS VDD=VDD
Xspi_inst_shreg_in_reg[29] DFFQSRX1 $PINS Q=spi_inst_shreg_in[29] CLK=sclk
+ D=n_392 RESETB=VDD SETB=n_29 VSS=VSS VDD=VDD
Xspi_inst_shreg_in_reg[30] DFFQSRX1 $PINS Q=spi_inst_shreg_in[30] CLK=sclk
+ D=n_371 RESETB=VDD SETB=n_29 VSS=VSS VDD=VDD
Xspi_inst_shreg_in_reg[31] DFFQSRX1 $PINS Q=spi_inst_shreg_in[31] CLK=sclk
+ D=n_360 RESETB=VDD SETB=n_29 VSS=VSS VDD=VDD
Xspi_inst_shreg_in_reg[32] DFFQSRX1 $PINS Q=spi_inst_shreg_in[32] CLK=sclk
+ D=n_327 RESETB=VDD SETB=n_29 VSS=VSS VDD=VDD
Xspi_inst_shreg_in_reg[33] DFFQSRX1 $PINS Q=spi_inst_shreg_in[33] CLK=sclk
+ D=n_375 RESETB=VDD SETB=n_29 VSS=VSS VDD=VDD
Xspi_inst_shreg_in_reg[34] DFFQSRX1 $PINS Q=spi_inst_shreg_in[34] CLK=sclk
+ D=n_401 RESETB=VDD SETB=n_29 VSS=VSS VDD=VDD
Xspi_inst_shreg_in_reg[35] DFFQSRX1 $PINS Q=spi_inst_shreg_in[35] CLK=sclk
+ D=n_362 RESETB=VDD SETB=n_29 VSS=VSS VDD=VDD
Xspi_inst_shreg_in_reg[36] DFFQSRX1 $PINS Q=spi_inst_shreg_in[36] CLK=sclk
+ D=n_343 RESETB=VDD SETB=n_29 VSS=VSS VDD=VDD
Xspi_inst_shreg_in_reg[37] DFFQSRX1 $PINS Q=spi_inst_shreg_in[37] CLK=sclk
+ D=n_361 RESETB=VDD SETB=n_29 VSS=VSS VDD=VDD
Xspi_inst_shreg_in_reg[38] DFFQSRX1 $PINS Q=spi_inst_shreg_in[38] CLK=sclk
+ D=n_355 RESETB=VDD SETB=n_29 VSS=VSS VDD=VDD
Xspi_inst_shreg_in_reg[39] DFFQSRX1 $PINS Q=spi_inst_shreg_in[39] CLK=sclk
+ D=n_338 RESETB=VDD SETB=n_29 VSS=VSS VDD=VDD
Xspi_inst_shreg_in_reg[40] DFFQSRX1 $PINS Q=spi_inst_shreg_in[40] CLK=sclk
+ D=n_406 RESETB=VDD SETB=n_29 VSS=VSS VDD=VDD
Xspi_inst_shreg_in_reg[41] DFFQSRX1 $PINS Q=spi_inst_shreg_in[41] CLK=sclk
+ D=n_330 RESETB=VDD SETB=n_29 VSS=VSS VDD=VDD
Xspi_inst_shreg_in_reg[42] DFFQSRX1 $PINS Q=spi_inst_shreg_in[42] CLK=sclk
+ D=n_378 RESETB=VDD SETB=n_29 VSS=VSS VDD=VDD
Xspi_inst_shreg_in_reg[43] DFFQSRX1 $PINS Q=spi_inst_shreg_in[43] CLK=sclk
+ D=n_372 RESETB=VDD SETB=n_29 VSS=VSS VDD=VDD
Xspi_inst_shreg_in_reg[44] DFFQSRX1 $PINS Q=spi_inst_shreg_in[44] CLK=sclk
+ D=n_341 RESETB=VDD SETB=n_29 VSS=VSS VDD=VDD
Xspi_inst_shreg_in_reg[45] DFFQSRX1 $PINS Q=spi_inst_shreg_in[45] CLK=sclk
+ D=n_326 RESETB=VDD SETB=n_29 VSS=VSS VDD=VDD
Xspi_inst_shreg_in_reg[46] DFFQSRX1 $PINS Q=spi_inst_shreg_in[46] CLK=sclk
+ D=n_324 RESETB=VDD SETB=n_29 VSS=VSS VDD=VDD
Xspi_inst_shreg_in_reg[47] DFFQSRX1 $PINS Q=spi_inst_shreg_in[47] CLK=sclk
+ D=n_328 RESETB=VDD SETB=n_29 VSS=VSS VDD=VDD
Xspi_inst_shreg_in_reg[48] DFFQSRX1 $PINS Q=spi_inst_shreg_in[48] CLK=sclk
+ D=n_379 RESETB=VDD SETB=n_29 VSS=VSS VDD=VDD
Xspi_inst_shreg_in_reg[49] DFFQSRX1 $PINS Q=spi_inst_shreg_in[49] CLK=sclk
+ D=n_365 RESETB=VDD SETB=n_29 VSS=VSS VDD=VDD
Xspi_inst_shreg_in_reg[50] DFFQSRX1 $PINS Q=spi_inst_shreg_in[50] CLK=sclk
+ D=n_323 RESETB=VDD SETB=n_29 VSS=VSS VDD=VDD
Xspi_inst_shreg_in_reg[51] DFFQSRX1 $PINS Q=spi_inst_shreg_in[51] CLK=sclk
+ D=n_386 RESETB=VDD SETB=n_29 VSS=VSS VDD=VDD
Xspi_inst_shreg_in_reg[52] DFFQSRX1 $PINS Q=spi_inst_shreg_in[52] CLK=sclk
+ D=n_370 RESETB=VDD SETB=n_29 VSS=VSS VDD=VDD
Xspi_inst_shreg_in_reg[53] DFFQSRX1 $PINS Q=spi_inst_shreg_in[53] CLK=sclk
+ D=n_333 RESETB=VDD SETB=n_29 VSS=VSS VDD=VDD
Xspi_inst_shreg_in_reg[54] DFFQSRX1 $PINS Q=spi_inst_shreg_in[54] CLK=sclk
+ D=n_337 RESETB=VDD SETB=n_29 VSS=VSS VDD=VDD
Xspi_inst_shreg_in_reg[55] DFFQSRX1 $PINS Q=spi_inst_shreg_in[55] CLK=sclk
+ D=n_347 RESETB=VDD SETB=n_29 VSS=VSS VDD=VDD
Xspi_inst_shreg_in_reg[56] DFFQSRX1 $PINS Q=spi_inst_shreg_in[56] CLK=sclk
+ D=n_385 RESETB=VDD SETB=n_29 VSS=VSS VDD=VDD
Xspi_inst_shreg_in_reg[57] DFFQSRX1 $PINS Q=spi_inst_shreg_in[57] CLK=sclk
+ D=n_357 RESETB=VDD SETB=n_29 VSS=VSS VDD=VDD
Xspi_inst_shreg_in_reg[58] DFFQSRX1 $PINS Q=spi_inst_shreg_in[58] CLK=sclk
+ D=n_356 RESETB=VDD SETB=n_29 VSS=VSS VDD=VDD
Xspi_inst_shreg_in_reg[59] DFFQSRX1 $PINS Q=spi_inst_shreg_in[59] CLK=sclk
+ D=n_398 RESETB=VDD SETB=n_29 VSS=VSS VDD=VDD
Xspi_inst_shreg_in_reg[60] DFFQSRX1 $PINS Q=spi_inst_shreg_in[60] CLK=sclk
+ D=n_348 RESETB=VDD SETB=n_29 VSS=VSS VDD=VDD
Xspi_inst_shreg_in_reg[61] DFFQSRX1 $PINS Q=spi_inst_shreg_in[61] CLK=sclk
+ D=n_321 RESETB=VDD SETB=n_29 VSS=VSS VDD=VDD
Xspi_inst_shreg_in_reg[62] DFFQSRX1 $PINS Q=spi_inst_shreg_in[62] CLK=sclk
+ D=n_351 RESETB=VDD SETB=n_29 VSS=VSS VDD=VDD
Xstart_decrypt_reg DFFQSRX1 $PINS Q=start_decrypt CLK=CTS_28 D=n_878 RESETB=VDD
+ SETB=n_29 VSS=VSS VDD=VDD
Xstart_encrypt_reg DFFQSRX1 $PINS Q=start_encrypt CLK=CTS_28 D=n_877 RESETB=VDD
+ SETB=n_29 VSS=VSS VDD=VDD
Xtransaction_state_reg[0] DFFQSRX1 $PINS Q=transaction_state[0] CLK=CTS_4
+ D=n_2192 RESETB=VDD SETB=n_29 VSS=VSS VDD=VDD
Xtransaction_state_reg[1] DFFQSRX1 $PINS Q=transaction_state[1] CLK=CTS_4
+ D=n_2102 RESETB=VDD SETB=n_29 VSS=VSS VDD=VDD
Xg121462 NAND2X1 $PINS Z=n_5877 A=n_5875 B=n_3061 VSS=VSS VDD=VDD
Xg121463 MUX2X1 $PINS Z=n_5876 A=n_5853 B=n_3185 S=n_410 VSS=VSS VDD=VDD
Xg121466 NAND2X1 $PINS Z=n_5875 A=n_5850 B=n_20 VSS=VSS VDD=VDD
Xg121467 NAND2X1 $PINS Z=n_5874 A=n_5861 B=n_3270 VSS=VSS VDD=VDD
Xg121471 NAND3X1 $PINS Z=n_5873 A=n_5849 B=n_2681 C=n_1763 VSS=VSS VDD=VDD
Xg121472 NAND2X1 $PINS Z=n_5872 A=n_5858 B=n_3181 VSS=VSS VDD=VDD
Xg121473 NAND2X1 $PINS Z=n_5871 A=n_5856 B=n_3313 VSS=VSS VDD=VDD
Xg121474 NAND3X1 $PINS Z=n_5870 A=n_5846 B=n_2635 C=n_1769 VSS=VSS VDD=VDD
Xg121475 NAND3X1 $PINS Z=n_5869 A=n_5848 B=n_2571 C=n_1742 VSS=VSS VDD=VDD
Xg121483 NAND2X1 $PINS Z=n_5868 A=n_5842 B=n_3177 VSS=VSS VDD=VDD
Xg121484 NAND2X1 $PINS Z=n_5861 A=n_5835 B=n_20 VSS=VSS VDD=VDD
Xg121485 NAND2X1 $PINS Z=n_5858 A=n_5834 B=n_20 VSS=VSS VDD=VDD
Xg121486 NAND2X1 $PINS Z=n_5857 A=n_5845 B=n_3068 VSS=VSS VDD=VDD
Xg121487 NAND2X1 $PINS Z=n_5856 A=n_5836 B=n_20 VSS=VSS VDD=VDD
Xg121488 NAND3X1 $PINS Z=n_5855 A=n_5833 B=n_2603 C=n_1752 VSS=VSS VDD=VDD
Xg121489 XOR2X1 $PINS Z=n_5853 A=csm_inst_left_reg[10] B=n_5816 VSS=VSS VDD=VDD
Xg121490 XOR2X1 $PINS Z=n_5850 A=csm_inst_left_reg[3] B=n_5815 VSS=VSS VDD=VDD
Xg121491 NAND2X1 $PINS Z=n_5849 A=n_5817 B=n_20 VSS=VSS VDD=VDD
Xg121492 NAND2X1 $PINS Z=n_5848 A=n_5824 B=n_20 VSS=VSS VDD=VDD
Xg121493 NAND2X1 $PINS Z=n_5847 A=n_5831 B=n_3249 VSS=VSS VDD=VDD
Xg121494 NAND2X1 $PINS Z=n_5846 A=n_5818 B=n_20 VSS=VSS VDD=VDD
Xg121495 NAND2X1 $PINS Z=n_5845 A=n_5823 B=n_20 VSS=VSS VDD=VDD
Xg121501 NAND2X1 $PINS Z=n_5843 A=n_5832 B=n_3190 VSS=VSS VDD=VDD
Xg121502 NAND2X1 $PINS Z=n_5842 A=n_5819 B=n_20 VSS=VSS VDD=VDD
Xg121503 NAND2X1 $PINS Z=n_5841 A=n_5830 B=n_3051 VSS=VSS VDD=VDD
Xg121504 NAND2X1 $PINS Z=n_5840 A=n_5825 B=n_3189 VSS=VSS VDD=VDD
Xg121505 NAND2X1 $PINS Z=n_5839 A=n_5822 B=n_3433 VSS=VSS VDD=VDD
Xg121506 NAND3X1 $PINS Z=n_5838 A=n_5813 B=n_2703 C=n_1805 VSS=VSS VDD=VDD
Xg121507 MUX2X1 $PINS Z=n_5837 A=n_5794 B=n_3044 S=n_410 VSS=VSS VDD=VDD
Xg121508 XOR2X1 $PINS Z=n_5836 A=csm_inst_left_reg[31] B=n_5797 VSS=VSS VDD=VDD
Xg121509 XOR2X1 $PINS Z=n_5835 A=csm_inst_left_reg[5] B=n_5777 VSS=VSS VDD=VDD
Xg121510 XOR2X1 $PINS Z=n_5834 A=csm_inst_left_reg[11] B=n_5795 VSS=VSS VDD=VDD
Xg121511 NAND2X1 $PINS Z=n_5833 A=n_5782 B=n_20 VSS=VSS VDD=VDD
Xg121512 NAND2X1 $PINS Z=n_5832 A=n_5784 B=n_20 VSS=VSS VDD=VDD
Xg121513 NAND2X1 $PINS Z=n_5831 A=n_5783 B=n_20 VSS=VSS VDD=VDD
Xg121514 NAND2X1 $PINS Z=n_5830 A=n_5781 B=n_20 VSS=VSS VDD=VDD
Xg121515 NAND2X1 $PINS Z=n_5829 A=n_5809 B=n_3182 VSS=VSS VDD=VDD
Xg121524 NAND2X1 $PINS Z=n_5827 A=n_5806 B=n_3103 VSS=VSS VDD=VDD
Xg121525 NAND2X1 $PINS Z=n_5826 A=n_5805 B=n_3096 VSS=VSS VDD=VDD
Xg121526 NAND2X1 $PINS Z=n_5825 A=n_5785 B=n_20 VSS=VSS VDD=VDD
Xg121527 XOR2X1 $PINS Z=n_5824 A=csm_inst_left_reg[22] B=n_5766 VSS=VSS VDD=VDD
Xg121528 XOR2X1 $PINS Z=n_5823 A=csm_inst_left_reg[20] B=n_5756 VSS=VSS VDD=VDD
Xg121529 NAND2X1 $PINS Z=n_5822 A=n_5787 B=n_20 VSS=VSS VDD=VDD
Xg121530 NAND2X1 $PINS Z=n_5821 A=n_5786 B=n_3046 VSS=VSS VDD=VDD
Xg121531 NAND3X1 $PINS Z=n_5820 A=n_5774 B=n_2613 C=n_1759 VSS=VSS VDD=VDD
Xg121532 XOR2X1 $PINS Z=n_5819 A=csm_inst_left_reg[12] B=n_5767 VSS=VSS VDD=VDD
Xg121533 XOR2X1 $PINS Z=n_5818 A=csm_inst_left_reg[9] B=n_5769 VSS=VSS VDD=VDD
Xg121534 XOR2X1 $PINS Z=n_5817 A=csm_inst_left_reg[0] B=n_5754 VSS=VSS VDD=VDD
Xg121535 NAND2X1 $PINS Z=n_5816 A=n_5790 B=n_4733 VSS=VSS VDD=VDD
Xg121536 NAND3X1 $PINS Z=n_5815 A=n_5764 B=n_5137 C=n_5432 VSS=VSS VDD=VDD
Xg121537 OR2X1 $PINS Z=n_5813 A=n_410 B=n_5759 VSS=VSS VDD=VDD
Xg121538 NAND2X1 $PINS Z=n_5812 A=n_5771 B=n_3296 VSS=VSS VDD=VDD
Xg121539 NAND2X1 $PINS Z=n_5809 A=n_5762 B=n_20 VSS=VSS VDD=VDD
Xg121540 NAND2X1 $PINS Z=n_5806 A=n_5757 B=n_20 VSS=VSS VDD=VDD
Xg121541 NAND2X1 $PINS Z=n_5805 A=n_5761 B=n_20 VSS=VSS VDD=VDD
Xg121542 NAND2X1 $PINS Z=n_5804 A=n_5770 B=n_3439 VSS=VSS VDD=VDD
Xg121543 NAND2X1 $PINS Z=n_5803 A=n_5773 B=n_3040 VSS=VSS VDD=VDD
Xg121544 NAND2X1 $PINS Z=n_5802 A=n_5775 B=n_3143 VSS=VSS VDD=VDD
Xg121545 OR2X1 $PINS Z=n_5798 A=n_3078 B=n_5776 VSS=VSS VDD=VDD
Xg121546 NAND3X1 $PINS Z=n_5797 A=n_5737 B=n_5396 C=n_5294 VSS=VSS VDD=VDD
Xg121547 NAND3X1 $PINS Z=n_5795 A=n_5750 B=n_5586 C=n_5015 VSS=VSS VDD=VDD
Xg121549 XOR2X1 $PINS Z=n_5794 A=csm_inst_left_reg[25] B=n_5740 VSS=VSS VDD=VDD
Xg121550 NAND2X1 $PINS Z=n_5791 A=n_5763 B=n_3219 VSS=VSS VDD=VDD
Xg121551 NOR2X1 $PINS Z=n_5790 A=n_4659 B=n_5765 VSS=VSS VDD=VDD
Xg121552 NAND3X1 $PINS Z=n_5789 A=n_5748 B=n_5705 C=n_5725 VSS=VSS VDD=VDD
Xg121553 NAND3X1 $PINS Z=n_5788 A=n_5747 B=n_5707 C=n_5720 VSS=VSS VDD=VDD
Xg121554 XOR2X1 $PINS Z=n_5787 A=csm_inst_left_reg[27] B=n_5743 VSS=VSS VDD=VDD
Xg121555 NAND2X1 $PINS Z=n_5786 A=n_5758 B=n_20 VSS=VSS VDD=VDD
Xg121556 XOR2X1 $PINS Z=n_5785 A=csm_inst_left_reg[2] B=n_6068 VSS=VSS VDD=VDD
Xg121557 XOR2X1 $PINS Z=n_5784 A=csm_inst_left_reg[8] B=n_5742 VSS=VSS VDD=VDD
Xg121558 XOR2X1 $PINS Z=n_5783 A=csm_inst_left_reg[6] B=n_5741 VSS=VSS VDD=VDD
Xg121559 XOR2X1 $PINS Z=n_5782 A=csm_inst_left_reg[16] B=n_5726 VSS=VSS VDD=VDD
Xg121560 XOR2X1 $PINS Z=n_5781 A=csm_inst_left_reg[23] B=n_5728 VSS=VSS VDD=VDD
Xg121561 NAND3X1 $PINS Z=n_5777 A=n_5751 B=n_5566 C=n_4960 VSS=VSS VDD=VDD
Xg121562 NOR2X1 $PINS Z=n_5776 A=n_410 B=n_5734 VSS=VSS VDD=VDD
Xg121563 NAND2X1 $PINS Z=n_5775 A=n_5731 B=n_20 VSS=VSS VDD=VDD
Xg121564 NAND2X1 $PINS Z=n_5774 A=n_5736 B=n_20 VSS=VSS VDD=VDD
Xg121565 NAND2X1 $PINS Z=n_5773 A=n_5735 B=n_20 VSS=VSS VDD=VDD
Xg121566 OR2X1 $PINS Z=n_5772 A=n_3437 B=n_5753 VSS=VSS VDD=VDD
Xg121567 NAND2X1 $PINS Z=n_5771 A=n_5732 B=n_20 VSS=VSS VDD=VDD
Xg121568 NAND2X1 $PINS Z=n_5770 A=n_5729 B=n_20 VSS=VSS VDD=VDD
Xg121569 NAND3X1 $PINS Z=n_5769 A=n_5717 B=n_5027 C=n_4787 VSS=VSS VDD=VDD
Xg121570 NAND2X1 $PINS Z=n_5767 A=n_5749 B=n_4962 VSS=VSS VDD=VDD
Xg121571 NAND3X1 $PINS Z=n_5766 A=n_5711 B=n_5136 C=n_4696 VSS=VSS VDD=VDD
Xg121572 NAND3X1 $PINS Z=n_5765 A=n_5710 B=n_5433 C=n_5389 VSS=VSS VDD=VDD
Xg121573 NOR2X1 $PINS Z=n_5764 A=n_5369 B=n_5733 VSS=VSS VDD=VDD
Xg121574 NAND2X1 $PINS Z=n_5763 A=n_5739 B=n_20 VSS=VSS VDD=VDD
Xg121575 XOR2X1 $PINS Z=n_5762 A=csm_inst_left_reg[30] B=n_5716 VSS=VSS VDD=VDD
Xg121576 XOR2X1 $PINS Z=n_5761 A=csm_inst_left_reg[17] B=n_5698 VSS=VSS VDD=VDD
Xg121577 XOR2X1 $PINS Z=n_5759 A=csm_inst_left_reg[1] B=n_5714 VSS=VSS VDD=VDD
Xg121578 XOR2X1 $PINS Z=n_5758 A=csm_inst_left_reg[24] B=n_5715 VSS=VSS VDD=VDD
Xg121579 XOR2X1 $PINS Z=n_5757 A=csm_inst_left_reg[15] B=n_5701 VSS=VSS VDD=VDD
Xg121580 NAND3X1 $PINS Z=n_5756 A=n_5704 B=n_5120 C=n_4864 VSS=VSS VDD=VDD
Xg121581 NAND3X1 $PINS Z=n_5754 A=n_5708 B=n_5482 C=n_5120 VSS=VSS VDD=VDD
Xg121582 NOR2X1 $PINS Z=n_5753 A=n_410 B=n_5709 VSS=VSS VDD=VDD
Xg121583 NOR2X1 $PINS Z=n_5751 A=n_5481 B=n_5713 VSS=VSS VDD=VDD
Xg121584 AND2X1 $PINS Z=n_5750 A=n_5722 B=n_5221 VSS=VSS VDD=VDD
Xg121585 NOR2X1 $PINS Z=n_5749 A=n_5636 B=n_5721 VSS=VSS VDD=VDD
Xg121586 NAND3X1 $PINS Z=n_5748 A=n_5696 B=n_5643 C=csm_inst_left_reg[18]
+ VSS=VSS VDD=VDD
Xg121587 NAND3X1 $PINS Z=n_5747 A=n_5697 B=n_5672 C=csm_inst_left_reg[21]
+ VSS=VSS VDD=VDD
Xg121589 NAND3X1 $PINS Z=n_5743 A=n_5685 B=n_5654 C=n_5214 VSS=VSS VDD=VDD
Xg121590 NAND3X1 $PINS Z=n_5742 A=n_5589 B=n_5614 C=n_5673 VSS=VSS VDD=VDD
Xg121591 NAND3X1 $PINS Z=n_5741 A=n_5694 B=n_5649 C=n_4706 VSS=VSS VDD=VDD
Xg121592 NAND3X1 $PINS Z=n_5740 A=n_5693 B=n_5545 C=n_4899 VSS=VSS VDD=VDD
Xg121593 XOR2X1 $PINS Z=n_5739 A=csm_inst_left_reg[7] B=n_5660 VSS=VSS VDD=VDD
Xg121594 NOR2X1 $PINS Z=n_5737 A=n_5311 B=n_5723 VSS=VSS VDD=VDD
Xg121595 XOR2X1 $PINS Z=n_5736 A=csm_inst_left_reg[14] B=n_5659 VSS=VSS VDD=VDD
Xg121596 XOR2X1 $PINS Z=n_5735 A=csm_inst_left_reg[26] B=n_5661 VSS=VSS VDD=VDD
Xg121597 XOR2X1 $PINS Z=n_5734 A=csm_inst_left_reg[19] B=n_5676 VSS=VSS VDD=VDD
Xg121598 NAND3X1 $PINS Z=n_5733 A=n_5724 B=n_5063 C=n_4946 VSS=VSS VDD=VDD
Xg121599 XOR2X1 $PINS Z=n_5732 A=csm_inst_left_reg[4] B=n_5674 VSS=VSS VDD=VDD
Xg121600 XOR2X1 $PINS Z=n_5731 A=csm_inst_left_reg[13] B=n_5675 VSS=VSS VDD=VDD
Xg121601 XOR2X1 $PINS Z=n_5729 A=csm_inst_left_reg[29] B=n_5658 VSS=VSS VDD=VDD
Xg121602 NAND3X1 $PINS Z=n_5728 A=n_5719 B=n_4723 C=n_4607 VSS=VSS VDD=VDD
Xg121603 NAND3X1 $PINS Z=n_5726 A=n_5686 B=n_5556 C=n_5161 VSS=VSS VDD=VDD
Xg121604 OR2X1 $PINS Z=n_5725 A=n_3555 B=n_5696 VSS=VSS VDD=VDD
Xg121605 NOR2X1 $PINS Z=n_5724 A=n_4987 B=n_5662 VSS=VSS VDD=VDD
Xg121606 NAND3X1 $PINS Z=n_5723 A=n_5656 B=n_5577 C=n_4706 VSS=VSS VDD=VDD
Xg121607 NOR2X1 $PINS Z=n_5722 A=n_5558 B=n_5665 VSS=VSS VDD=VDD
Xg121608 NAND3X1 $PINS Z=n_5721 A=n_5655 B=n_5338 C=n_4731 VSS=VSS VDD=VDD
Xg121609 NAND2X1 $PINS Z=n_5720 A=n_5671 B=n_764 VSS=VSS VDD=VDD
Xg121610 NOR2X1 $PINS Z=n_5719 A=n_5093 B=n_5670 VSS=VSS VDD=VDD
Xg121611 NOR2X1 $PINS Z=n_5717 A=n_5313 B=n_5695 VSS=VSS VDD=VDD
Xg121612 NAND3X1 $PINS Z=n_5716 A=n_5651 B=n_5373 C=n_4916 VSS=VSS VDD=VDD
Xg121613 NAND3X1 $PINS Z=n_5715 A=n_5652 B=n_5599 C=n_5572 VSS=VSS VDD=VDD
Xg121614 NOR2X1 $PINS Z=n_5714 A=n_5635 B=n_5667 VSS=VSS VDD=VDD
Xg121615 NAND3X1 $PINS Z=n_5713 A=n_5679 B=n_5598 C=n_5563 VSS=VSS VDD=VDD
Xg121616 NOR2X1 $PINS Z=n_5711 A=n_4948 B=n_5663 VSS=VSS VDD=VDD
Xg121617 NOR2X1 $PINS Z=n_5710 A=n_5346 B=n_5666 VSS=VSS VDD=VDD
Xg121618 XOR2X1 $PINS Z=n_5709 A=csm_inst_left_reg[28] B=n_5645 VSS=VSS VDD=VDD
Xg121619 NOR2X1 $PINS Z=n_5708 A=n_5486 B=n_5669 VSS=VSS VDD=VDD
Xg121620 OR2X1 $PINS Z=n_5707 A=n_3634 B=n_5697 VSS=VSS VDD=VDD
Xg121622 NAND3X1 $PINS Z=n_5705 A=n_5642 B=n_20 C=n_35 VSS=VSS VDD=VDD
Xg121623 NOR2X1 $PINS Z=n_5704 A=n_4368 B=n_5677 VSS=VSS VDD=VDD
Xg121624 NAND3X1 $PINS Z=n_5701 A=n_5657 B=n_5647 C=n_5507 VSS=VSS VDD=VDD
Xg121625 NAND3X1 $PINS Z=n_5698 A=n_5678 B=n_5543 C=n_5296 VSS=VSS VDD=VDD
Xg121626 NAND3X1 $PINS Z=n_5695 A=n_5587 B=n_5347 C=n_4875 VSS=VSS VDD=VDD
Xg121627 NOR2X1 $PINS Z=n_5694 A=n_5362 B=n_5638 VSS=VSS VDD=VDD
Xg121628 AND2X1 $PINS Z=n_5693 A=n_5650 B=n_5135 VSS=VSS VDD=VDD
Xg121629 NOR2X1 $PINS Z=n_5686 A=n_5557 B=n_5641 VSS=VSS VDD=VDD
Xg121630 AND2X1 $PINS Z=n_5685 A=n_5653 B=n_5535 VSS=VSS VDD=VDD
Xg121631 OR2X1 $PINS Z=n_5679 A=n_5099 B=n_5640 VSS=VSS VDD=VDD
Xg121632 NOR2X1 $PINS Z=n_5678 A=n_5608 B=n_5634 VSS=VSS VDD=VDD
Xg121633 NAND3X1 $PINS Z=n_5677 A=n_5646 B=n_5087 C=n_4600 VSS=VSS VDD=VDD
Xg121634 NOR2X1 $PINS Z=n_5676 A=n_5323 B=n_5631 VSS=VSS VDD=VDD
Xg121635 NAND3X1 $PINS Z=n_5675 A=n_5603 B=n_5398 C=n_5194 VSS=VSS VDD=VDD
Xg121636 NOR2X1 $PINS Z=n_5697 A=n_410 B=n_5632 VSS=VSS VDD=VDD
Xg121637 NOR2X1 $PINS Z=n_5696 A=n_410 B=n_5633 VSS=VSS VDD=VDD
Xg121638 NAND3X1 $PINS Z=n_5674 A=n_5590 B=n_4710 C=n_5055 VSS=VSS VDD=VDD
Xg121639 INVX2 $PINS Z=n_5673 A=n_5668 VSS=VSS VDD=VDD
Xg121640 INVX2 $PINS Z=n_5672 A=n_5671 VSS=VSS VDD=VDD
Xg121641 NAND3X1 $PINS Z=n_5670 A=n_5578 B=n_5124 C=n_4847 VSS=VSS VDD=VDD
Xg121642 NAND3X1 $PINS Z=n_5669 A=n_5617 B=n_5193 C=n_4878 VSS=VSS VDD=VDD
Xg121643 NAND3X1 $PINS Z=n_5668 A=n_5588 B=n_5612 C=n_5527 VSS=VSS VDD=VDD
Xg121644 NAND3X1 $PINS Z=n_5667 A=n_5613 B=n_4975 C=n_4914 VSS=VSS VDD=VDD
Xg121645 NAND3X1 $PINS Z=n_5666 A=n_5611 B=n_5470 C=n_5343 VSS=VSS VDD=VDD
Xg121646 NAND3X1 $PINS Z=n_5665 A=n_5610 B=n_5467 C=n_5502 VSS=VSS VDD=VDD
Xg121647 NAND3X1 $PINS Z=n_5664 A=n_5536 B=n_5607 C=n_4713 VSS=VSS VDD=VDD
Xg121648 NAND3X1 $PINS Z=n_5663 A=n_5630 B=n_5605 C=n_4913 VSS=VSS VDD=VDD
Xg121649 NAND3X1 $PINS Z=n_5662 A=n_5618 B=n_5485 C=n_5080 VSS=VSS VDD=VDD
Xg121650 NAND3X1 $PINS Z=n_5661 A=n_5639 B=n_5499 C=n_5315 VSS=VSS VDD=VDD
Xg121651 NAND3X1 $PINS Z=n_5671 A=n_5579 B=n_5549 C=n_4861 VSS=VSS VDD=VDD
Xg121652 NAND3X1 $PINS Z=n_5660 A=n_5644 B=n_5410 C=n_5361 VSS=VSS VDD=VDD
Xg121653 NAND3X1 $PINS Z=n_5659 A=n_5609 B=n_4710 C=n_4391 VSS=VSS VDD=VDD
Xg121654 NAND3X1 $PINS Z=n_5658 A=n_5623 B=n_5575 C=n_5412 VSS=VSS VDD=VDD
Xg121655 INVX2 $PINS Z=n_5657 A=n_5648 VSS=VSS VDD=VDD
Xg121656 AND2X1 $PINS Z=n_5656 A=n_5620 B=n_5370 VSS=VSS VDD=VDD
Xg121657 AND2X1 $PINS Z=n_5655 A=n_5597 B=n_5190 VSS=VSS VDD=VDD
Xg121658 NOR2X1 $PINS Z=n_5654 A=n_5544 B=n_5625 VSS=VSS VDD=VDD
Xg121659 NOR2X1 $PINS Z=n_5653 A=n_5627 B=n_5594 VSS=VSS VDD=VDD
Xg121660 AND2X1 $PINS Z=n_5652 A=n_5600 B=n_5298 VSS=VSS VDD=VDD
Xg121661 NOR2X1 $PINS Z=n_5651 A=n_5372 B=n_5629 VSS=VSS VDD=VDD
Xg121662 NOR2X1 $PINS Z=n_5650 A=n_4893 B=n_6070 VSS=VSS VDD=VDD
Xg121663 AND2X1 $PINS Z=n_5649 A=n_5616 B=n_5364 VSS=VSS VDD=VDD
Xg121664 NAND3X1 $PINS Z=n_5648 A=n_5571 B=n_5124 C=n_5002 VSS=VSS VDD=VDD
Xg121665 NOR2X1 $PINS Z=n_5647 A=n_4725 B=n_5584 VSS=VSS VDD=VDD
Xg121666 NOR2X1 $PINS Z=n_5646 A=n_4715 B=n_5581 VSS=VSS VDD=VDD
Xg121667 NOR2X1 $PINS Z=n_5645 A=n_5504 B=n_5592 VSS=VSS VDD=VDD
Xg121668 INVX2 $PINS Z=n_5644 A=n_5637 VSS=VSS VDD=VDD
Xg121669 INVX2 $PINS Z=n_5643 A=n_5642 VSS=VSS VDD=VDD
Xg121670 NAND3X1 $PINS Z=n_5641 A=n_5574 B=n_5329 C=n_4865 VSS=VSS VDD=VDD
Xg121671 NAND3X1 $PINS Z=n_5640 A=n_5565 B=n_5304 C=n_4818 VSS=VSS VDD=VDD
Xg121672 NOR2X1 $PINS Z=n_5639 A=n_5626 B=n_5595 VSS=VSS VDD=VDD
Xg121673 NAND3X1 $PINS Z=n_5638 A=n_5596 B=n_5044 C=n_5216 VSS=VSS VDD=VDD
Xg121674 NAND3X1 $PINS Z=n_5637 A=n_5615 B=n_5476 C=n_5060 VSS=VSS VDD=VDD
Xg121675 NAND3X1 $PINS Z=n_5636 A=n_5576 B=n_5339 C=n_5429 VSS=VSS VDD=VDD
Xg121676 NAND3X1 $PINS Z=n_5635 A=n_5541 B=n_4883 C=n_5360 VSS=VSS VDD=VDD
Xg121677 NAND3X1 $PINS Z=n_5634 A=n_5554 B=n_5457 C=n_5145 VSS=VSS VDD=VDD
Xg121678 NAND3X1 $PINS Z=n_5633 A=n_5602 B=n_5299 C=n_5326 VSS=VSS VDD=VDD
Xg121679 NAND3X1 $PINS Z=n_5632 A=n_5539 B=n_5186 C=n_5320 VSS=VSS VDD=VDD
Xg121680 NAND3X1 $PINS Z=n_5631 A=n_5582 B=n_5573 C=n_4587 VSS=VSS VDD=VDD
Xg121681 NAND3X1 $PINS Z=n_5642 A=n_5540 B=n_5553 C=n_5381 VSS=VSS VDD=VDD
Xg121682 OR2X1 $PINS Z=n_5630 A=n_4141 B=n_5548 VSS=VSS VDD=VDD
Xg121683 NAND3X1 $PINS Z=n_5629 A=n_5488 B=n_5387 C=n_4766 VSS=VSS VDD=VDD
Xg121684 NAND2X1 $PINS Z=n_5628 A=n_5526 B=n_4216 VSS=VSS VDD=VDD
Xg121685 NOR2X1 $PINS Z=n_5627 A=n_4214 B=n_5512 VSS=VSS VDD=VDD
Xg121686 NAND2X1 $PINS Z=n_5626 A=n_5570 B=n_5380 VSS=VSS VDD=VDD
Xg121687 NOR2X1 $PINS Z=n_5625 A=n_5427 B=n_5511 VSS=VSS VDD=VDD
Xg121688 NOR2X1 $PINS Z=n_5623 A=n_5569 B=n_5531 VSS=VSS VDD=VDD
Xg121689 NAND2X1 $PINS Z=n_5620 A=n_5568 B=n_4141 VSS=VSS VDD=VDD
Xg121690 NAND2X1 $PINS Z=n_5618 A=n_5542 B=n_4521 VSS=VSS VDD=VDD
Xg121691 NOR2X1 $PINS Z=n_5617 A=n_4467 B=n_5530 VSS=VSS VDD=VDD
Xg121692 NAND2X1 $PINS Z=n_5616 A=n_5546 B=n_4141 VSS=VSS VDD=VDD
Xg121693 NOR2X1 $PINS Z=n_5615 A=n_5423 B=n_5529 VSS=VSS VDD=VDD
Xg121694 NOR2X1 $PINS Z=n_5614 A=n_5349 B=n_5561 VSS=VSS VDD=VDD
Xg121695 NAND2X1 $PINS Z=n_5613 A=n_5528 B=n_5475 VSS=VSS VDD=VDD
Xg121696 NAND2X1 $PINS Z=n_5612 A=n_5559 B=n_4212 VSS=VSS VDD=VDD
Xg121697 NAND2X1 $PINS Z=n_5611 A=n_5525 B=n_4487 VSS=VSS VDD=VDD
Xg121698 NAND2X1 $PINS Z=n_5610 A=n_5524 B=n_4215 VSS=VSS VDD=VDD
Xg121699 NOR2X1 $PINS Z=n_5609 A=n_4972 B=n_5523 VSS=VSS VDD=VDD
Xg121700 OR2X1 $PINS Z=n_5608 A=n_5328 B=n_5555 VSS=VSS VDD=VDD
Xg121701 NAND2X1 $PINS Z=n_5607 A=n_5550 B=n_4212 VSS=VSS VDD=VDD
Xg121703 INVX2 $PINS Z=n_5605 A=n_5601 VSS=VSS VDD=VDD
Xg121704 INVX2 $PINS Z=n_5603 A=n_5585 VSS=VSS VDD=VDD
Xg121705 INVX2 $PINS Z=n_5602 A=n_5583 VSS=VSS VDD=VDD
Xg121706 NAND3X1 $PINS Z=n_5601 A=n_5446 B=n_5318 C=n_4472 VSS=VSS VDD=VDD
Xg121707 NAND2X1 $PINS Z=n_5600 A=n_5547 B=n_4319 VSS=VSS VDD=VDD
Xg121708 NOR2X1 $PINS Z=n_5599 A=n_5420 B=n_5518 VSS=VSS VDD=VDD
Xg121709 NAND2X1 $PINS Z=n_5598 A=n_5517 B=n_4075 VSS=VSS VDD=VDD
Xg121710 NAND2X1 $PINS Z=n_5597 A=n_5546 B=n_4140 VSS=VSS VDD=VDD
Xg121711 NOR2X1 $PINS Z=n_5596 A=n_5293 B=n_5562 VSS=VSS VDD=VDD
Xg121712 NAND3X1 $PINS Z=n_5595 A=n_5492 B=n_5491 C=n_5493 VSS=VSS VDD=VDD
Xg121713 NAND3X1 $PINS Z=n_5594 A=n_5425 B=n_5413 C=n_5077 VSS=VSS VDD=VDD
Xg121714 NAND3X1 $PINS Z=n_5592 A=n_5532 B=n_5421 C=n_5506 VSS=VSS VDD=VDD
Xg121715 NOR2X1 $PINS Z=n_5590 A=n_5484 B=n_5567 VSS=VSS VDD=VDD
Xg121716 NAND3X1 $PINS Z=n_5589 A=n_5435 B=n_4528 C=n_4148 VSS=VSS VDD=VDD
Xg121717 NAND3X1 $PINS Z=n_5588 A=n_5473 B=n_4811 C=n_4149 VSS=VSS VDD=VDD
Xg121718 NOR2X1 $PINS Z=n_5587 A=n_5472 B=n_5538 VSS=VSS VDD=VDD
Xg121719 NAND3X1 $PINS Z=n_5586 A=n_5469 B=n_4831 C=n_4830 VSS=VSS VDD=VDD
Xg121720 NAND3X1 $PINS Z=n_5585 A=n_5505 B=n_5337 C=n_4867 VSS=VSS VDD=VDD
Xg121721 NAND3X1 $PINS Z=n_5584 A=n_5332 B=n_5464 C=n_4576 VSS=VSS VDD=VDD
Xg121722 NAND3X1 $PINS Z=n_5583 A=n_5405 B=n_5314 C=n_4986 VSS=VSS VDD=VDD
Xg121723 NOR2X1 $PINS Z=n_5582 A=n_5322 B=n_5520 VSS=VSS VDD=VDD
Xg121724 NAND3X1 $PINS Z=n_5581 A=n_5454 B=n_5450 C=n_4863 VSS=VSS VDD=VDD
Xg121725 NAND3X1 $PINS Z=n_5579 A=n_5448 B=n_5223 C=n_4539 VSS=VSS VDD=VDD
Xg121726 NOR2X1 $PINS Z=n_5578 A=n_4902 B=n_5519 VSS=VSS VDD=VDD
Xg121727 NAND2X1 $PINS Z=n_5577 A=n_5411 B=n_4140 VSS=VSS VDD=VDD
Xg121728 NAND2X1 $PINS Z=n_5576 A=n_5415 B=n_4142 VSS=VSS VDD=VDD
Xg121729 AND2X1 $PINS Z=n_5575 A=n_5419 B=n_5424 VSS=VSS VDD=VDD
Xg121730 NAND2X1 $PINS Z=n_5574 A=n_5406 B=n_4810 VSS=VSS VDD=VDD
Xg121731 NAND2X1 $PINS Z=n_5573 A=n_5399 B=n_4092 VSS=VSS VDD=VDD
Xg121732 NAND3X1 $PINS Z=n_5572 A=n_5163 B=n_4496 C=n_4412 VSS=VSS VDD=VDD
Xg121733 NOR2X1 $PINS Z=n_5571 A=n_5022 B=n_5397 VSS=VSS VDD=VDD
Xg121734 NAND2X1 $PINS Z=n_5570 A=n_5414 B=n_4535 VSS=VSS VDD=VDD
Xg121735 OR2X1 $PINS Z=n_5569 A=n_6072 B=n_5205 VSS=VSS VDD=VDD
Xg121736 NAND2X1 $PINS Z=n_5568 A=n_5453 B=n_4696 VSS=VSS VDD=VDD
Xg121737 NAND2X1 $PINS Z=n_5567 A=n_5483 B=n_4901 VSS=VSS VDD=VDD
Xg121738 NAND2X1 $PINS Z=n_5566 A=n_5452 B=n_4215 VSS=VSS VDD=VDD
Xg121739 NOR2X1 $PINS Z=n_5565 A=n_4751 B=n_5437 VSS=VSS VDD=VDD
Xg121740 OR2X1 $PINS Z=n_5563 A=n_4818 B=n_5480 VSS=VSS VDD=VDD
Xg121741 AND2X1 $PINS Z=n_5562 A=n_5478 B=n_4140 VSS=VSS VDD=VDD
Xg121742 NOR2X1 $PINS Z=n_5561 A=n_4060 B=n_5474 VSS=VSS VDD=VDD
Xg121743 NAND2X1 $PINS Z=n_5559 A=n_5418 B=n_5159 VSS=VSS VDD=VDD
Xg121744 NOR2X1 $PINS Z=n_5558 A=n_4402 B=n_5468 VSS=VSS VDD=VDD
Xg121745 AND2X1 $PINS Z=n_5557 A=n_5461 B=n_4148 VSS=VSS VDD=VDD
Xg121746 NAND2X1 $PINS Z=n_5556 A=n_5462 B=n_4252 VSS=VSS VDD=VDD
Xg121747 NOR2X1 $PINS Z=n_5555 A=n_4422 B=n_5458 VSS=VSS VDD=VDD
Xg121748 OR2X1 $PINS Z=n_5554 A=n_4802 B=n_5430 VSS=VSS VDD=VDD
Xg121749 NAND2X1 $PINS Z=n_5553 A=n_5508 B=n_4956 VSS=VSS VDD=VDD
Xg121750 NAND2X1 $PINS Z=n_5550 A=n_5404 B=n_4716 VSS=VSS VDD=VDD
Xg121751 NAND2X1 $PINS Z=n_5549 A=n_5449 B=n_4722 VSS=VSS VDD=VDD
Xg121752 AND2X1 $PINS Z=n_5548 A=n_5453 B=n_5396 VSS=VSS VDD=VDD
Xg121753 NAND3X1 $PINS Z=n_5547 A=n_5191 B=n_5118 C=n_5083 VSS=VSS VDD=VDD
Xg121754 NAND2X1 $PINS Z=n_5545 A=n_5403 B=n_4307 VSS=VSS VDD=VDD
Xg121755 AND2X1 $PINS Z=n_5544 A=n_5452 B=n_4214 VSS=VSS VDD=VDD
Xg121756 NAND3X1 $PINS Z=n_5543 A=n_5231 B=n_4215 C=n_4135 VSS=VSS VDD=VDD
Xg121757 NAND2X1 $PINS Z=n_5542 A=n_5400 B=n_4605 VSS=VSS VDD=VDD
Xg121758 NAND2X1 $PINS Z=n_5541 A=n_5431 B=n_4314 VSS=VSS VDD=VDD
Xg121759 NAND2X1 $PINS Z=n_5540 A=n_5455 B=n_4328 VSS=VSS VDD=VDD
Xg121760 NAND2X1 $PINS Z=n_5539 A=n_5440 B=n_4672 VSS=VSS VDD=VDD
Xg121761 NAND3X1 $PINS Z=n_5538 A=n_5078 B=n_5330 C=n_5025 VSS=VSS VDD=VDD
Xg121762 NAND3X1 $PINS Z=n_5536 A=n_5309 B=n_5178 C=n_4415 VSS=VSS VDD=VDD
Xg121763 NAND3X1 $PINS Z=n_5535 A=n_5378 B=n_5199 C=n_4840 VSS=VSS VDD=VDD
Xg121764 NOR2X1 $PINS Z=n_5532 A=n_5490 B=n_5489 VSS=VSS VDD=VDD
Xg121765 NAND3X1 $PINS Z=n_5531 A=n_5160 B=n_5157 C=n_5219 VSS=VSS VDD=VDD
Xg121766 NAND3X1 $PINS Z=n_5530 A=n_5367 B=n_5188 C=n_5059 VSS=VSS VDD=VDD
Xg121767 NAND3X1 $PINS Z=n_5529 A=n_5185 B=n_5503 C=n_4907 VSS=VSS VDD=VDD
Xg121768 NAND3X1 $PINS Z=n_5528 A=n_5348 B=n_5091 C=n_4693 VSS=VSS VDD=VDD
Xg121769 NAND3X1 $PINS Z=n_5527 A=n_5187 B=n_4209 C=n_4060 VSS=VSS VDD=VDD
Xg121770 NAND3X1 $PINS Z=n_5526 A=n_5324 B=n_5123 C=n_4971 VSS=VSS VDD=VDD
Xg121771 NAND3X1 $PINS Z=n_5525 A=n_5152 B=n_4365 C=n_4378 VSS=VSS VDD=VDD
Xg121772 NAND3X1 $PINS Z=n_5524 A=n_5434 B=n_5198 C=n_4960 VSS=VSS VDD=VDD
Xg121773 NAND3X1 $PINS Z=n_5523 A=n_5466 B=n_5334 C=n_4581 VSS=VSS VDD=VDD
Xg121774 NAND3X1 $PINS Z=n_5520 A=n_5321 B=n_4606 C=n_4790 VSS=VSS VDD=VDD
Xg121775 NAND3X1 $PINS Z=n_5519 A=n_5444 B=n_4939 C=n_4620 VSS=VSS VDD=VDD
Xg121776 NAND3X1 $PINS Z=n_5518 A=n_5158 B=n_5442 C=n_5316 VSS=VSS VDD=VDD
Xg121777 MUX2X1 $PINS Z=n_5517 A=n_4836 B=n_5302 S=n_4139 VSS=VSS VDD=VDD
Xg121778 MUX2X1 $PINS Z=n_5512 A=n_5312 B=n_4926 S=n_4139 VSS=VSS VDD=VDD
Xg121779 MUX2X1 $PINS Z=n_5511 A=n_4830 B=n_5290 S=n_4139 VSS=VSS VDD=VDD
Xg121780 MUX2X1 $PINS Z=n_5546 A=n_5363 B=n_4273 S=n_4065 VSS=VSS VDD=VDD
Xg121782 NAND2X1 $PINS Z=n_5508 A=n_5143 B=n_4783 VSS=VSS VDD=VDD
Xg121783 OR2X1 $PINS Z=n_5507 A=n_4125 B=n_5333 VSS=VSS VDD=VDD
Xg121784 NAND3X1 $PINS Z=n_5506 A=n_5076 B=n_4225 C=n_4144 VSS=VSS VDD=VDD
Xg121785 NAND2X1 $PINS Z=n_5505 A=n_5148 B=n_4501 VSS=VSS VDD=VDD
Xg121786 NOR2X1 $PINS Z=n_5504 A=n_4225 B=n_5189 VSS=VSS VDD=VDD
Xg121787 NAND2X1 $PINS Z=n_5503 A=n_5358 B=n_4086 VSS=VSS VDD=VDD
Xg121788 NAND2X1 $PINS Z=n_5502 A=n_5174 B=n_4441 VSS=VSS VDD=VDD
Xg121789 NAND3X1 $PINS Z=n_5499 A=n_4966 B=n_4689 C=n_4212 VSS=VSS VDD=VDD
Xg121790 OR2X1 $PINS Z=n_5493 A=n_4409 B=n_5306 VSS=VSS VDD=VDD
Xg121791 NAND2X1 $PINS Z=n_5492 A=n_5395 B=n_4257 VSS=VSS VDD=VDD
Xg121792 OR2X1 $PINS Z=n_5491 A=n_4528 B=n_5379 VSS=VSS VDD=VDD
Xg121793 NAND2X1 $PINS Z=n_5490 A=n_5377 B=n_4768 VSS=VSS VDD=VDD
Xg121794 NAND2X1 $PINS Z=n_5489 A=n_5162 B=n_5227 VSS=VSS VDD=VDD
Xg121795 AND2X1 $PINS Z=n_5488 A=n_5371 B=n_4764 VSS=VSS VDD=VDD
Xg121796 NAND2X1 $PINS Z=n_5486 A=n_5368 B=n_4755 VSS=VSS VDD=VDD
Xg121797 NAND2X1 $PINS Z=n_5485 A=n_5181 B=n_4540 VSS=VSS VDD=VDD
Xg121798 NAND2X1 $PINS Z=n_5484 A=n_5366 B=n_5386 VSS=VSS VDD=VDD
Xg121799 NAND2X1 $PINS Z=n_5483 A=n_5156 B=n_4151 VSS=VSS VDD=VDD
Xg121800 NAND2X1 $PINS Z=n_5482 A=n_5390 B=n_4292 VSS=VSS VDD=VDD
Xg121801 AND2X1 $PINS Z=n_5481 A=n_5392 B=n_4961 VSS=VSS VDD=VDD
Xg121802 AND2X1 $PINS Z=n_5480 A=n_5212 B=n_4993 VSS=VSS VDD=VDD
Xg121803 NAND2X1 $PINS Z=n_5478 A=n_5155 B=n_4589 VSS=VSS VDD=VDD
Xg121804 NAND3X1 $PINS Z=n_5476 A=n_4574 B=n_5046 C=n_4289 VSS=VSS VDD=VDD
Xg121805 NAND2X1 $PINS Z=n_5475 A=n_5355 B=n_4181 VSS=VSS VDD=VDD
Xg121806 NOR2X1 $PINS Z=n_5474 A=n_5035 B=n_5172 VSS=VSS VDD=VDD
Xg121807 NAND2X1 $PINS Z=n_5473 A=n_5306 B=n_5153 VSS=VSS VDD=VDD
Xg121808 NAND2X1 $PINS Z=n_5472 A=n_4938 B=n_5388 VSS=VSS VDD=VDD
Xg121809 OR2X1 $PINS Z=n_5470 A=n_4292 B=n_5342 VSS=VSS VDD=VDD
Xg121810 NAND2X1 $PINS Z=n_5469 A=n_5151 B=n_4835 VSS=VSS VDD=VDD
Xg121811 AND2X1 $PINS Z=n_5468 A=n_5341 B=n_4869 VSS=VSS VDD=VDD
Xg121812 NAND2X1 $PINS Z=n_5467 A=n_5340 B=n_4543 VSS=VSS VDD=VDD
Xg121813 NAND2X1 $PINS Z=n_5466 A=n_5170 B=n_4300 VSS=VSS VDD=VDD
Xg121815 NAND2X1 $PINS Z=n_5464 A=n_5331 B=n_4090 VSS=VSS VDD=VDD
Xg121816 NAND2X1 $PINS Z=n_5462 A=n_5394 B=n_4575 VSS=VSS VDD=VDD
Xg121817 NAND2X1 $PINS Z=n_5461 A=n_5306 B=n_5147 VSS=VSS VDD=VDD
Xg121818 NOR2X1 $PINS Z=n_5458 A=n_5392 B=n_5301 VSS=VSS VDD=VDD
Xg121819 OR2X1 $PINS Z=n_5457 A=n_4407 B=n_5327 VSS=VSS VDD=VDD
Xg121820 NAND2X1 $PINS Z=n_5455 A=n_5325 B=n_4712 VSS=VSS VDD=VDD
Xg121821 NAND2X1 $PINS Z=n_5454 A=n_5141 B=n_4307 VSS=VSS VDD=VDD
Xg121822 NAND2X1 $PINS Z=n_5450 A=n_5385 B=n_4318 VSS=VSS VDD=VDD
Xg121823 NAND2X1 $PINS Z=n_5449 A=n_5295 B=n_4981 VSS=VSS VDD=VDD
Xg121824 NAND2X1 $PINS Z=n_5448 A=n_5183 B=n_4221 VSS=VSS VDD=VDD
Xg121825 NAND2X1 $PINS Z=n_5446 A=n_5391 B=n_4141 VSS=VSS VDD=VDD
Xg121826 NOR2X1 $PINS Z=n_5444 A=n_5092 B=n_5382 VSS=VSS VDD=VDD
Xg121827 NAND2X1 $PINS Z=n_5442 A=n_5317 B=n_4156 VSS=VSS VDD=VDD
Xg121828 MUX2X1 $PINS Z=n_5440 A=n_4461 B=n_4900 S=n_4225 VSS=VSS VDD=VDD
Xg121829 NOR2X1 $PINS Z=n_5437 A=n_4214 B=n_5319 VSS=VSS VDD=VDD
Xg121830 NAND2X1 $PINS Z=n_5435 A=n_5309 B=n_4379 VSS=VSS VDD=VDD
Xg121831 NAND2X1 $PINS Z=n_5434 A=n_5303 B=n_4401 VSS=VSS VDD=VDD
Xg121832 NAND3X1 $PINS Z=n_5433 A=n_5023 B=n_4030 C=n_4064 VSS=VSS VDD=VDD
Xg121833 NAND2X1 $PINS Z=n_5432 A=n_5305 B=n_4492 VSS=VSS VDD=VDD
Xg121834 NAND2X1 $PINS Z=n_5431 A=n_5359 B=n_4463 VSS=VSS VDD=VDD
Xg121835 NOR2X1 $PINS Z=n_5430 A=n_4784 B=n_5230 VSS=VSS VDD=VDD
Xg121836 OR2X1 $PINS Z=n_5429 A=n_4065 B=n_5149 VSS=VSS VDD=VDD
Xg121838 NOR2X1 $PINS Z=n_5427 A=n_4961 B=n_5307 VSS=VSS VDD=VDD
Xg121839 NAND3X1 $PINS Z=n_5425 A=n_5106 B=n_4422 C=n_4074 VSS=VSS VDD=VDD
Xg121840 OR2X1 $PINS Z=n_5424 A=n_4328 B=n_5376 VSS=VSS VDD=VDD
Xg121841 AND2X1 $PINS Z=n_5423 A=n_5220 B=n_4328 VSS=VSS VDD=VDD
Xg121842 NAND2X1 $PINS Z=n_5421 A=n_5229 B=n_4494 VSS=VSS VDD=VDD
Xg121843 NOR2X1 $PINS Z=n_5420 A=n_4817 B=n_5297 VSS=VSS VDD=VDD
Xg121844 NAND3X1 $PINS Z=n_5419 A=n_4955 B=n_4511 C=n_4155 VSS=VSS VDD=VDD
Xg121845 NAND3X1 $PINS Z=n_5418 A=n_5030 B=n_4408 C=n_4149 VSS=VSS VDD=VDD
Xg121846 NAND3X1 $PINS Z=n_5415 A=n_4949 B=n_4824 C=n_4645 VSS=VSS VDD=VDD
Xg121847 NAND3X1 $PINS Z=n_5414 A=n_5128 B=n_4832 C=n_4442 VSS=VSS VDD=VDD
Xg121848 NAND3X1 $PINS Z=n_5413 A=n_4950 B=n_4401 C=n_4214 VSS=VSS VDD=VDD
Xg121849 NAND3X1 $PINS Z=n_5412 A=n_4956 B=n_4328 C=n_4237 VSS=VSS VDD=VDD
Xg121850 NAND3X1 $PINS Z=n_5411 A=n_5300 B=n_5071 C=n_4762 VSS=VSS VDD=VDD
Xg121851 NAND3X1 $PINS Z=n_5410 A=n_5062 B=n_4480 C=n_4083 VSS=VSS VDD=VDD
Xg121852 NAND3X1 $PINS Z=n_5406 A=n_4940 B=n_4992 C=n_4389 VSS=VSS VDD=VDD
Xg121853 NAND3X1 $PINS Z=n_5405 A=n_4896 B=n_4675 C=n_4156 VSS=VSS VDD=VDD
Xg121854 NAND3X1 $PINS Z=n_5404 A=n_4967 B=n_4217 C=n_4149 VSS=VSS VDD=VDD
Xg121855 NAND3X1 $PINS Z=n_5403 A=n_4882 B=n_4432 C=n_4330 VSS=VSS VDD=VDD
Xg121856 NAND3X1 $PINS Z=n_5401 A=n_4970 B=n_4311 C=n_4030 VSS=VSS VDD=VDD
Xg121857 MUX2X1 $PINS Z=n_5400 A=n_4943 B=n_4425 S=n_4233 VSS=VSS VDD=VDD
Xg121858 MUX2X1 $PINS Z=n_5399 A=n_4170 B=n_5088 S=n_4438 VSS=VSS VDD=VDD
Xg121859 MUX2X1 $PINS Z=n_5398 A=n_4603 B=n_5079 S=n_4800 VSS=VSS VDD=VDD
Xg121860 MUX2X1 $PINS Z=n_5397 A=n_4678 B=n_4998 S=n_4072 VSS=VSS VDD=VDD
Xg121861 MUX2X1 $PINS Z=n_5453 A=n_4980 B=n_4271 S=n_4065 VSS=VSS VDD=VDD
Xg121862 NOR2X1 $PINS Z=n_5452 A=n_4407 B=n_5308 VSS=VSS VDD=VDD
Xg121863 INVX2 $PINS Z=n_5395 A=n_5394 VSS=VSS VDD=VDD
Xg121864 NAND2X1 $PINS Z=n_5391 A=n_4824 B=n_4915 VSS=VSS VDD=VDD
Xg121865 NAND2X1 $PINS Z=n_5390 A=n_4957 B=n_4619 VSS=VSS VDD=VDD
Xg121866 OR2X1 $PINS Z=n_5389 A=n_4306 B=n_4957 VSS=VSS VDD=VDD
Xg121867 NAND3X1 $PINS Z=n_5388 A=n_4735 B=n_4234 C=n_4131 VSS=VSS VDD=VDD
Xg121868 NAND2X1 $PINS Z=n_5387 A=n_4933 B=n_4297 VSS=VSS VDD=VDD
Xg121869 NAND2X1 $PINS Z=n_5386 A=n_5054 B=n_4298 VSS=VSS VDD=VDD
Xg121870 NAND2X1 $PINS Z=n_5385 A=n_4957 B=n_4614 VSS=VSS VDD=VDD
Xg121871 NOR2X1 $PINS Z=n_5382 A=n_4235 B=n_4890 VSS=VSS VDD=VDD
Xg121872 NAND2X1 $PINS Z=n_5381 A=n_4885 B=n_3982 VSS=VSS VDD=VDD
Xg121873 NAND3X1 $PINS Z=n_5380 A=n_4702 B=n_4247 C=n_4209 VSS=VSS VDD=VDD
Xg121874 AND2X1 $PINS Z=n_5379 A=n_5123 B=n_4881 VSS=VSS VDD=VDD
Xg121875 NAND2X1 $PINS Z=n_5378 A=n_5099 B=n_4075 VSS=VSS VDD=VDD
Xg121876 NAND2X1 $PINS Z=n_5377 A=n_5075 B=n_4413 VSS=VSS VDD=VDD
Xg121877 AND2X1 $PINS Z=n_5376 A=n_5118 B=n_4767 VSS=VSS VDD=VDD
Xg121878 NAND2X1 $PINS Z=n_5373 A=n_4941 B=n_4331 VSS=VSS VDD=VDD
Xg121879 AND2X1 $PINS Z=n_5372 A=n_5073 B=n_4033 VSS=VSS VDD=VDD
Xg121880 NAND2X1 $PINS Z=n_5371 A=n_5072 B=n_4293 VSS=VSS VDD=VDD
Xg121881 NAND3X1 $PINS Z=n_5370 A=n_4685 B=n_4184 C=n_4143 VSS=VSS VDD=VDD
Xg121882 AND2X1 $PINS Z=n_5369 A=n_5064 B=n_4800 VSS=VSS VDD=VDD
Xg121883 NAND2X1 $PINS Z=n_5368 A=n_5113 B=n_4318 VSS=VSS VDD=VDD
Xg121884 NAND2X1 $PINS Z=n_5367 A=n_5056 B=n_4337 VSS=VSS VDD=VDD
Xg121885 NAND2X1 $PINS Z=n_5366 A=n_4877 B=n_4300 VSS=VSS VDD=VDD
Xg121887 NAND3X1 $PINS Z=n_5364 A=n_4685 B=n_4191 C=n_4142 VSS=VSS VDD=VDD
Xg121888 NAND2X1 $PINS Z=n_5363 A=n_4942 B=n_4476 VSS=VSS VDD=VDD
Xg121889 AND2X1 $PINS Z=n_5362 A=n_5045 B=n_4065 VSS=VSS VDD=VDD
Xg121890 NAND2X1 $PINS Z=n_5361 A=n_4963 B=n_4518 VSS=VSS VDD=VDD
Xg121891 OR2X1 $PINS Z=n_5360 A=n_4177 B=n_5040 VSS=VSS VDD=VDD
Xg121892 NAND2X1 $PINS Z=n_5359 A=n_4833 B=n_5089 VSS=VSS VDD=VDD
Xg121893 OR2X1 $PINS Z=n_5358 A=n_4905 B=n_5086 VSS=VSS VDD=VDD
Xg121894 NAND2X1 $PINS Z=n_5355 A=n_5003 B=n_4131 VSS=VSS VDD=VDD
Xg121895 NOR2X1 $PINS Z=n_5349 A=n_4848 B=n_5098 VSS=VSS VDD=VDD
Xg121896 NAND2X1 $PINS Z=n_5348 A=n_5032 B=n_4072 VSS=VSS VDD=VDD
Xg121897 AND2X1 $PINS Z=n_5347 A=n_4935 B=n_4591 VSS=VSS VDD=VDD
Xg121898 AND2X1 $PINS Z=n_5346 A=n_5094 B=n_4307 VSS=VSS VDD=VDD
Xg121899 OR2X1 $PINS Z=n_5343 A=n_4153 B=n_5017 VSS=VSS VDD=VDD
Xg121900 NOR2X1 $PINS Z=n_5342 A=n_4556 B=n_5113 VSS=VSS VDD=VDD
Xg121901 NAND3X1 $PINS Z=n_5341 A=n_4805 B=n_4214 C=n_4074 VSS=VSS VDD=VDD
Xg121902 OR2X1 $PINS Z=n_5340 A=n_5012 B=n_5106 VSS=VSS VDD=VDD
Xg121903 NAND2X1 $PINS Z=n_5339 A=n_5129 B=n_4142 VSS=VSS VDD=VDD
Xg121904 AND2X1 $PINS Z=n_5338 A=n_4868 B=n_4726 VSS=VSS VDD=VDD
Xg121905 NAND3X1 $PINS Z=n_5337 A=n_4672 B=n_4221 C=n_4230 VSS=VSS VDD=VDD
Xg121906 NAND2X1 $PINS Z=n_5334 A=n_4866 B=n_4454 VSS=VSS VDD=VDD
Xg121907 NOR2X1 $PINS Z=n_5333 A=n_4633 B=n_5005 VSS=VSS VDD=VDD
Xg121908 NAND2X1 $PINS Z=n_5332 A=n_4997 B=n_4178 VSS=VSS VDD=VDD
Xg121909 NAND2X1 $PINS Z=n_5331 A=n_4887 B=n_4562 VSS=VSS VDD=VDD
Xg121910 NAND2X1 $PINS Z=n_5330 A=n_4858 B=n_4165 VSS=VSS VDD=VDD
Xg121911 OR2X1 $PINS Z=n_5329 A=n_4704 B=n_5128 VSS=VSS VDD=VDD
Xg121912 NOR2X1 $PINS Z=n_5328 A=n_4541 B=n_5099 VSS=VSS VDD=VDD
Xg121913 NOR2X1 $PINS Z=n_5327 A=n_4441 B=n_4991 VSS=VSS VDD=VDD
Xg121914 NAND2X1 $PINS Z=n_5326 A=n_5132 B=n_4675 VSS=VSS VDD=VDD
Xg121915 NAND2X1 $PINS Z=n_5325 A=n_4955 B=n_4086 VSS=VSS VDD=VDD
Xg121916 NAND2X1 $PINS Z=n_5324 A=n_5095 B=n_4270 VSS=VSS VDD=VDD
Xg121917 NOR2X1 $PINS Z=n_5323 A=n_4033 B=n_4904 VSS=VSS VDD=VDD
Xg121918 NAND2X1 $PINS Z=n_5322 A=n_4985 B=n_4752 VSS=VSS VDD=VDD
Xg121919 NAND2X1 $PINS Z=n_5321 A=n_4982 B=n_4033 VSS=VSS VDD=VDD
Xg121920 NAND2X1 $PINS Z=n_5320 A=n_4903 B=n_4540 VSS=VSS VDD=VDD
Xg121921 NOR2X1 $PINS Z=n_5319 A=n_4075 B=n_4959 VSS=VSS VDD=VDD
Xg121922 NAND2X1 $PINS Z=n_5318 A=n_4979 B=n_4255 VSS=VSS VDD=VDD
Xg121923 NAND2X1 $PINS Z=n_5317 A=n_5131 B=n_4888 VSS=VSS VDD=VDD
Xg121924 NAND2X1 $PINS Z=n_5316 A=n_4963 B=n_4086 VSS=VSS VDD=VDD
Xg121925 NAND2X1 $PINS Z=n_5315 A=n_4976 B=n_4415 VSS=VSS VDD=VDD
Xg121926 NAND2X1 $PINS Z=n_5314 A=n_4930 B=n_4801 VSS=VSS VDD=VDD
Xg121927 NAND2X1 $PINS Z=n_5313 A=n_5014 B=n_4895 VSS=VSS VDD=VDD
Xg121928 NAND2X1 $PINS Z=n_5312 A=n_4954 B=n_4407 VSS=VSS VDD=VDD
Xg121929 NOR2X1 $PINS Z=n_5311 A=n_4142 B=n_5130 VSS=VSS VDD=VDD
Xg121930 AND2X1 $PINS Z=n_5396 A=n_4962 B=n_4860 VSS=VSS VDD=VDD
Xg121931 NAND2X1 $PINS Z=n_5394 A=n_5095 B=n_4217 VSS=VSS VDD=VDD
Xg121932 NOR2X1 $PINS Z=n_5392 A=n_4075 B=n_4958 VSS=VSS VDD=VDD
Xg121934 INVX2 $PINS Z=n_5308 A=n_5307 VSS=VSS VDD=VDD
Xg121935 MUX2X1 $PINS Z=n_5305 A=n_4610 B=n_4494 S=n_4221 VSS=VSS VDD=VDD
Xg121936 NAND2X1 $PINS Z=n_5304 A=n_4932 B=n_4214 VSS=VSS VDD=VDD
Xg121937 NAND2X1 $PINS Z=n_5303 A=n_4910 B=n_4174 VSS=VSS VDD=VDD
Xg121938 NOR2X1 $PINS Z=n_5302 A=n_4402 B=n_4911 VSS=VSS VDD=VDD
Xg121939 AND2X1 $PINS Z=n_5301 A=n_4959 B=n_4401 VSS=VSS VDD=VDD
Xg121940 NAND3X1 $PINS Z=n_5300 A=n_4660 B=n_4065 C=n_4095 VSS=VSS VDD=VDD
Xg121941 NAND3X1 $PINS Z=n_5299 A=n_4497 B=n_4794 C=n_4155 VSS=VSS VDD=VDD
Xg121942 NAND3X1 $PINS Z=n_5298 A=n_4794 B=n_4302 C=n_4236 VSS=VSS VDD=VDD
Xg121943 NOR2X1 $PINS Z=n_5297 A=n_4617 B=n_5085 VSS=VSS VDD=VDD
Xg121944 OR2X1 $PINS Z=n_5296 A=n_4818 B=n_4953 VSS=VSS VDD=VDD
Xg121945 NAND2X1 $PINS Z=n_5295 A=n_4945 B=n_4145 VSS=VSS VDD=VDD
Xg121946 NAND2X1 $PINS Z=n_5294 A=n_5122 B=n_4179 VSS=VSS VDD=VDD
Xg121947 NOR2X1 $PINS Z=n_5293 A=n_4192 B=n_5121 VSS=VSS VDD=VDD
Xg121948 OR2X1 $PINS Z=n_5290 A=n_4078 B=n_4954 VSS=VSS VDD=VDD
Xg121949 NOR2X1 $PINS Z=n_5231 A=n_4077 B=n_4954 VSS=VSS VDD=VDD
Xg121950 AND2X1 $PINS Z=n_5230 A=n_4954 B=n_4078 VSS=VSS VDD=VDD
Xg121951 NAND2X1 $PINS Z=n_5229 A=n_4912 B=n_4763 VSS=VSS VDD=VDD
Xg121952 NAND3X1 $PINS Z=n_5227 A=n_4638 B=n_4492 C=n_4225 VSS=VSS VDD=VDD
Xg121953 NAND3X1 $PINS Z=n_5224 A=n_4743 B=n_4353 C=n_4164 VSS=VSS VDD=VDD
Xg121954 NAND3X1 $PINS Z=n_5223 A=n_4692 B=n_4654 C=n_4425 VSS=VSS VDD=VDD
Xg121955 NAND2X1 $PINS Z=n_5221 A=n_4934 B=n_4407 VSS=VSS VDD=VDD
Xg121956 OR2X1 $PINS Z=n_5220 A=n_4906 B=n_5134 VSS=VSS VDD=VDD
Xg121957 NAND3X1 $PINS Z=n_5219 A=n_4816 B=n_4326 C=n_4236 VSS=VSS VDD=VDD
Xg121958 NAND3X1 $PINS Z=n_5216 A=n_4660 B=n_4630 C=n_4066 VSS=VSS VDD=VDD
Xg121959 NAND2X1 $PINS Z=n_5214 A=n_4834 B=n_4958 VSS=VSS VDD=VDD
Xg121960 NAND2X1 $PINS Z=n_5212 A=n_4958 B=n_4077 VSS=VSS VDD=VDD
Xg121961 NOR2X1 $PINS Z=n_5205 A=n_4303 B=n_5074 VSS=VSS VDD=VDD
Xg121962 NAND3X1 $PINS Z=n_5203 A=n_4810 B=n_4417 C=n_4146 VSS=VSS VDD=VDD
Xg121963 NAND2X1 $PINS Z=n_5199 A=n_4947 B=n_4802 VSS=VSS VDD=VDD
Xg121964 NAND3X1 $PINS Z=n_5198 A=n_4805 B=n_4402 C=n_4078 VSS=VSS VDD=VDD
Xg121965 NAND2X1 $PINS Z=n_5194 A=n_4952 B=n_4507 VSS=VSS VDD=VDD
Xg121966 NAND2X1 $PINS Z=n_5193 A=n_4898 B=n_4307 VSS=VSS VDD=VDD
Xg121967 OR2X1 $PINS Z=n_5191 A=n_4496 B=n_4955 VSS=VSS VDD=VDD
Xg121968 NAND3X1 $PINS Z=n_5190 A=n_4685 B=n_4193 C=n_4066 VSS=VSS VDD=VDD
Xg121969 NOR2X1 $PINS Z=n_5189 A=n_4599 B=n_4886 VSS=VSS VDD=VDD
Xg121970 NAND2X1 $PINS Z=n_5188 A=n_4894 B=n_4208 VSS=VSS VDD=VDD
Xg121971 NAND2X1 $PINS Z=n_5187 A=n_5031 B=n_4848 VSS=VSS VDD=VDD
Xg121972 NAND3X1 $PINS Z=n_5186 A=n_4698 B=n_4583 C=n_4484 VSS=VSS VDD=VDD
Xg121973 NAND3X1 $PINS Z=n_5185 A=n_4769 B=n_4319 C=n_4411 VSS=VSS VDD=VDD
Xg121974 NAND3X1 $PINS Z=n_5183 A=n_4582 B=n_4519 C=n_4225 VSS=VSS VDD=VDD
Xg121975 NAND3X1 $PINS Z=n_5181 A=n_4656 B=n_4757 C=n_4756 VSS=VSS VDD=VDD
Xg121976 NAND2X1 $PINS Z=n_5178 A=n_5095 B=n_4276 VSS=VSS VDD=VDD
Xg121977 MUX2X1 $PINS Z=n_5174 A=n_4407 B=n_4796 S=n_4402 VSS=VSS VDD=VDD
Xg121978 AND2X1 $PINS Z=n_5172 A=n_5098 B=n_4415 VSS=VSS VDD=VDD
Xg121979 NAND3X1 $PINS Z=n_5170 A=n_4639 B=n_4557 C=n_4274 VSS=VSS VDD=VDD
Xg121980 NOR2X1 $PINS Z=n_5163 A=n_4892 B=n_4420 VSS=VSS VDD=VDD
Xg121981 NAND3X1 $PINS Z=n_5162 A=n_4681 B=n_4507 C=n_4423 VSS=VSS VDD=VDD
Xg121982 NAND2X1 $PINS Z=n_5161 A=n_4994 B=n_4247 VSS=VSS VDD=VDD
Xg121983 NAND2X1 $PINS Z=n_5160 A=n_4880 B=n_4420 VSS=VSS VDD=VDD
Xg121984 NAND3X1 $PINS Z=n_5159 A=n_4637 B=n_4268 C=n_4217 VSS=VSS VDD=VDD
Xg121985 NAND3X1 $PINS Z=n_5158 A=n_4421 B=n_4509 C=n_4817 VSS=VSS VDD=VDD
Xg121986 NAND3X1 $PINS Z=n_5157 A=n_4801 B=n_4319 C=n_4237 VSS=VSS VDD=VDD
Xg121987 NAND3X1 $PINS Z=n_5156 A=n_4876 B=n_4355 C=n_4468 VSS=VSS VDD=VDD
Xg121988 NAND3X1 $PINS Z=n_5155 A=n_4663 B=n_4185 C=n_4065 VSS=VSS VDD=VDD
Xg121989 NAND3X1 $PINS Z=n_5154 A=n_4891 B=n_4565 C=n_4750 VSS=VSS VDD=VDD
Xg121990 NAND3X1 $PINS Z=n_5153 A=n_4669 B=n_4736 C=n_4209 VSS=VSS VDD=VDD
Xg121991 NAND3X1 $PINS Z=n_5152 A=n_4699 B=n_4030 C=n_4035 VSS=VSS VDD=VDD
Xg121992 NAND3X1 $PINS Z=n_5151 A=n_4776 B=n_4214 C=n_4195 VSS=VSS VDD=VDD
Xg121993 NAND3X1 $PINS Z=n_5149 A=n_4663 B=n_4141 C=n_4095 VSS=VSS VDD=VDD
Xg121994 NAND3X1 $PINS Z=n_5148 A=n_4778 B=n_4773 C=n_4414 VSS=VSS VDD=VDD
Xg121995 NAND3X1 $PINS Z=n_5147 A=n_4670 B=n_4212 C=n_4060 VSS=VSS VDD=VDD
Xg121996 NAND3X1 $PINS Z=n_5145 A=n_4831 B=n_4175 C=n_4215 VSS=VSS VDD=VDD
Xg121997 NAND3X1 $PINS Z=n_5143 A=n_4676 B=n_4156 C=n_4086 VSS=VSS VDD=VDD
Xg121998 NAND3X1 $PINS Z=n_5141 A=n_5112 B=n_4432 C=n_4714 VSS=VSS VDD=VDD
Xg121999 NAND3X1 $PINS Z=n_5137 A=n_4799 B=n_4507 C=n_4233 VSS=VSS VDD=VDD
Xg122000 NAND3X1 $PINS Z=n_5136 A=n_4684 B=n_4333 C=n_4066 VSS=VSS VDD=VDD
Xg122001 NAND3X1 $PINS Z=n_5135 A=n_4491 B=n_4739 C=n_4064 VSS=VSS VDD=VDD
Xg122002 NAND2X1 $PINS Z=n_5309 A=n_5098 B=n_4275 VSS=VSS VDD=VDD
Xg122003 NAND2X1 $PINS Z=n_5307 A=n_4897 B=n_4658 VSS=VSS VDD=VDD
Xg122004 NAND3X1 $PINS Z=n_5306 A=n_4669 B=n_4212 C=n_4061 VSS=VSS VDD=VDD
Xg122005 INVX2 $PINS Z=n_5132 A=n_5131 VSS=VSS VDD=VDD
Xg122006 INVX2 $PINS Z=n_5130 A=n_5129 VSS=VSS VDD=VDD
Xg122007 INVX2 $PINS Z=n_5122 A=n_5121 VSS=VSS VDD=VDD
Xg122008 INVX2 $PINS Z=n_5112 A=n_5113 VSS=VSS VDD=VDD
Xg122009 INVX2 $PINS Z=n_5095 A=n_5098 VSS=VSS VDD=VDD
Xg122010 OR2X1 $PINS Z=n_5094 A=n_4464 B=n_4705 VSS=VSS VDD=VDD
Xg122011 NOR2X1 $PINS Z=n_5093 A=n_4131 B=n_4683 VSS=VSS VDD=VDD
Xg122012 NOR2X1 $PINS Z=n_5092 A=n_4131 B=n_4849 VSS=VSS VDD=VDD
Xg122013 OR2X1 $PINS Z=n_5091 A=n_4488 B=n_4688 VSS=VSS VDD=VDD
Xg122014 NAND2X1 $PINS Z=n_5089 A=n_4629 B=n_4166 VSS=VSS VDD=VDD
Xg122015 NAND2X1 $PINS Z=n_5088 A=n_4604 B=n_4167 VSS=VSS VDD=VDD
Xg122016 OR2X1 $PINS Z=n_5087 A=n_4699 B=n_4485 VSS=VSS VDD=VDD
Xg122017 AND2X1 $PINS Z=n_5086 A=n_4794 B=n_4326 VSS=VSS VDD=VDD
Xg122018 NOR2X1 $PINS Z=n_5085 A=n_4086 B=n_4676 VSS=VSS VDD=VDD
Xg122019 NAND2X1 $PINS Z=n_5083 A=n_4801 B=n_4236 VSS=VSS VDD=VDD
Xg122020 OR2X1 $PINS Z=n_5080 A=n_4233 B=n_4698 VSS=VSS VDD=VDD
Xg122021 OR2X1 $PINS Z=n_5079 A=n_4222 B=n_4681 VSS=VSS VDD=VDD
Xg122022 NAND2X1 $PINS Z=n_5078 A=n_4678 B=n_4130 VSS=VSS VDD=VDD
Xg122023 NAND2X1 $PINS Z=n_5077 A=n_4837 B=n_4543 VSS=VSS VDD=VDD
Xg122024 NOR2X1 $PINS Z=n_5076 A=n_4233 B=n_4672 VSS=VSS VDD=VDD
Xg122025 OR2X1 $PINS Z=n_5075 A=n_4595 B=n_4644 VSS=VSS VDD=VDD
Xg122026 NOR2X1 $PINS Z=n_5074 A=n_4855 B=n_4842 VSS=VSS VDD=VDD
Xg122027 NAND2X1 $PINS Z=n_5073 A=n_4839 B=n_4280 VSS=VSS VDD=VDD
Xg122028 NAND3X1 $PINS Z=n_5072 A=n_4347 B=n_4396 C=n_4283 VSS=VSS VDD=VDD
Xg122029 NAND2X1 $PINS Z=n_5071 A=n_4684 B=n_4256 VSS=VSS VDD=VDD
Xg122030 OR2X1 $PINS Z=n_5064 A=n_4608 B=n_4761 VSS=VSS VDD=VDD
Xg122031 OR2X1 $PINS Z=n_5063 A=n_4539 B=n_4697 VSS=VSS VDD=VDD
Xg122032 OR2X1 $PINS Z=n_5062 A=n_4326 B=n_4794 VSS=VSS VDD=VDD
Xg122033 NAND2X1 $PINS Z=n_5060 A=n_4842 B=n_4421 VSS=VSS VDD=VDD
Xg122034 NAND2X1 $PINS Z=n_5059 A=n_4753 B=n_4307 VSS=VSS VDD=VDD
Xg122035 NAND2X1 $PINS Z=n_5056 A=n_4844 B=n_4548 VSS=VSS VDD=VDD
Xg122036 AND2X1 $PINS Z=n_5055 A=n_4577 B=n_4588 VSS=VSS VDD=VDD
Xg122037 NAND3X1 $PINS Z=n_5054 A=n_4346 B=n_4274 C=n_4287 VSS=VSS VDD=VDD
Xg122038 OR2X1 $PINS Z=n_5046 A=n_4319 B=n_4801 VSS=VSS VDD=VDD
Xg122039 NOR2X1 $PINS Z=n_5045 A=n_4332 B=n_4684 VSS=VSS VDD=VDD
Xg122040 NAND2X1 $PINS Z=n_5044 A=n_4821 B=n_4255 VSS=VSS VDD=VDD
Xg122041 NOR2X1 $PINS Z=n_5040 A=n_4648 B=n_4781 VSS=VSS VDD=VDD
Xg122042 AND2X1 $PINS Z=n_5035 A=n_4810 B=n_4689 VSS=VSS VDD=VDD
Xg122043 NAND2X1 $PINS Z=n_5032 A=n_4688 B=n_4235 VSS=VSS VDD=VDD
Xg122044 NAND3X1 $PINS Z=n_5031 A=n_4408 B=n_4148 C=n_4146 VSS=VSS VDD=VDD
Xg122045 NAND2X1 $PINS Z=n_5030 A=n_4669 B=n_4528 VSS=VSS VDD=VDD
Xg122046 OR2X1 $PINS Z=n_5027 A=n_4069 B=n_4833 VSS=VSS VDD=VDD
Xg122047 NAND2X1 $PINS Z=n_5025 A=n_4854 B=n_4091 VSS=VSS VDD=VDD
Xg122048 OR2X1 $PINS Z=n_5023 A=n_4397 B=n_4655 VSS=VSS VDD=VDD
Xg122049 AND2X1 $PINS Z=n_5022 A=n_4845 B=n_4125 VSS=VSS VDD=VDD
Xg122050 NOR2X1 $PINS Z=n_5017 A=n_4451 B=n_4732 VSS=VSS VDD=VDD
Xg122051 NAND2X1 $PINS Z=n_5015 A=n_4836 B=n_4074 VSS=VSS VDD=VDD
Xg122052 NAND2X1 $PINS Z=n_5014 A=n_4857 B=n_4329 VSS=VSS VDD=VDD
Xg122053 AND2X1 $PINS Z=n_5012 A=n_4668 B=n_4407 VSS=VSS VDD=VDD
Xg122054 NOR2X1 $PINS Z=n_5005 A=n_4090 B=n_4847 VSS=VSS VDD=VDD
Xg122055 NAND2X1 $PINS Z=n_5003 A=n_4856 B=n_4686 VSS=VSS VDD=VDD
Xg122056 NAND3X1 $PINS Z=n_5002 A=n_4383 B=n_4234 C=n_4131 VSS=VSS VDD=VDD
Xg122057 NOR2X1 $PINS Z=n_4998 A=n_4504 B=n_4621 VSS=VSS VDD=VDD
Xg122058 NAND2X1 $PINS Z=n_4997 A=n_4693 B=n_4780 VSS=VSS VDD=VDD
Xg122059 NAND2X1 $PINS Z=n_4994 A=n_4832 B=n_4724 VSS=VSS VDD=VDD
Xg122060 NAND2X1 $PINS Z=n_4993 A=n_4666 B=n_4075 VSS=VSS VDD=VDD
Xg122061 NAND2X1 $PINS Z=n_4992 A=n_4670 B=n_4061 VSS=VSS VDD=VDD
Xg122062 NOR2X1 $PINS Z=n_4991 A=n_4195 B=n_4668 VSS=VSS VDD=VDD
Xg122063 NOR2X1 $PINS Z=n_4987 A=n_4218 B=n_4692 VSS=VSS VDD=VDD
Xg122064 NAND2X1 $PINS Z=n_4986 A=n_4855 B=n_4319 VSS=VSS VDD=VDD
Xg122065 NAND2X1 $PINS Z=n_4985 A=n_4718 B=n_4335 VSS=VSS VDD=VDD
Xg122066 NAND2X1 $PINS Z=n_4982 A=n_4839 B=n_4345 VSS=VSS VDD=VDD
Xg122067 OR2X1 $PINS Z=n_4981 A=n_4225 B=n_4672 VSS=VSS VDD=VDD
Xg122068 OR2X1 $PINS Z=n_4980 A=n_4184 B=n_4660 VSS=VSS VDD=VDD
Xg122069 NAND2X1 $PINS Z=n_4979 A=n_4711 B=n_4446 VSS=VSS VDD=VDD
Xg122070 NAND3X1 $PINS Z=n_4978 A=n_4523 B=n_4318 C=n_4163 VSS=VSS VDD=VDD
Xg122071 NAND2X1 $PINS Z=n_4976 A=n_4786 B=n_4481 VSS=VSS VDD=VDD
Xg122072 OR2X1 $PINS Z=n_4975 A=n_4314 B=n_4683 VSS=VSS VDD=VDD
Xg122073 NOR2X1 $PINS Z=n_4972 A=n_4336 B=n_4626 VSS=VSS VDD=VDD
Xg122074 OR2X1 $PINS Z=n_4971 A=n_4246 B=n_4811 VSS=VSS VDD=VDD
Xg122075 AND2X1 $PINS Z=n_5134 A=n_4801 B=n_4083 VSS=VSS VDD=VDD
Xg122076 NAND2X1 $PINS Z=n_5131 A=n_4801 B=n_4086 VSS=VSS VDD=VDD
Xg122077 NOR2X1 $PINS Z=n_5129 A=n_4140 B=n_4711 VSS=VSS VDD=VDD
Xg122078 NAND3X1 $PINS Z=n_5128 A=n_4408 B=n_4209 C=n_4147 VSS=VSS VDD=VDD
Xg122079 OR2X1 $PINS Z=n_5124 A=n_4320 B=n_4833 VSS=VSS VDD=VDD
Xg122080 NAND2X1 $PINS Z=n_5123 A=n_4810 B=n_4149 VSS=VSS VDD=VDD
Xg122081 NOR2X1 $PINS Z=n_5121 A=n_4744 B=n_4677 VSS=VSS VDD=VDD
Xg122082 NAND3X1 $PINS Z=n_5120 A=n_4490 B=n_4079 C=n_4030 VSS=VSS VDD=VDD
Xg122083 NAND2X1 $PINS Z=n_5118 A=n_4794 B=n_4083 VSS=VSS VDD=VDD
Xg122084 NOR2X1 $PINS Z=n_5113 A=n_4031 B=n_4844 VSS=VSS VDD=VDD
Xg122085 AND2X1 $PINS Z=n_5106 A=n_4796 B=n_4402 VSS=VSS VDD=VDD
Xg122086 NOR2X1 $PINS Z=n_5099 A=n_4402 B=n_4796 VSS=VSS VDD=VDD
Xg122087 NAND2X1 $PINS Z=n_5098 A=n_4807 B=n_4811 VSS=VSS VDD=VDD
Xg122088 INVX2 $PINS Z=n_4970 A=n_4944 VSS=VSS VDD=VDD
Xg122089 INVX2 $PINS Z=n_4967 A=n_4966 VSS=VSS VDD=VDD
Xg122090 INVX2 $PINS Z=n_4955 A=n_4956 VSS=VSS VDD=VDD
Xg122091 INVX2 $PINS Z=n_4953 A=n_4954 VSS=VSS VDD=VDD
Xg122092 OR2X1 $PINS Z=n_4952 A=n_4484 B=n_4771 VSS=VSS VDD=VDD
Xg122093 NOR2X1 $PINS Z=n_4950 A=n_4174 B=n_4802 VSS=VSS VDD=VDD
Xg122094 NAND2X1 $PINS Z=n_4949 A=n_4677 B=n_4184 VSS=VSS VDD=VDD
Xg122095 AND2X1 $PINS Z=n_4948 A=n_4677 B=n_4191 VSS=VSS VDD=VDD
Xg122096 NAND2X1 $PINS Z=n_4947 A=n_4796 B=n_4401 VSS=VSS VDD=VDD
Xg122097 NAND2X1 $PINS Z=n_4946 A=n_4708 B=n_4144 VSS=VSS VDD=VDD
Xg122098 NAND2X1 $PINS Z=n_4945 A=n_4707 B=n_4647 VSS=VSS VDD=VDD
Xg122099 MUX2X1 $PINS Z=n_4944 A=n_4064 B=n_4548 S=n_4079 VSS=VSS VDD=VDD
Xg122100 NAND2X1 $PINS Z=n_4943 A=n_4774 B=n_4145 VSS=VSS VDD=VDD
Xg122101 OR2X1 $PINS Z=n_4942 A=n_4095 B=n_4663 VSS=VSS VDD=VDD
Xg122102 NAND2X1 $PINS Z=n_4941 A=n_4592 B=n_4348 VSS=VSS VDD=VDD
Xg122103 NAND2X1 $PINS Z=n_4940 A=n_4640 B=n_4624 VSS=VSS VDD=VDD
Xg122104 OR2X1 $PINS Z=n_4939 A=n_4072 B=n_4686 VSS=VSS VDD=VDD
Xg122105 OR2X1 $PINS Z=n_4938 A=n_4310 B=n_4683 VSS=VSS VDD=VDD
Xg122106 NAND3X1 $PINS Z=n_4935 A=n_4488 B=n_4314 C=n_4091 VSS=VSS VDD=VDD
Xg122107 NOR2X1 $PINS Z=n_4934 A=n_4668 B=n_4840 VSS=VSS VDD=VDD
Xg122108 NAND3X1 $PINS Z=n_4933 A=n_4400 B=n_4281 C=n_4279 VSS=VSS VDD=VDD
Xg122109 NAND2X1 $PINS Z=n_4932 A=n_4668 B=n_4174 VSS=VSS VDD=VDD
Xg122110 MUX2X1 $PINS Z=n_4930 A=n_4518 B=n_4509 S=n_4303 VSS=VSS VDD=VDD
Xg122111 NAND3X1 $PINS Z=n_4926 A=n_4402 B=n_4404 C=n_4174 VSS=VSS VDD=VDD
Xg122112 NAND3X1 $PINS Z=n_4916 A=n_4298 B=n_4351 C=n_4032 VSS=VSS VDD=VDD
Xg122113 NAND3X1 $PINS Z=n_4915 A=n_4517 B=n_4142 C=n_4095 VSS=VSS VDD=VDD
Xg122114 NAND2X1 $PINS Z=n_4914 A=n_4622 B=n_4329 VSS=VSS VDD=VDD
Xg122115 NAND3X1 $PINS Z=n_4913 A=n_4532 B=n_4399 C=n_4141 VSS=VSS VDD=VDD
Xg122116 MUX2X1 $PINS Z=n_4912 A=n_4519 B=n_4482 S=n_4145 VSS=VSS VDD=VDD
Xg122117 NOR2X1 $PINS Z=n_4911 A=n_4077 B=n_4805 VSS=VSS VDD=VDD
Xg122118 NAND2X1 $PINS Z=n_4910 A=n_4796 B=n_4078 VSS=VSS VDD=VDD
Xg122119 NAND3X1 $PINS Z=n_4907 A=n_4511 B=n_4795 C=n_4098 VSS=VSS VDD=VDD
Xg122120 AND2X1 $PINS Z=n_4906 A=n_4509 B=n_4795 VSS=VSS VDD=VDD
Xg122121 NOR2X1 $PINS Z=n_4905 A=n_4303 B=n_4817 VSS=VSS VDD=VDD
Xg122122 NOR2X1 $PINS Z=n_4904 A=n_4338 B=n_4601 VSS=VSS VDD=VDD
Xg122123 NAND2X1 $PINS Z=n_4903 A=n_4697 B=n_4579 VSS=VSS VDD=VDD
Xg122124 NOR2X1 $PINS Z=n_4902 A=n_4504 B=n_4734 VSS=VSS VDD=VDD
Xg122125 NAND3X1 $PINS Z=n_4901 A=n_4438 B=n_4171 C=n_4092 VSS=VSS VDD=VDD
Xg122126 AND2X1 $PINS Z=n_4900 A=n_4800 B=n_4492 VSS=VSS VDD=VDD
Xg122127 NAND2X1 $PINS Z=n_4899 A=n_6074 B=n_4490 VSS=VSS VDD=VDD
Xg122128 OR2X1 $PINS Z=n_4898 A=n_4278 B=n_4705 VSS=VSS VDD=VDD
Xg122129 OR2X1 $PINS Z=n_4897 A=n_4135 B=n_4830 VSS=VSS VDD=VDD
Xg122130 OR2X1 $PINS Z=n_4896 A=n_4779 B=n_4794 VSS=VSS VDD=VDD
Xg122131 NAND2X1 $PINS Z=n_4895 A=n_4845 B=n_4182 VSS=VSS VDD=VDD
Xg122132 NAND2X1 $PINS Z=n_4894 A=n_4578 B=n_4357 VSS=VSS VDD=VDD
Xg122133 NOR2X1 $PINS Z=n_4893 A=n_4062 B=n_4740 VSS=VSS VDD=VDD
Xg122134 NOR2X1 $PINS Z=n_4892 A=n_4816 B=n_4511 VSS=VSS VDD=VDD
Xg122135 NAND3X1 $PINS Z=n_4891 A=n_4523 B=n_4315 C=n_4164 VSS=VSS VDD=VDD
Xg122136 MUX2X1 $PINS Z=n_4890 A=n_4166 B=n_4181 S=n_4430 VSS=VSS VDD=VDD
Xg122137 NAND2X1 $PINS Z=n_4888 A=n_4509 B=n_4816 VSS=VSS VDD=VDD
Xg122138 NAND3X1 $PINS Z=n_4887 A=n_4428 B=n_4235 C=n_4130 VSS=VSS VDD=VDD
Xg122139 NOR2X1 $PINS Z=n_4886 A=n_4681 B=n_4800 VSS=VSS VDD=VDD
Xg122140 NAND2X1 $PINS Z=n_4885 A=n_4571 B=n_4618 VSS=VSS VDD=VDD
Xg122141 NAND2X1 $PINS Z=n_4883 A=n_4678 B=n_4358 VSS=VSS VDD=VDD
Xg122142 MUX2X1 $PINS Z=n_4882 A=n_4485 B=n_4551 S=n_4030 VSS=VSS VDD=VDD
Xg122143 NAND3X1 $PINS Z=n_4881 A=n_4249 B=n_4409 C=n_4212 VSS=VSS VDD=VDD
Xg122144 MUX2X1 $PINS Z=n_4880 A=n_4497 B=n_4518 S=n_3982 VSS=VSS VDD=VDD
Xg122145 NAND3X1 $PINS Z=n_4878 A=n_4533 B=n_4311 C=n_4031 VSS=VSS VDD=VDD
Xg122146 NAND3X1 $PINS Z=n_4877 A=n_4387 B=n_4371 C=n_4295 VSS=VSS VDD=VDD
Xg122147 NAND3X1 $PINS Z=n_4876 A=n_4431 B=n_4033 C=n_3981 VSS=VSS VDD=VDD
Xg122148 NAND3X1 $PINS Z=n_4875 A=n_4506 B=n_4310 C=n_4178 VSS=VSS VDD=VDD
Xg122149 NAND3X1 $PINS Z=n_4869 A=n_4796 B=n_4195 C=n_4197 VSS=VSS VDD=VDD
Xg122150 NAND3X1 $PINS Z=n_4868 A=n_4532 B=n_4255 C=n_4192 VSS=VSS VDD=VDD
Xg122151 NAND3X1 $PINS Z=n_4867 A=n_4414 B=n_4521 C=n_4520 VSS=VSS VDD=VDD
Xg122152 NAND3X1 $PINS Z=n_4866 A=n_4392 B=n_4459 C=n_4162 VSS=VSS VDD=VDD
Xg122153 NAND3X1 $PINS Z=n_4865 A=n_4415 B=n_4408 C=n_4266 VSS=VSS VDD=VDD
Xg122154 NAND3X1 $PINS Z=n_4864 A=n_4533 B=n_4153 C=n_4079 VSS=VSS VDD=VDD
Xg122155 NAND3X1 $PINS Z=n_4863 A=n_4394 B=n_4159 C=n_4062 VSS=VSS VDD=VDD
Xg122156 NAND3X1 $PINS Z=n_4862 A=n_4811 B=n_4535 C=n_4266 VSS=VSS VDD=VDD
Xg122157 NAND3X1 $PINS Z=n_4861 A=n_4521 B=n_4502 C=n_4144 VSS=VSS VDD=VDD
Xg122158 NAND3X1 $PINS Z=n_4860 A=n_4532 B=n_4191 C=n_4142 VSS=VSS VDD=VDD
Xg122159 MUX2X1 $PINS Z=n_4858 A=n_4495 B=n_4534 S=n_4314 VSS=VSS VDD=VDD
Xg122160 XOR2X1 $PINS Z=n_4966 A=n_4060 B=n_4409 VSS=VSS VDD=VDD
Xg122161 AND2X1 $PINS Z=n_4963 A=n_4794 B=n_4098 VSS=VSS VDD=VDD
Xg122162 NAND3X1 $PINS Z=n_4962 A=n_4517 B=n_4179 C=n_4143 VSS=VSS VDD=VDD
Xg122163 XOR2X1 $PINS Z=n_4961 A=n_4077 B=n_4407 VSS=VSS VDD=VDD
Xg122164 NAND2X1 $PINS Z=n_4960 A=n_4796 B=n_4175 VSS=VSS VDD=VDD
Xg122165 OR2X1 $PINS Z=n_4959 A=n_4837 B=n_4831 VSS=VSS VDD=VDD
Xg122166 XOR2X1 $PINS Z=n_4958 A=n_4135 B=n_4401 VSS=VSS VDD=VDD
Xg122167 NAND3X1 $PINS Z=n_4957 A=n_4490 B=n_4081 C=n_4031 VSS=VSS VDD=VDD
Xg122168 NAND2X1 $PINS Z=n_4956 A=n_4817 B=n_4812 VSS=VSS VDD=VDD
Xg122169 XOR2X1 $PINS Z=n_4954 A=n_4075 B=n_4401 VSS=VSS VDD=VDD
Xg122170 INVX2 $PINS Z=n_4857 A=n_4856 VSS=VSS VDD=VDD
Xg122171 INVX2 $PINS Z=n_4854 A=n_4849 VSS=VSS VDD=VDD
Xg122172 INVX2 $PINS Z=n_4835 A=n_4834 VSS=VSS VDD=VDD
Xg122173 INVX2 $PINS Z=n_4821 A=n_4824 VSS=VSS VDD=VDD
Xg122174 INVX2 $PINS Z=n_4812 A=n_4816 VSS=VSS VDD=VDD
Xg122175 INVX2 $PINS Z=n_4810 A=n_4807 VSS=VSS VDD=VDD
Xg122176 INVX2 $PINS Z=n_4802 A=n_4805 VSS=VSS VDD=VDD
Xg122177 INVX2 $PINS Z=n_4799 A=n_4800 VSS=VSS VDD=VDD
Xg122178 INVX2 $PINS Z=n_4794 A=n_4795 VSS=VSS VDD=VDD
Xg122179 NAND3X1 $PINS Z=n_4790 A=n_4298 B=n_4172 C=n_4151 VSS=VSS VDD=VDD
Xg122180 NAND2X1 $PINS Z=n_4787 A=n_4377 B=n_4360 VSS=VSS VDD=VDD
Xg122181 NAND2X1 $PINS Z=n_4786 A=n_4409 B=n_4270 VSS=VSS VDD=VDD
Xg122182 NOR2X1 $PINS Z=n_4784 A=n_4402 B=n_4436 VSS=VSS VDD=VDD
Xg122183 NAND2X1 $PINS Z=n_4783 A=n_4518 B=n_4155 VSS=VSS VDD=VDD
Xg122184 AND2X1 $PINS Z=n_4781 A=n_4495 B=n_4130 VSS=VSS VDD=VDD
Xg122185 NAND2X1 $PINS Z=n_4780 A=n_4488 B=n_4131 VSS=VSS VDD=VDD
Xg122186 NOR2X1 $PINS Z=n_4779 A=n_4086 B=n_4411 VSS=VSS VDD=VDD
Xg122187 NAND2X1 $PINS Z=n_4778 A=n_4484 B=n_4218 VSS=VSS VDD=VDD
Xg122188 NAND2X1 $PINS Z=n_4776 A=n_4401 B=n_4075 VSS=VSS VDD=VDD
Xg122189 OR2X1 $PINS Z=n_4774 A=n_4221 B=n_4502 VSS=VSS VDD=VDD
Xg122190 NAND2X1 $PINS Z=n_4773 A=n_4423 B=n_4034 VSS=VSS VDD=VDD
Xg122191 AND2X1 $PINS Z=n_4771 A=n_4398 B=n_4218 VSS=VSS VDD=VDD
Xg122192 AND2X1 $PINS Z=n_4770 A=n_4497 B=n_3982 VSS=VSS VDD=VDD
Xg122193 OR2X1 $PINS Z=n_4769 A=n_3982 B=n_4497 VSS=VSS VDD=VDD
Xg122194 NAND2X1 $PINS Z=n_4768 A=n_4521 B=n_4540 VSS=VSS VDD=VDD
Xg122195 NAND2X1 $PINS Z=n_4767 A=n_4518 B=n_4412 VSS=VSS VDD=VDD
Xg122196 NAND3X1 $PINS Z=n_4766 A=n_4294 B=n_4300 C=n_4102 VSS=VSS VDD=VDD
Xg122197 NAND3X1 $PINS Z=n_4764 A=n_4299 B=n_4261 C=n_4171 VSS=VSS VDD=VDD
Xg122198 NAND2X1 $PINS Z=n_4763 A=n_4502 B=n_4221 VSS=VSS VDD=VDD
Xg122199 NAND2X1 $PINS Z=n_4762 A=n_4532 B=n_4104 VSS=VSS VDD=VDD
Xg122200 NOR2X1 $PINS Z=n_4761 A=n_4034 B=n_4493 VSS=VSS VDD=VDD
Xg122201 NAND2X1 $PINS Z=n_4757 A=n_4507 B=n_4034 VSS=VSS VDD=VDD
Xg122202 NAND2X1 $PINS Z=n_4756 A=n_4492 B=n_4222 VSS=VSS VDD=VDD
Xg122203 NAND2X1 $PINS Z=n_4755 A=n_4556 B=n_4036 VSS=VSS VDD=VDD
Xg122204 NAND2X1 $PINS Z=n_4753 A=n_4491 B=n_4551 VSS=VSS VDD=VDD
Xg122205 OR2X1 $PINS Z=n_4752 A=n_4557 B=n_4431 VSS=VSS VDD=VDD
Xg122206 NOR2X1 $PINS Z=n_4751 A=n_4402 B=n_4433 VSS=VSS VDD=VDD
Xg122207 NAND2X1 $PINS Z=n_4750 A=n_4533 B=n_4559 VSS=VSS VDD=VDD
Xg122208 AND2X1 $PINS Z=n_4744 A=n_4517 B=n_4140 VSS=VSS VDD=VDD
Xg122209 OR2X1 $PINS Z=n_4743 A=n_4533 B=n_4490 VSS=VSS VDD=VDD
Xg122210 NAND3X1 $PINS Z=n_4740 A=n_4487 B=n_4262 C=n_4035 VSS=VSS VDD=VDD
Xg122211 NAND2X1 $PINS Z=n_4739 A=n_4364 B=n_4207 VSS=VSS VDD=VDD
Xg122213 NAND2X1 $PINS Z=n_4736 A=n_4409 B=n_4061 VSS=VSS VDD=VDD
Xg122214 NOR2X1 $PINS Z=n_4735 A=n_4165 B=n_4430 VSS=VSS VDD=VDD
Xg122215 NOR2X1 $PINS Z=n_4734 A=n_4473 B=n_4363 VSS=VSS VDD=VDD
Xg122216 OR2X1 $PINS Z=n_4733 A=n_4312 B=n_4551 VSS=VSS VDD=VDD
Xg122217 NOR2X1 $PINS Z=n_4732 A=n_4159 B=n_4522 VSS=VSS VDD=VDD
Xg122218 NAND3X1 $PINS Z=n_4731 A=n_4517 B=n_4333 C=n_4184 VSS=VSS VDD=VDD
Xg122219 NAND3X1 $PINS Z=n_4726 A=n_4514 B=n_4333 C=n_4191 VSS=VSS VDD=VDD
Xg122220 NOR2X1 $PINS Z=n_4725 A=n_4235 B=n_4439 VSS=VSS VDD=VDD
Xg122221 OR2X1 $PINS Z=n_4724 A=n_4209 B=n_4528 VSS=VSS VDD=VDD
Xg122222 OR2X1 $PINS Z=n_4723 A=n_4439 B=n_4489 VSS=VSS VDD=VDD
Xg122223 NAND2X1 $PINS Z=n_4722 A=n_4539 B=n_4466 VSS=VSS VDD=VDD
Xg122224 NAND2X1 $PINS Z=n_4718 A=n_4343 B=n_4369 VSS=VSS VDD=VDD
Xg122225 NAND2X1 $PINS Z=n_4716 A=n_4535 B=n_4257 VSS=VSS VDD=VDD
Xg122226 NOR2X1 $PINS Z=n_4715 A=n_4292 B=n_4432 VSS=VSS VDD=VDD
Xg122227 OR2X1 $PINS Z=n_4714 A=n_4164 B=n_4548 VSS=VSS VDD=VDD
Xg122228 OR2X1 $PINS Z=n_4713 A=n_4249 B=n_4442 VSS=VSS VDD=VDD
Xg122229 NAND2X1 $PINS Z=n_4856 A=n_4495 B=n_4091 VSS=VSS VDD=VDD
Xg122230 AND2X1 $PINS Z=n_4855 A=n_4511 B=n_4411 VSS=VSS VDD=VDD
Xg122231 NAND2X1 $PINS Z=n_4849 A=n_4534 B=n_4198 VSS=VSS VDD=VDD
Xg122232 NAND2X1 $PINS Z=n_4848 A=n_4535 B=n_4147 VSS=VSS VDD=VDD
Xg122233 NAND2X1 $PINS Z=n_4847 A=n_4488 B=n_4308 VSS=VSS VDD=VDD
Xg122234 AND2X1 $PINS Z=n_4845 A=n_4534 B=n_4321 VSS=VSS VDD=VDD
Xg122235 NAND2X1 $PINS Z=n_4844 A=n_4523 B=n_4081 VSS=VSS VDD=VDD
Xg122236 NOR2X1 $PINS Z=n_4842 A=n_4411 B=n_4496 VSS=VSS VDD=VDD
Xg122237 AND2X1 $PINS Z=n_4840 A=n_4422 B=n_4436 VSS=VSS VDD=VDD
Xg122238 NOR2X1 $PINS Z=n_4839 A=n_4460 B=n_4374 VSS=VSS VDD=VDD
Xg122239 NOR2X1 $PINS Z=n_4837 A=n_4139 B=n_4404 VSS=VSS VDD=VDD
Xg122240 NOR2X1 $PINS Z=n_4836 A=n_4404 B=n_4422 VSS=VSS VDD=VDD
Xg122241 NOR2X1 $PINS Z=n_4834 A=n_4074 B=n_4422 VSS=VSS VDD=VDD
Xg122242 OR2X1 $PINS Z=n_4712 A=n_3982 B=n_4496 VSS=VSS VDD=VDD
Xg122243 NAND2X1 $PINS Z=n_4833 A=n_4488 B=n_4122 VSS=VSS VDD=VDD
Xg122244 NAND2X1 $PINS Z=n_4832 A=n_4408 B=n_4061 VSS=VSS VDD=VDD
Xg122245 NOR2X1 $PINS Z=n_4831 A=n_4135 B=n_4407 VSS=VSS VDD=VDD
Xg122246 OR2X1 $PINS Z=n_4830 A=n_4197 B=n_4402 VSS=VSS VDD=VDD
Xg122247 NAND2X1 $PINS Z=n_4824 A=n_4517 B=n_4191 VSS=VSS VDD=VDD
Xg122248 NAND2X1 $PINS Z=n_4818 A=n_4407 B=n_4214 VSS=VSS VDD=VDD
Xg122249 NAND2X1 $PINS Z=n_4817 A=n_4411 B=n_3982 VSS=VSS VDD=VDD
Xg122250 NOR2X1 $PINS Z=n_4816 A=n_3982 B=n_4411 VSS=VSS VDD=VDD
Xg122251 NAND2X1 $PINS Z=n_4811 A=n_4408 B=n_4212 VSS=VSS VDD=VDD
Xg122252 NAND2X1 $PINS Z=n_4807 A=n_4409 B=n_4209 VSS=VSS VDD=VDD
Xg122253 NOR2X1 $PINS Z=n_4805 A=n_4135 B=n_4404 VSS=VSS VDD=VDD
Xg122254 NOR2X1 $PINS Z=n_4801 A=n_3982 B=n_4412 VSS=VSS VDD=VDD
Xg122255 NOR2X1 $PINS Z=n_4800 A=n_4540 B=n_4537 VSS=VSS VDD=VDD
Xg122256 NOR2X1 $PINS Z=n_4796 A=n_4139 B=n_4407 VSS=VSS VDD=VDD
Xg122257 NAND2X1 $PINS Z=n_4795 A=n_4412 B=n_3982 VSS=VSS VDD=VDD
Xg122258 INVX2 $PINS Z=n_4708 A=n_4707 VSS=VSS VDD=VDD
Xg122259 INVX2 $PINS Z=n_4704 A=n_4702 VSS=VSS VDD=VDD
Xg122260 INVX2 $PINS Z=n_4675 A=n_4676 VSS=VSS VDD=VDD
Xg122261 INVX2 $PINS Z=n_4669 A=n_4670 VSS=VSS VDD=VDD
Xg122262 INVX2 $PINS Z=n_4666 A=n_4668 VSS=VSS VDD=VDD
Xg122263 INVX2 $PINS Z=n_4660 A=n_4663 VSS=VSS VDD=VDD
Xg122264 NOR2X1 $PINS Z=n_4659 A=n_4471 B=n_4491 VSS=VSS VDD=VDD
Xg122265 NAND2X1 $PINS Z=n_4658 A=n_4402 B=n_4175 VSS=VSS VDD=VDD
Xg122266 NAND2X1 $PINS Z=n_4656 A=n_4484 B=n_4521 VSS=VSS VDD=VDD
Xg122267 NOR2X1 $PINS Z=n_4655 A=n_4315 B=n_4487 VSS=VSS VDD=VDD
Xg122268 NAND2X1 $PINS Z=n_4654 A=n_4494 B=n_4492 VSS=VSS VDD=VDD
Xg122269 NOR2X1 $PINS Z=n_4648 A=n_4329 B=n_4489 VSS=VSS VDD=VDD
Xg122270 NAND2X1 $PINS Z=n_4647 A=n_4493 B=n_4520 VSS=VSS VDD=VDD
Xg122271 NAND2X1 $PINS Z=n_4645 A=n_4544 B=n_4179 VSS=VSS VDD=VDD
Xg122272 AND2X1 $PINS Z=n_4644 A=n_4501 B=n_4482 VSS=VSS VDD=VDD
Xg122273 NAND2X1 $PINS Z=n_4640 A=n_4417 B=n_4147 VSS=VSS VDD=VDD
Xg122274 NAND2X1 $PINS Z=n_4639 A=n_4370 B=n_3981 VSS=VSS VDD=VDD
Xg122275 OR2X1 $PINS Z=n_4638 A=n_4145 B=n_4501 VSS=VSS VDD=VDD
Xg122276 MUX2X1 $PINS Z=n_4637 A=n_4247 B=n_4148 S=n_4061 VSS=VSS VDD=VDD
Xg122277 AND2X1 $PINS Z=n_4633 A=n_4495 B=n_4069 VSS=VSS VDD=VDD
Xg122278 MUX2X1 $PINS Z=n_4630 A=n_4193 B=n_4184 S=n_4228 VSS=VSS VDD=VDD
Xg122279 NAND3X1 $PINS Z=n_4629 A=n_4504 B=n_4201 C=n_4181 VSS=VSS VDD=VDD
Xg122280 NOR2X1 $PINS Z=n_4626 A=n_4447 B=n_4354 VSS=VSS VDD=VDD
Xg122281 OR2X1 $PINS Z=n_4624 A=n_4257 B=n_4524 VSS=VSS VDD=VDD
Xg122282 OR2X1 $PINS Z=n_4622 A=n_4194 B=n_4495 VSS=VSS VDD=VDD
Xg122283 NOR2X1 $PINS Z=n_4621 A=n_4182 B=n_4395 VSS=VSS VDD=VDD
Xg122284 NAND3X1 $PINS Z=n_4620 A=n_4495 B=n_4314 C=n_4177 VSS=VSS VDD=VDD
Xg122285 NAND2X1 $PINS Z=n_4619 A=n_4523 B=n_4164 VSS=VSS VDD=VDD
Xg122286 NAND2X1 $PINS Z=n_4618 A=n_4518 B=n_4326 VSS=VSS VDD=VDD
Xg122287 AND2X1 $PINS Z=n_4617 A=n_4511 B=n_4328 VSS=VSS VDD=VDD
Xg122288 NAND2X1 $PINS Z=n_4614 A=n_4487 B=n_4161 VSS=VSS VDD=VDD
Xg122289 OR2X1 $PINS Z=n_4610 A=n_4507 B=n_4501 VSS=VSS VDD=VDD
Xg122290 NOR2X1 $PINS Z=n_4608 A=n_4521 B=n_4482 VSS=VSS VDD=VDD
Xg122291 NAND3X1 $PINS Z=n_4607 A=n_4495 B=n_4321 C=n_4178 VSS=VSS VDD=VDD
Xg122292 NAND3X1 $PINS Z=n_4606 A=n_4258 B=n_4297 C=n_4335 VSS=VSS VDD=VDD
Xg122293 NAND2X1 $PINS Z=n_4605 A=n_4413 B=n_4520 VSS=VSS VDD=VDD
Xg122294 NAND3X1 $PINS Z=n_4604 A=n_4293 B=n_4171 C=n_4157 VSS=VSS VDD=VDD
Xg122295 NAND2X1 $PINS Z=n_4603 A=n_4500 B=n_4492 VSS=VSS VDD=VDD
Xg122296 NOR2X1 $PINS Z=n_4601 A=n_4173 B=n_4431 VSS=VSS VDD=VDD
Xg122297 NAND2X1 $PINS Z=n_4600 A=n_4490 B=n_4311 VSS=VSS VDD=VDD
Xg122298 NOR2X1 $PINS Z=n_4599 A=n_4482 B=n_4414 VSS=VSS VDD=VDD
Xg122299 AND2X1 $PINS Z=n_4595 A=n_4492 B=n_4245 VSS=VSS VDD=VDD
Xg122300 NAND2X1 $PINS Z=n_4592 A=n_4431 B=n_4171 VSS=VSS VDD=VDD
Xg122301 NAND3X1 $PINS Z=n_4591 A=n_4308 B=n_4235 C=n_4182 VSS=VSS VDD=VDD
Xg122302 NAND3X1 $PINS Z=n_4589 A=n_4256 B=n_4228 C=n_4094 VSS=VSS VDD=VDD
Xg122303 NAND3X1 $PINS Z=n_4588 A=n_4331 B=n_4168 C=n_4157 VSS=VSS VDD=VDD
Xg122304 NAND3X1 $PINS Z=n_4587 A=n_4297 B=n_4168 C=n_4157 VSS=VSS VDD=VDD
Xg122305 NAND2X1 $PINS Z=n_4583 A=n_4493 B=n_4414 VSS=VSS VDD=VDD
Xg122306 NAND2X1 $PINS Z=n_4582 A=n_4493 B=n_4482 VSS=VSS VDD=VDD
Xg122307 NAND3X1 $PINS Z=n_4581 A=n_4298 B=n_4168 C=n_4032 VSS=VSS VDD=VDD
Xg122308 NAND2X1 $PINS Z=n_4579 A=n_4502 B=n_4243 VSS=VSS VDD=VDD
Xg122309 NAND2X1 $PINS Z=n_4578 A=n_4487 B=n_4366 VSS=VSS VDD=VDD
Xg122310 NAND3X1 $PINS Z=n_4577 A=n_4293 B=n_4172 C=n_4093 VSS=VSS VDD=VDD
Xg122311 NAND3X1 $PINS Z=n_4576 A=n_4495 B=n_4329 C=n_4194 VSS=VSS VDD=VDD
Xg122312 NAND3X1 $PINS Z=n_4575 A=n_4212 B=n_4216 C=n_4061 VSS=VSS VDD=VDD
Xg122313 OR2X1 $PINS Z=n_4574 A=n_4511 B=n_4509 VSS=VSS VDD=VDD
Xg122314 NAND2X1 $PINS Z=n_4571 A=n_4420 B=n_4509 VSS=VSS VDD=VDD
Xg122315 NAND3X1 $PINS Z=n_4565 A=n_4485 B=n_4311 C=n_4161 VSS=VSS VDD=VDD
Xg122316 NAND2X1 $PINS Z=n_4711 A=n_4532 B=n_4095 VSS=VSS VDD=VDD
Xg122317 NAND2X1 $PINS Z=n_4562 A=n_4534 B=n_4314 VSS=VSS VDD=VDD
Xg122318 NAND3X1 $PINS Z=n_4710 A=n_4259 B=n_4331 C=n_4093 VSS=VSS VDD=VDD
Xg122319 NAND2X1 $PINS Z=n_4707 A=n_4501 B=n_4502 VSS=VSS VDD=VDD
Xg122320 NAND3X1 $PINS Z=n_4706 A=n_4255 B=n_4179 C=n_4066 VSS=VSS VDD=VDD
Xg122321 NOR2X1 $PINS Z=n_4705 A=n_4031 B=n_4485 VSS=VSS VDD=VDD
Xg122322 XOR2X1 $PINS Z=n_4702 A=n_4060 B=n_4217 VSS=VSS VDD=VDD
Xg122323 NAND3X1 $PINS Z=n_4699 A=n_4292 B=n_4030 C=n_4064 VSS=VSS VDD=VDD
Xg122324 NAND2X1 $PINS Z=n_4698 A=n_4413 B=n_4494 VSS=VSS VDD=VDD
Xg122325 NAND2X1 $PINS Z=n_4697 A=n_4501 B=n_4520 VSS=VSS VDD=VDD
Xg122326 NAND3X1 $PINS Z=n_4696 A=n_4227 B=n_4256 C=n_4184 VSS=VSS VDD=VDD
Xg122327 NAND2X1 $PINS Z=n_4693 A=n_4506 B=n_4321 VSS=VSS VDD=VDD
Xg122328 NAND2X1 $PINS Z=n_4692 A=n_4507 B=n_4502 VSS=VSS VDD=VDD
Xg122329 MUX2X1 $PINS Z=n_4689 A=n_4146 B=n_4252 S=n_4216 VSS=VSS VDD=VDD
Xg122330 MUX2X1 $PINS Z=n_4688 A=n_4310 B=n_4131 S=n_4158 VSS=VSS VDD=VDD
Xg122331 NAND2X1 $PINS Z=n_4686 A=n_4534 B=n_4194 VSS=VSS VDD=VDD
Xg122332 XOR2X1 $PINS Z=n_4685 A=n_4140 B=n_4228 VSS=VSS VDD=VDD
Xg122333 NOR2X1 $PINS Z=n_4684 A=n_4179 B=n_4474 VSS=VSS VDD=VDD
Xg122334 NAND2X1 $PINS Z=n_4683 A=n_4506 B=n_4194 VSS=VSS VDD=VDD
Xg122335 OR2X1 $PINS Z=n_4681 A=n_4492 B=n_4484 VSS=VSS VDD=VDD
Xg122336 NOR2X1 $PINS Z=n_4678 A=n_4166 B=n_4489 VSS=VSS VDD=VDD
Xg122337 NOR2X1 $PINS Z=n_4677 A=n_4065 B=n_4546 VSS=VSS VDD=VDD
Xg122338 XOR2X1 $PINS Z=n_4676 A=n_4098 B=n_4237 VSS=VSS VDD=VDD
Xg122339 XOR2X1 $PINS Z=n_4672 A=n_4034 B=n_4245 VSS=VSS VDD=VDD
Xg122340 XOR2X1 $PINS Z=n_4670 A=n_4147 B=n_4217 VSS=VSS VDD=VDD
Xg122341 NAND2X1 $PINS Z=n_4668 A=n_4402 B=n_4135 VSS=VSS VDD=VDD
Xg122342 XOR2X1 $PINS Z=n_4663 A=n_4143 B=n_4228 VSS=VSS VDD=VDD
Xg122344 INVX2 $PINS Z=n_4546 A=n_4544 VSS=VSS VDD=VDD
Xg122345 INVX2 $PINS Z=n_4541 A=n_4543 VSS=VSS VDD=VDD
Xg122346 INVX2 $PINS Z=n_4539 A=n_4537 VSS=VSS VDD=VDD
Xg122347 INVX2 $PINS Z=n_4524 A=n_4528 VSS=VSS VDD=VDD
Xg122348 INVX2 $PINS Z=n_4523 A=n_4522 VSS=VSS VDD=VDD
Xg122349 INVX2 $PINS Z=n_4519 A=n_4520 VSS=VSS VDD=VDD
Xg122350 INVX2 $PINS Z=n_4514 A=n_4517 VSS=VSS VDD=VDD
Xg122351 INVX2 $PINS Z=n_4504 A=n_4506 VSS=VSS VDD=VDD
Xg122352 INVX2 $PINS Z=n_4500 A=n_4501 VSS=VSS VDD=VDD
Xg122353 INVX2 $PINS Z=n_4496 A=n_4497 VSS=VSS VDD=VDD
Xg122354 INVX2 $PINS Z=n_4493 A=n_4494 VSS=VSS VDD=VDD
Xg122355 INVX2 $PINS Z=n_4490 A=n_4491 VSS=VSS VDD=VDD
Xg122356 INVX2 $PINS Z=n_4488 A=n_4489 VSS=VSS VDD=VDD
Xg122357 INVX2 $PINS Z=n_4485 A=n_4487 VSS=VSS VDD=VDD
Xg122358 INVX2 $PINS Z=n_4482 A=n_4484 VSS=VSS VDD=VDD
Xg122359 NAND2X1 $PINS Z=n_4481 A=n_4209 B=n_4266 VSS=VSS VDD=VDD
Xg122360 NAND2X1 $PINS Z=n_4480 A=n_4303 B=n_3982 VSS=VSS VDD=VDD
Xg122362 NAND2X1 $PINS Z=n_4476 A=n_4228 B=n_4104 VSS=VSS VDD=VDD
Xg122363 AND2X1 $PINS Z=n_4474 A=n_4227 B=n_4104 VSS=VSS VDD=VDD
Xg122364 AND2X1 $PINS Z=n_4473 A=n_4285 B=n_4072 VSS=VSS VDD=VDD
Xg122365 NAND2X1 $PINS Z=n_4472 A=n_4256 B=n_4179 VSS=VSS VDD=VDD
Xg122366 NOR2X1 $PINS Z=n_4471 A=n_4337 B=n_4290 VSS=VSS VDD=VDD
Xg122367 NAND2X1 $PINS Z=n_4468 A=n_4335 B=n_4170 VSS=VSS VDD=VDD
Xg122368 NOR2X1 $PINS Z=n_4467 A=n_4292 B=n_4330 VSS=VSS VDD=VDD
Xg122369 NAND2X1 $PINS Z=n_4466 A=n_4221 B=n_4233 VSS=VSS VDD=VDD
Xg122370 NOR2X1 $PINS Z=n_4464 A=n_4242 B=n_4163 VSS=VSS VDD=VDD
Xg122371 NAND2X1 $PINS Z=n_4463 A=n_4235 B=n_4178 VSS=VSS VDD=VDD
Xg122372 NOR2X1 $PINS Z=n_4461 A=n_4230 B=n_4221 VSS=VSS VDD=VDD
Xg122373 NOR2X1 $PINS Z=n_4460 A=n_4173 B=n_4336 VSS=VSS VDD=VDD
Xg122374 NAND2X1 $PINS Z=n_4459 A=n_4335 B=n_4205 VSS=VSS VDD=VDD
Xg122375 OR2X1 $PINS Z=n_4454 A=n_4170 B=n_4261 VSS=VSS VDD=VDD
Xg122376 NOR2X1 $PINS Z=n_4451 A=n_4241 B=n_4330 VSS=VSS VDD=VDD
Xg122377 NOR2X1 $PINS Z=n_4447 A=n_4173 B=n_4261 VSS=VSS VDD=VDD
Xg122378 NAND2X1 $PINS Z=n_4446 A=n_4228 B=n_4184 VSS=VSS VDD=VDD
Xg122379 NOR2X1 $PINS Z=n_4559 A=n_4031 B=n_4292 VSS=VSS VDD=VDD
Xg122380 NAND2X1 $PINS Z=n_4557 A=n_4331 B=n_3980 VSS=VSS VDD=VDD
Xg122381 NOR2X1 $PINS Z=n_4556 A=n_4242 B=n_4330 VSS=VSS VDD=VDD
Xg122382 NAND2X1 $PINS Z=n_4551 A=n_4242 B=n_4079 VSS=VSS VDD=VDD
Xg122383 OR2X1 $PINS Z=n_4548 A=n_4062 B=n_4242 VSS=VSS VDD=VDD
Xg122384 NOR2X1 $PINS Z=n_4544 A=n_4140 B=n_4228 VSS=VSS VDD=VDD
Xg122385 NOR2X1 $PINS Z=n_4543 A=n_4195 B=n_4215 VSS=VSS VDD=VDD
Xg122386 NOR2X1 $PINS Z=n_4540 A=n_4145 B=n_4221 VSS=VSS VDD=VDD
Xg122387 NOR2X1 $PINS Z=n_4537 A=n_4144 B=n_4218 VSS=VSS VDD=VDD
Xg122388 NOR2X1 $PINS Z=n_4535 A=n_4149 B=n_4217 VSS=VSS VDD=VDD
Xg122389 AND2X1 $PINS Z=n_4534 A=n_4234 B=n_4158 VSS=VSS VDD=VDD
Xg122390 NOR2X1 $PINS Z=n_4533 A=n_4064 B=n_4242 VSS=VSS VDD=VDD
Xg122391 NOR2X1 $PINS Z=n_4532 A=n_4066 B=n_4228 VSS=VSS VDD=VDD
Xg122392 NAND2X1 $PINS Z=n_4528 A=n_4216 B=n_4060 VSS=VSS VDD=VDD
Xg122393 NAND2X1 $PINS Z=n_4522 A=n_4242 B=n_4062 VSS=VSS VDD=VDD
Xg122394 NOR2X1 $PINS Z=n_4521 A=n_4245 B=n_4225 VSS=VSS VDD=VDD
Xg122395 NOR2X1 $PINS Z=n_4520 A=n_4034 B=n_4230 VSS=VSS VDD=VDD
Xg122396 NOR2X1 $PINS Z=n_4518 A=n_4086 B=n_4237 VSS=VSS VDD=VDD
Xg122397 NOR2X1 $PINS Z=n_4517 A=n_4066 B=n_4227 VSS=VSS VDD=VDD
Xg122398 NOR2X1 $PINS Z=n_4511 A=n_4083 B=n_4237 VSS=VSS VDD=VDD
Xg122399 NOR2X1 $PINS Z=n_4509 A=n_4086 B=n_4236 VSS=VSS VDD=VDD
Xg122400 NOR2X1 $PINS Z=n_4507 A=n_4243 B=n_4225 VSS=VSS VDD=VDD
Xg122401 NOR2X1 $PINS Z=n_4506 A=n_4158 B=n_4234 VSS=VSS VDD=VDD
Xg122402 AND2X1 $PINS Z=n_4502 A=n_4230 B=n_4034 VSS=VSS VDD=VDD
Xg122403 NOR2X1 $PINS Z=n_4501 A=n_4245 B=n_4222 VSS=VSS VDD=VDD
Xg122404 NOR2X1 $PINS Z=n_4497 A=n_4083 B=n_4236 VSS=VSS VDD=VDD
Xg122405 NOR2X1 $PINS Z=n_4495 A=n_4158 B=n_4235 VSS=VSS VDD=VDD
Xg122406 NOR2X1 $PINS Z=n_4494 A=n_4243 B=n_4222 VSS=VSS VDD=VDD
Xg122407 AND2X1 $PINS Z=n_4492 A=n_4233 B=n_4034 VSS=VSS VDD=VDD
Xg122408 NAND2X1 $PINS Z=n_4491 A=n_4242 B=n_4064 VSS=VSS VDD=VDD
Xg122409 NAND2X1 $PINS Z=n_4489 A=n_4235 B=n_4158 VSS=VSS VDD=VDD
Xg122410 NOR2X1 $PINS Z=n_4487 A=n_4079 B=n_4242 VSS=VSS VDD=VDD
Xg122411 NOR2X1 $PINS Z=n_4484 A=n_4034 B=n_4233 VSS=VSS VDD=VDD
Xg122412 INVX2 $PINS Z=n_4436 A=n_4433 VSS=VSS VDD=VDD
Xg122413 INVX2 $PINS Z=n_4430 A=n_4428 VSS=VSS VDD=VDD
Xg122414 INVX2 $PINS Z=n_4423 A=n_4425 VSS=VSS VDD=VDD
Xg122415 INVX2 $PINS Z=n_4420 A=n_4421 VSS=VSS VDD=VDD
Xg122416 INVX2 $PINS Z=n_4415 A=n_4417 VSS=VSS VDD=VDD
Xg122417 INVX2 $PINS Z=n_4413 A=n_4414 VSS=VSS VDD=VDD
Xg122418 INVX2 $PINS Z=n_4411 A=n_4412 VSS=VSS VDD=VDD
Xg122419 INVX2 $PINS Z=n_4408 A=n_4409 VSS=VSS VDD=VDD
Xg122420 INVX2 $PINS Z=n_4404 A=n_4407 VSS=VSS VDD=VDD
Xg122421 INVX2 $PINS Z=n_4401 A=n_4402 VSS=VSS VDD=VDD
Xg122422 NAND2X1 $PINS Z=n_4400 A=n_4300 B=n_3981 VSS=VSS VDD=VDD
Xg122423 OR2X1 $PINS Z=n_4399 A=n_4291 B=n_4179 VSS=VSS VDD=VDD
Xg122424 XOR2X1 $PINS Z=n_4398 A=n_4034 B=n_4145 VSS=VSS VDD=VDD
Xg122425 NOR2X1 $PINS Z=n_4397 A=n_4081 B=n_4312 VSS=VSS VDD=VDD
Xg122426 OR2X1 $PINS Z=n_4396 A=n_3980 B=n_4336 VSS=VSS VDD=VDD
Xg122427 NOR2X1 $PINS Z=n_4395 A=n_4091 B=n_4310 VSS=VSS VDD=VDD
Xg122428 XOR2X1 $PINS Z=n_4394 A=n_4079 B=n_4153 VSS=VSS VDD=VDD
Xg122429 NAND3X1 $PINS Z=n_4392 A=n_4170 B=n_4151 C=n_4157 VSS=VSS VDD=VDD
Xg122430 NAND3X1 $PINS Z=n_4391 A=n_4172 B=n_4033 C=n_4093 VSS=VSS VDD=VDD
Xg122431 NAND2X1 $PINS Z=n_4389 A=n_4247 B=n_4217 VSS=VSS VDD=VDD
Xg122432 OR2X1 $PINS Z=n_4387 A=n_4151 B=n_4259 VSS=VSS VDD=VDD
Xg122433 NAND2X1 $PINS Z=n_4383 A=n_4203 B=n_4166 VSS=VSS VDD=VDD
Xg122434 NAND2X1 $PINS Z=n_4379 A=n_4212 B=n_4257 VSS=VSS VDD=VDD
Xg122435 OR2X1 $PINS Z=n_4378 A=n_4062 B=n_4292 VSS=VSS VDD=VDD
Xg122436 NAND2X1 $PINS Z=n_4377 A=n_4320 B=n_4166 VSS=VSS VDD=VDD
Xg122437 AND2X1 $PINS Z=n_4374 A=n_4298 B=n_4171 VSS=VSS VDD=VDD
Xg122438 NAND2X1 $PINS Z=n_4371 A=n_4293 B=n_4168 VSS=VSS VDD=VDD
Xg122439 NAND2X1 $PINS Z=n_4370 A=n_4294 B=n_4167 VSS=VSS VDD=VDD
Xg122440 NAND2X1 $PINS Z=n_4369 A=n_4295 B=n_4168 VSS=VSS VDD=VDD
Xg122441 AND2X1 $PINS Z=n_4368 A=n_4278 B=n_4318 VSS=VSS VDD=VDD
Xg122442 NAND2X1 $PINS Z=n_4366 A=n_4262 B=n_4160 VSS=VSS VDD=VDD
Xg122443 NAND2X1 $PINS Z=n_4365 A=n_4306 B=n_4031 VSS=VSS VDD=VDD
Xg122444 OR2X1 $PINS Z=n_4364 A=n_4030 B=n_4292 VSS=VSS VDD=VDD
Xg122445 AND2X1 $PINS Z=n_4363 A=n_4314 B=n_4166 VSS=VSS VDD=VDD
Xg122446 OR2X1 $PINS Z=n_4360 A=n_4194 B=n_4329 VSS=VSS VDD=VDD
Xg122447 NAND2X1 $PINS Z=n_4358 A=n_4310 B=n_4320 VSS=VSS VDD=VDD
Xg122448 OR2X1 $PINS Z=n_4357 A=n_4163 B=n_4292 VSS=VSS VDD=VDD
Xg122449 OR2X1 $PINS Z=n_4355 A=n_4336 B=n_4259 VSS=VSS VDD=VDD
Xg122450 NOR2X1 $PINS Z=n_4354 A=n_3981 B=n_4295 VSS=VSS VDD=VDD
Xg122451 NAND2X1 $PINS Z=n_4353 A=n_4315 B=n_4312 VSS=VSS VDD=VDD
Xg122452 OR2X1 $PINS Z=n_4351 A=n_4204 B=n_4170 VSS=VSS VDD=VDD
Xg122453 NAND2X1 $PINS Z=n_4348 A=n_4298 B=n_3981 VSS=VSS VDD=VDD
Xg122454 NAND2X1 $PINS Z=n_4347 A=n_4299 B=n_4170 VSS=VSS VDD=VDD
Xg122455 NAND2X1 $PINS Z=n_4346 A=n_4297 B=n_3981 VSS=VSS VDD=VDD
Xg122456 NAND2X1 $PINS Z=n_4345 A=n_4300 B=n_4171 VSS=VSS VDD=VDD
Xg122457 NAND2X1 $PINS Z=n_4343 A=n_4293 B=n_3980 VSS=VSS VDD=VDD
Xg122458 AND2X1 $PINS Z=n_4338 A=n_4298 B=n_4170 VSS=VSS VDD=VDD
Xg122459 NAND2X1 $PINS Z=n_4442 A=n_4209 B=n_4061 VSS=VSS VDD=VDD
Xg122460 NOR2X1 $PINS Z=n_4441 A=n_4197 B=n_4215 VSS=VSS VDD=VDD
Xg122461 NAND3X1 $PINS Z=n_4439 A=n_4200 B=n_4130 C=n_4091 VSS=VSS VDD=VDD
Xg122462 NAND2X1 $PINS Z=n_4438 A=n_4295 B=n_4294 VSS=VSS VDD=VDD
Xg122463 NOR2X1 $PINS Z=n_4433 A=n_4077 B=n_4215 VSS=VSS VDD=VDD
Xg122464 NAND3X1 $PINS Z=n_4432 A=n_4163 B=n_4031 C=n_4064 VSS=VSS VDD=VDD
Xg122465 NOR2X1 $PINS Z=n_4431 A=n_4298 B=n_4300 VSS=VSS VDD=VDD
Xg122466 XOR2X1 $PINS Z=n_4428 A=n_4069 B=n_4158 VSS=VSS VDD=VDD
Xg122467 NAND2X1 $PINS Z=n_4425 A=n_4221 B=n_4144 VSS=VSS VDD=VDD
Xg122468 NAND2X1 $PINS Z=n_4422 A=n_4215 B=n_4077 VSS=VSS VDD=VDD
Xg122469 NOR2X1 $PINS Z=n_4421 A=n_4319 B=n_4302 VSS=VSS VDD=VDD
Xg122470 NAND2X1 $PINS Z=n_4417 A=n_4217 B=n_4148 VSS=VSS VDD=VDD
Xg122471 NAND2X1 $PINS Z=n_4414 A=n_4218 B=n_4145 VSS=VSS VDD=VDD
Xg122472 XOR2X1 $PINS Z=n_4412 A=csm_inst_right_reg[12] B=n_4128 VSS=VSS
+ VDD=VDD
Xg122473 XOR2X1 $PINS Z=n_4409 A=csm_inst_right_reg[22] B=n_4127 VSS=VSS
+ VDD=VDD
Xg122474 XOR2X1 $PINS Z=n_4407 A=csm_inst_right_reg[0] B=n_4126 VSS=VSS VDD=VDD
Xg122475 XOR2X1 $PINS Z=n_4402 A=csm_inst_right_reg[1] B=n_4129 VSS=VSS VDD=VDD
Xg122476 INVX2 $PINS Z=n_4333 A=n_4332 VSS=VSS VDD=VDD
Xg122478 INVX2 $PINS Z=n_4320 A=n_4321 VSS=VSS VDD=VDD
Xg122479 INVX2 $PINS Z=n_4315 A=n_4318 VSS=VSS VDD=VDD
Xg122480 INVX2 $PINS Z=n_4311 A=n_4312 VSS=VSS VDD=VDD
Xg122481 INVX2 $PINS Z=n_4308 A=n_4310 VSS=VSS VDD=VDD
Xg122482 INVX2 $PINS Z=n_4306 A=n_4307 VSS=VSS VDD=VDD
Xg122483 INVX2 $PINS Z=n_4302 A=n_4303 VSS=VSS VDD=VDD
Xg122484 INVX2 $PINS Z=n_4299 A=n_4300 VSS=VSS VDD=VDD
Xg122485 INVX2 $PINS Z=n_4295 A=n_4297 VSS=VSS VDD=VDD
Xg122486 INVX2 $PINS Z=n_4293 A=n_4294 VSS=VSS VDD=VDD
Xg122487 NOR2X1 $PINS Z=n_4291 A=n_4104 B=n_4142 VSS=VSS VDD=VDD
Xg122488 NOR2X1 $PINS Z=n_4290 A=n_4035 B=n_4163 VSS=VSS VDD=VDD
Xg122489 OR2X1 $PINS Z=n_4289 A=n_3982 B=n_4156 VSS=VSS VDD=VDD
Xg122490 NAND2X1 $PINS Z=n_4287 A=n_4150 B=n_4102 VSS=VSS VDD=VDD
Xg122491 NAND2X1 $PINS Z=n_4285 A=n_4166 B=n_4131 VSS=VSS VDD=VDD
Xg122492 OR2X1 $PINS Z=n_4283 A=n_4157 B=n_4173 VSS=VSS VDD=VDD
Xg122493 NAND2X1 $PINS Z=n_4281 A=n_4170 B=n_4092 VSS=VSS VDD=VDD
Xg122494 NAND2X1 $PINS Z=n_4280 A=n_4168 B=n_4093 VSS=VSS VDD=VDD
Xg122495 OR2X1 $PINS Z=n_4279 A=n_4103 B=n_4157 VSS=VSS VDD=VDD
Xg122496 NOR2X1 $PINS Z=n_4337 A=n_4154 B=n_4159 VSS=VSS VDD=VDD
Xg122497 NAND2X1 $PINS Z=n_4336 A=n_4157 B=n_4092 VSS=VSS VDD=VDD
Xg122498 NOR2X1 $PINS Z=n_4335 A=n_4092 B=n_4157 VSS=VSS VDD=VDD
Xg122499 NAND2X1 $PINS Z=n_4332 A=n_4141 B=n_4143 VSS=VSS VDD=VDD
Xg122500 NOR2X1 $PINS Z=n_4331 A=n_4033 B=n_4151 VSS=VSS VDD=VDD
Xg122501 NAND3X1 $PINS Z=n_4330 A=n_4079 B=n_4030 C=n_4062 VSS=VSS VDD=VDD
Xg122502 NOR2X1 $PINS Z=n_4329 A=n_4069 B=n_4131 VSS=VSS VDD=VDD
Xg122503 AND2X1 $PINS Z=n_4328 A=n_4155 B=n_4098 VSS=VSS VDD=VDD
Xg122504 NOR2X1 $PINS Z=n_4326 A=n_4098 B=n_4155 VSS=VSS VDD=VDD
Xg122505 NOR2X1 $PINS Z=n_4321 A=n_4072 B=n_4131 VSS=VSS VDD=VDD
Xg122506 NOR2X1 $PINS Z=n_4319 A=n_4098 B=n_4156 VSS=VSS VDD=VDD
Xg122507 NOR2X1 $PINS Z=n_4318 A=n_4035 B=n_4153 VSS=VSS VDD=VDD
Xg122508 NOR2X1 $PINS Z=n_4314 A=n_4072 B=n_4130 VSS=VSS VDD=VDD
Xg122509 NAND2X1 $PINS Z=n_4312 A=n_4153 B=n_4035 VSS=VSS VDD=VDD
Xg122510 NAND2X1 $PINS Z=n_4310 A=n_4131 B=n_4072 VSS=VSS VDD=VDD
Xg122511 NOR2X1 $PINS Z=n_4307 A=n_4036 B=n_4153 VSS=VSS VDD=VDD
Xg122512 NAND2X1 $PINS Z=n_4303 A=n_4156 B=n_4098 VSS=VSS VDD=VDD
Xg122513 NOR2X1 $PINS Z=n_4300 A=n_4093 B=n_4157 VSS=VSS VDD=VDD
Xg122514 AND2X1 $PINS Z=n_4298 A=n_4157 B=n_4093 VSS=VSS VDD=VDD
Xg122515 NOR2X1 $PINS Z=n_4297 A=n_4032 B=n_4151 VSS=VSS VDD=VDD
Xg122516 NAND2X1 $PINS Z=n_4294 A=n_4151 B=n_4032 VSS=VSS VDD=VDD
Xg122517 NAND2X1 $PINS Z=n_4292 A=n_4153 B=n_4036 VSS=VSS VDD=VDD
Xg122518 INVX2 $PINS Z=n_4276 A=n_4275 VSS=VSS VDD=VDD
Xg122519 INVX2 $PINS Z=n_4273 A=n_4271 VSS=VSS VDD=VDD
Xg122520 INVX2 $PINS Z=n_4270 A=n_4268 VSS=VSS VDD=VDD
Xg122521 INVX2 $PINS Z=n_4259 A=n_4258 VSS=VSS VDD=VDD
Xg122522 INVX2 $PINS Z=n_4249 A=n_4252 VSS=VSS VDD=VDD
Xg122523 INVX2 $PINS Z=n_4247 A=n_4246 VSS=VSS VDD=VDD
Xg122524 INVX2 $PINS Z=n_4243 A=n_4245 VSS=VSS VDD=VDD
Xg122525 INVX2 $PINS Z=n_4241 A=n_4242 VSS=VSS VDD=VDD
Xg122526 INVX2 $PINS Z=n_4236 A=n_4237 VSS=VSS VDD=VDD
Xg122527 INVX2 $PINS Z=n_4234 A=n_4235 VSS=VSS VDD=VDD
Xg122528 INVX2 $PINS Z=n_4230 A=n_4233 VSS=VSS VDD=VDD
Xg122529 INVX2 $PINS Z=n_4227 A=n_4228 VSS=VSS VDD=VDD
Xg122530 INVX2 $PINS Z=n_4222 A=n_4225 VSS=VSS VDD=VDD
Xg122531 INVX2 $PINS Z=n_4218 A=n_4221 VSS=VSS VDD=VDD
Xg122532 INVX2 $PINS Z=n_4216 A=n_4217 VSS=VSS VDD=VDD
Xg122533 INVX2 $PINS Z=n_4214 A=n_4215 VSS=VSS VDD=VDD
Xg122534 INVX2 $PINS Z=n_4209 A=n_4212 VSS=VSS VDD=VDD
Xg122535 NAND2X1 $PINS Z=n_4208 A=n_4153 B=n_4062 VSS=VSS VDD=VDD
Xg122536 NAND2X1 $PINS Z=n_4207 A=n_4159 B=n_4154 VSS=VSS VDD=VDD
Xg122537 NAND2X1 $PINS Z=n_4205 A=n_4151 B=n_3980 VSS=VSS VDD=VDD
Xg122538 NOR2X1 $PINS Z=n_4204 A=n_3981 B=n_4150 VSS=VSS VDD=VDD
Xg122539 NAND2X1 $PINS Z=n_4203 A=n_4178 B=n_4072 VSS=VSS VDD=VDD
Xg122540 OR2X1 $PINS Z=n_4201 A=n_4090 B=n_4158 VSS=VSS VDD=VDD
Xg122541 NOR2X1 $PINS Z=n_4278 A=n_4062 B=n_4163 VSS=VSS VDD=VDD
Xg122542 NOR2X1 $PINS Z=n_4275 A=n_4060 B=n_4147 VSS=VSS VDD=VDD
Xg122543 NAND2X1 $PINS Z=n_4274 A=n_4171 B=n_4151 VSS=VSS VDD=VDD
Xg122544 NAND2X1 $PINS Z=n_4271 A=n_4193 B=n_4142 VSS=VSS VDD=VDD
Xg122545 NAND2X1 $PINS Z=n_4268 A=n_4147 B=n_4061 VSS=VSS VDD=VDD
Xg122546 NOR2X1 $PINS Z=n_4266 A=n_4061 B=n_4147 VSS=VSS VDD=VDD
Xg122547 NAND2X1 $PINS Z=n_4262 A=n_4153 B=n_4030 VSS=VSS VDD=VDD
Xg122548 NOR2X1 $PINS Z=n_4261 A=n_4032 B=n_4150 VSS=VSS VDD=VDD
Xg122549 NOR2X1 $PINS Z=n_4258 A=n_4171 B=n_4168 VSS=VSS VDD=VDD
Xg122550 NOR2X1 $PINS Z=n_4257 A=n_4061 B=n_4146 VSS=VSS VDD=VDD
Xg122551 NOR2X1 $PINS Z=n_4256 A=n_4065 B=n_4143 VSS=VSS VDD=VDD
Xg122552 NOR2X1 $PINS Z=n_4255 A=n_4142 B=n_4141 VSS=VSS VDD=VDD
Xg122553 NOR2X1 $PINS Z=n_4252 A=n_4146 B=n_4148 VSS=VSS VDD=VDD
Xg122554 NAND2X1 $PINS Z=n_4246 A=n_4149 B=n_4146 VSS=VSS VDD=VDD
Xg122555 XOR2X1 $PINS Z=n_4245 A=csm_inst_right_reg[8] B=n_4109 VSS=VSS VDD=VDD
Xg122556 XOR2X1 $PINS Z=n_4242 A=csm_inst_right_reg[5] B=n_4119 VSS=VSS VDD=VDD
Xg122557 XOR2X1 $PINS Z=n_4237 A=csm_inst_right_reg[11] B=n_4117 VSS=VSS
+ VDD=VDD
Xg122558 XOR2X1 $PINS Z=n_4235 A=csm_inst_right_reg[28] B=n_4118 VSS=VSS
+ VDD=VDD
Xg122559 XOR2X1 $PINS Z=n_4233 A=csm_inst_right_reg[12] B=n_4111 VSS=VSS
+ VDD=VDD
Xg122560 XOR2X1 $PINS Z=n_4228 A=csm_inst_right_reg[17] B=n_4113 VSS=VSS
+ VDD=VDD
Xg122561 XOR2X1 $PINS Z=n_4225 A=csm_inst_right_reg[10] B=n_4110 VSS=VSS
+ VDD=VDD
Xg122562 XOR2X1 $PINS Z=n_4221 A=csm_inst_right_reg[11] B=n_4106 VSS=VSS
+ VDD=VDD
Xg122563 XOR2X1 $PINS Z=n_4217 A=csm_inst_right_reg[19] B=n_4115 VSS=VSS
+ VDD=VDD
Xg122564 XOR2X1 $PINS Z=n_4215 A=csm_inst_right_reg[4] B=n_4108 VSS=VSS VDD=VDD
Xg122565 XOR2X1 $PINS Z=n_4212 A=csm_inst_right_reg[20] B=n_4114 VSS=VSS
+ VDD=VDD
Xg122566 INVX2 $PINS Z=n_4200 A=n_4198 VSS=VSS VDD=VDD
Xg122567 INVX2 $PINS Z=n_4192 A=n_4193 VSS=VSS VDD=VDD
Xg122568 INVX2 $PINS Z=n_4191 A=n_4185 VSS=VSS VDD=VDD
Xg122569 INVX2 $PINS Z=n_4181 A=n_4182 VSS=VSS VDD=VDD
Xg122570 INVX2 $PINS Z=n_4177 A=n_4178 VSS=VSS VDD=VDD
Xg122571 INVX2 $PINS Z=n_4174 A=n_4175 VSS=VSS VDD=VDD
Xg122572 INVX2 $PINS Z=n_4172 A=n_4173 VSS=VSS VDD=VDD
Xg122573 INVX2 $PINS Z=n_4167 A=n_4168 VSS=VSS VDD=VDD
Xg122574 INVX2 $PINS Z=n_4165 A=n_4166 VSS=VSS VDD=VDD
Xg122575 INVX2 $PINS Z=n_4163 A=n_4164 VSS=VSS VDD=VDD
Xg122576 NAND2X1 $PINS Z=n_4162 A=n_4103 B=n_4093 VSS=VSS VDD=VDD
Xg122577 NOR2X1 $PINS Z=n_4198 A=n_4069 B=n_4122 VSS=VSS VDD=VDD
Xg122578 NAND2X1 $PINS Z=n_4197 A=n_4078 B=n_4074 VSS=VSS VDD=VDD
Xg122579 NAND2X1 $PINS Z=n_4195 A=n_4077 B=n_4075 VSS=VSS VDD=VDD
Xg122580 NOR2X1 $PINS Z=n_4194 A=n_4091 B=n_4122 VSS=VSS VDD=VDD
Xg122581 NOR2X1 $PINS Z=n_4193 A=n_4104 B=n_4094 VSS=VSS VDD=VDD
Xg122582 NAND2X1 $PINS Z=n_4185 A=n_4094 B=n_4104 VSS=VSS VDD=VDD
Xg122583 AND2X1 $PINS Z=n_4184 A=n_4095 B=n_4104 VSS=VSS VDD=VDD
Xg122584 NOR2X1 $PINS Z=n_4182 A=n_4090 B=n_4125 VSS=VSS VDD=VDD
Xg122585 NOR2X1 $PINS Z=n_4179 A=n_4104 B=n_4095 VSS=VSS VDD=VDD
Xg122586 NOR2X1 $PINS Z=n_4178 A=n_4090 B=n_4122 VSS=VSS VDD=VDD
Xg122587 NOR2X1 $PINS Z=n_4175 A=n_4074 B=n_4077 VSS=VSS VDD=VDD
Xg122588 NAND2X1 $PINS Z=n_4173 A=n_4103 B=n_3981 VSS=VSS VDD=VDD
Xg122589 NOR2X1 $PINS Z=n_4171 A=n_3981 B=n_4102 VSS=VSS VDD=VDD
Xg122590 NOR2X1 $PINS Z=n_4170 A=n_3981 B=n_4103 VSS=VSS VDD=VDD
Xg122591 NOR2X1 $PINS Z=n_4168 A=n_3980 B=n_4103 VSS=VSS VDD=VDD
Xg122592 NAND2X1 $PINS Z=n_4166 A=n_4122 B=n_4090 VSS=VSS VDD=VDD
Xg122593 NOR2X1 $PINS Z=n_4164 A=n_4030 B=n_4081 VSS=VSS VDD=VDD
Xg122594 INVX2 $PINS Z=n_4161 A=n_4160 VSS=VSS VDD=VDD
Xg122595 INVX2 $PINS Z=n_4155 A=n_4156 VSS=VSS VDD=VDD
Xg122596 INVX2 $PINS Z=n_4153 A=n_4154 VSS=VSS VDD=VDD
Xg122597 INVX2 $PINS Z=n_4150 A=n_4151 VSS=VSS VDD=VDD
Xg122598 INVX2 $PINS Z=n_4148 A=n_4149 VSS=VSS VDD=VDD
Xg122599 INVX2 $PINS Z=n_4146 A=n_4147 VSS=VSS VDD=VDD
Xg122600 INVX2 $PINS Z=n_4144 A=n_4145 VSS=VSS VDD=VDD
Xg122601 INVX2 $PINS Z=n_4142 A=n_4143 VSS=VSS VDD=VDD
Xg122602 INVX2 $PINS Z=n_4140 A=n_4141 VSS=VSS VDD=VDD
Xg122603 INVX2 $PINS Z=n_4135 A=n_4139 VSS=VSS VDD=VDD
Xg122604 INVX2 $PINS Z=n_4130 A=n_4131 VSS=VSS VDD=VDD
Xg122605 NAND3X1 $PINS Z=n_4129 A=n_4048 B=n_2476 C=n_3352 VSS=VSS VDD=VDD
Xg122606 NAND3X1 $PINS Z=n_4128 A=n_4121 B=n_1089 C=n_1090 VSS=VSS VDD=VDD
Xg122607 NAND3X1 $PINS Z=n_4127 A=n_4120 B=n_3389 C=n_1018 VSS=VSS VDD=VDD
Xg122608 NAND3X1 $PINS Z=n_4126 A=n_4049 B=n_1007 C=n_2726 VSS=VSS VDD=VDD
Xg122609 NAND2X1 $PINS Z=n_4160 A=n_4031 B=n_4062 VSS=VSS VDD=VDD
Xg122610 XOR2X1 $PINS Z=n_4159 A=n_4036 B=n_4031 VSS=VSS VDD=VDD
Xg122611 XOR2X1 $PINS Z=n_4158 A=csm_inst_right_reg[27] B=n_4045 VSS=VSS
+ VDD=VDD
Xg122612 XOR2X1 $PINS Z=n_4157 A=csm_inst_right_reg[25] B=n_4014 VSS=VSS
+ VDD=VDD
Xg122613 XOR2X1 $PINS Z=n_4156 A=csm_inst_right_reg[13] B=n_4019 VSS=VSS
+ VDD=VDD
Xg122614 XOR2X1 $PINS Z=n_4154 A=csm_inst_right_reg[8] B=n_4024 VSS=VSS VDD=VDD
Xg122615 XOR2X1 $PINS Z=n_4151 A=csm_inst_right_reg[28] B=n_4038 VSS=VSS
+ VDD=VDD
Xg122616 XOR2X1 $PINS Z=n_4149 A=csm_inst_right_reg[21] B=n_4018 VSS=VSS
+ VDD=VDD
Xg122617 XOR2X1 $PINS Z=n_4147 A=csm_inst_right_reg[24] B=n_4040 VSS=VSS
+ VDD=VDD
Xg122618 XOR2X1 $PINS Z=n_4145 A=csm_inst_right_reg[7] B=n_4042 VSS=VSS VDD=VDD
Xg122619 XOR2X1 $PINS Z=n_4143 A=csm_inst_right_reg[20] B=n_4021 VSS=VSS
+ VDD=VDD
Xg122620 XOR2X1 $PINS Z=n_4141 A=csm_inst_right_reg[15] B=n_4020 VSS=VSS
+ VDD=VDD
Xg122621 XOR2X1 $PINS Z=n_4139 A=csm_inst_right_reg[31] B=n_4016 VSS=VSS
+ VDD=VDD
Xg122622 XOR2X1 $PINS Z=n_4131 A=csm_inst_right_reg[29] B=n_4017 VSS=VSS
+ VDD=VDD
Xg122623 INVX2 $PINS Z=n_4122 A=n_4125 VSS=VSS VDD=VDD
Xg122624 NOR2X1 $PINS Z=n_4121 A=n_1609 B=n_4056 VSS=VSS VDD=VDD
Xg122625 NOR2X1 $PINS Z=n_4120 A=n_3130 B=n_4029 VSS=VSS VDD=VDD
Xg122626 NAND3X1 $PINS Z=n_4119 A=n_4026 B=n_923 C=n_1023 VSS=VSS VDD=VDD
Xg122627 NAND3X1 $PINS Z=n_4118 A=n_4051 B=n_1148 C=n_1130 VSS=VSS VDD=VDD
Xg122628 NAND3X1 $PINS Z=n_4117 A=n_4057 B=n_999 C=n_3217 VSS=VSS VDD=VDD
Xg122629 NAND3X1 $PINS Z=n_4115 A=n_4002 B=n_2786 C=n_1217 VSS=VSS VDD=VDD
Xg122630 NAND3X1 $PINS Z=n_4114 A=n_3969 B=n_3039 C=n_3440 VSS=VSS VDD=VDD
Xg122631 NAND3X1 $PINS Z=n_4113 A=n_4004 B=n_2451 C=n_3225 VSS=VSS VDD=VDD
Xg122632 NAND3X1 $PINS Z=n_4111 A=n_4054 B=n_1558 C=n_919 VSS=VSS VDD=VDD
Xg122633 NAND3X1 $PINS Z=n_4110 A=n_4052 B=n_904 C=n_905 VSS=VSS VDD=VDD
Xg122634 NAND3X1 $PINS Z=n_4109 A=n_4058 B=n_1637 C=n_892 VSS=VSS VDD=VDD
Xg122635 NAND3X1 $PINS Z=n_4108 A=n_4050 B=n_1462 C=n_1826 VSS=VSS VDD=VDD
Xg122636 NAND3X1 $PINS Z=n_4106 A=n_3998 B=n_1641 C=n_1380 VSS=VSS VDD=VDD
Xg122637 XOR2X1 $PINS Z=n_4125 A=csm_inst_right_reg[30] B=n_3963 VSS=VSS
+ VDD=VDD
Xg122638 INVX2 $PINS Z=n_4102 A=n_4103 VSS=VSS VDD=VDD
Xg122639 INVX2 $PINS Z=n_4094 A=n_4095 VSS=VSS VDD=VDD
Xg122640 INVX2 $PINS Z=n_4092 A=n_4093 VSS=VSS VDD=VDD
Xg122641 INVX2 $PINS Z=n_4090 A=n_4091 VSS=VSS VDD=VDD
Xg122642 INVX2 $PINS Z=n_4083 A=n_4086 VSS=VSS VDD=VDD
Xg122643 INVX2 $PINS Z=n_4079 A=n_4081 VSS=VSS VDD=VDD
Xg122644 INVX2 $PINS Z=n_4077 A=n_4078 VSS=VSS VDD=VDD
Xg122645 INVX2 $PINS Z=n_4074 A=n_4075 VSS=VSS VDD=VDD
Xg122646 INVX2 $PINS Z=n_4069 A=n_4072 VSS=VSS VDD=VDD
Xg122647 INVX2 $PINS Z=n_4065 A=n_4066 VSS=VSS VDD=VDD
Xg122648 INVX2 $PINS Z=n_4062 A=n_4064 VSS=VSS VDD=VDD
Xg122649 INVX2 $PINS Z=n_4060 A=n_4061 VSS=VSS VDD=VDD
Xg122650 XOR2X1 $PINS Z=n_4104 A=csm_inst_right_reg[19] B=n_3965 VSS=VSS
+ VDD=VDD
Xg122651 XOR2X1 $PINS Z=n_4103 A=csm_inst_right_reg[27] B=n_3996 VSS=VSS
+ VDD=VDD
Xg122652 XOR2X1 $PINS Z=n_4098 A=csm_inst_right_reg[15] B=n_3964 VSS=VSS
+ VDD=VDD
Xg122653 XOR2X1 $PINS Z=n_4095 A=csm_inst_right_reg[18] B=n_3957 VSS=VSS
+ VDD=VDD
Xg122654 XOR2X1 $PINS Z=n_4093 A=csm_inst_right_reg[24] B=n_3954 VSS=VSS
+ VDD=VDD
Xg122655 XOR2X1 $PINS Z=n_4091 A=csm_inst_right_reg[0] B=n_3985 VSS=VSS VDD=VDD
Xg122656 XOR2X1 $PINS Z=n_4086 A=csm_inst_right_reg[14] B=n_3966 VSS=VSS
+ VDD=VDD
Xg122657 XOR2X1 $PINS Z=n_4081 A=csm_inst_right_reg[7] B=n_3987 VSS=VSS VDD=VDD
Xg122658 XOR2X1 $PINS Z=n_4078 A=csm_inst_right_reg[2] B=n_3988 VSS=VSS VDD=VDD
Xg122659 XOR2X1 $PINS Z=n_4075 A=csm_inst_right_reg[3] B=n_3990 VSS=VSS VDD=VDD
Xg122660 XOR2X1 $PINS Z=n_4072 A=csm_inst_right_reg[31] B=n_3986 VSS=VSS
+ VDD=VDD
Xg122661 XOR2X1 $PINS Z=n_4066 A=csm_inst_right_reg[16] B=n_3956 VSS=VSS
+ VDD=VDD
Xg122662 XOR2X1 $PINS Z=n_4064 A=csm_inst_right_reg[4] B=n_3961 VSS=VSS VDD=VDD
Xg122663 XOR2X1 $PINS Z=n_4061 A=csm_inst_right_reg[23] B=n_3958 VSS=VSS
+ VDD=VDD
Xg122664 NOR2X1 $PINS Z=n_4058 A=n_3699 B=n_4000 VSS=VSS VDD=VDD
Xg122665 NOR2X1 $PINS Z=n_4057 A=n_3348 B=n_3972 VSS=VSS VDD=VDD
Xg122666 NAND3X1 $PINS Z=n_4056 A=n_3940 B=n_3198 C=n_1087 VSS=VSS VDD=VDD
Xg122667 NOR2X1 $PINS Z=n_4054 A=n_921 B=n_3968 VSS=VSS VDD=VDD
Xg122668 NOR2X1 $PINS Z=n_4052 A=n_3665 B=n_3967 VSS=VSS VDD=VDD
Xg122669 NOR2X1 $PINS Z=n_4051 A=n_1128 B=n_3974 VSS=VSS VDD=VDD
Xg122670 NOR2X1 $PINS Z=n_4050 A=n_1262 B=n_4009 VSS=VSS VDD=VDD
Xg122671 NOR2X1 $PINS Z=n_4049 A=n_2994 B=n_4001 VSS=VSS VDD=VDD
Xg122672 NOR2X1 $PINS Z=n_4048 A=n_3406 B=n_3977 VSS=VSS VDD=VDD
Xg122673 NAND3X1 $PINS Z=n_4045 A=n_3911 B=n_3461 C=n_1100 VSS=VSS VDD=VDD
Xg122674 NAND3X1 $PINS Z=n_4042 A=n_3933 B=n_3459 C=n_3021 VSS=VSS VDD=VDD
Xg122675 NAND3X1 $PINS Z=n_4040 A=n_3922 B=n_3703 C=n_3473 VSS=VSS VDD=VDD
Xg122676 NAND3X1 $PINS Z=n_4038 A=n_3997 B=n_3527 C=n_3361 VSS=VSS VDD=VDD
Xg122677 INVX2 $PINS Z=n_4035 A=n_4036 VSS=VSS VDD=VDD
Xg122678 INVX2 $PINS Z=n_4032 A=n_4033 VSS=VSS VDD=VDD
Xg122679 INVX2 $PINS Z=n_4030 A=n_4031 VSS=VSS VDD=VDD
Xg122680 NAND3X1 $PINS Z=n_4029 A=n_3906 B=n_2197 C=n_3114 VSS=VSS VDD=VDD
Xg122681 NOR2X1 $PINS Z=n_4026 A=n_2769 B=n_4013 VSS=VSS VDD=VDD
Xg122682 NAND3X1 $PINS Z=n_4024 A=n_3983 B=n_1270 C=n_1640 VSS=VSS VDD=VDD
Xg122683 NAND3X1 $PINS Z=n_4021 A=n_3976 B=n_988 C=n_989 VSS=VSS VDD=VDD
Xg122684 NAND3X1 $PINS Z=n_4020 A=n_4005 B=n_1204 C=n_1112 VSS=VSS VDD=VDD
Xg122685 NAND3X1 $PINS Z=n_4019 A=n_4003 B=n_1079 C=n_903 VSS=VSS VDD=VDD
Xg122686 NAND3X1 $PINS Z=n_4018 A=n_3938 B=n_2724 C=n_1420 VSS=VSS VDD=VDD
Xg122687 NAND3X1 $PINS Z=n_4017 A=n_4006 B=n_3263 C=n_1208 VSS=VSS VDD=VDD
Xg122688 NAND3X1 $PINS Z=n_4016 A=n_4010 B=n_3356 C=n_3262 VSS=VSS VDD=VDD
Xg122689 NAND3X1 $PINS Z=n_4014 A=n_4012 B=n_1388 C=n_1389 VSS=VSS VDD=VDD
Xg122690 XOR2X1 $PINS Z=n_4036 A=csm_inst_right_reg[6] B=n_3905 VSS=VSS VDD=VDD
Xg122691 XOR2X1 $PINS Z=n_4034 A=csm_inst_right_reg[9] B=n_3904 VSS=VSS VDD=VDD
Xg122692 XOR2X1 $PINS Z=n_4033 A=csm_inst_right_reg[26] B=n_3903 VSS=VSS
+ VDD=VDD
Xg122693 XOR2X1 $PINS Z=n_4031 A=csm_inst_right_reg[3] B=n_3932 VSS=VSS VDD=VDD
Xg122694 NAND3X1 $PINS Z=n_4013 A=n_3845 B=n_3469 C=n_3467 VSS=VSS VDD=VDD
Xg122695 NOR2X1 $PINS Z=n_4012 A=n_3274 B=n_3920 VSS=VSS VDD=VDD
Xg122696 NOR2X1 $PINS Z=n_4010 A=n_3515 B=n_3947 VSS=VSS VDD=VDD
Xg122697 NAND3X1 $PINS Z=n_4009 A=n_3856 B=n_3353 C=n_1520 VSS=VSS VDD=VDD
Xg122698 NOR2X1 $PINS Z=n_4006 A=n_2480 B=n_3918 VSS=VSS VDD=VDD
Xg122699 NOR2X1 $PINS Z=n_4005 A=n_1201 B=n_3945 VSS=VSS VDD=VDD
Xg122700 NOR2X1 $PINS Z=n_4004 A=n_3224 B=n_3915 VSS=VSS VDD=VDD
Xg122701 NOR2X1 $PINS Z=n_4003 A=n_3193 B=n_3910 VSS=VSS VDD=VDD
Xg122702 NOR2X1 $PINS Z=n_4002 A=n_1188 B=n_3907 VSS=VSS VDD=VDD
Xg122703 NAND3X1 $PINS Z=n_4001 A=n_3843 B=n_3710 C=n_1173 VSS=VSS VDD=VDD
Xg122704 NAND3X1 $PINS Z=n_4000 A=n_3953 B=n_3544 C=n_894 VSS=VSS VDD=VDD
Xg122705 NOR2X1 $PINS Z=n_3998 A=n_3533 B=n_3935 VSS=VSS VDD=VDD
Xg122706 NOR2X1 $PINS Z=n_3997 A=n_3526 B=n_3951 VSS=VSS VDD=VDD
Xg122707 NAND3X1 $PINS Z=n_3996 A=n_3950 B=n_1612 C=n_1412 VSS=VSS VDD=VDD
Xg122708 NAND3X1 $PINS Z=n_3990 A=n_3948 B=n_3363 C=n_3183 VSS=VSS VDD=VDD
Xg122709 NAND3X1 $PINS Z=n_3988 A=n_3927 B=n_1101 C=n_885 VSS=VSS VDD=VDD
Xg122710 NAND3X1 $PINS Z=n_3987 A=n_3875 B=n_3530 C=n_3541 VSS=VSS VDD=VDD
Xg122711 NAND3X1 $PINS Z=n_3986 A=n_3860 B=n_3587 C=n_3281 VSS=VSS VDD=VDD
Xg122712 NAND3X1 $PINS Z=n_3985 A=n_3885 B=n_3405 C=n_1231 VSS=VSS VDD=VDD
Xg122713 INVX2 $PINS Z=n_3983 A=n_3971 VSS=VSS VDD=VDD
Xg122714 INVX2 $PINS Z=n_3980 A=n_3981 VSS=VSS VDD=VDD
Xg122715 NAND3X1 $PINS Z=n_3977 A=n_3873 B=n_1634 C=n_1280 VSS=VSS VDD=VDD
Xg122716 NOR2X1 $PINS Z=n_3976 A=n_2467 B=n_3946 VSS=VSS VDD=VDD
Xg122717 NAND3X1 $PINS Z=n_3974 A=n_3839 B=n_3460 C=n_3216 VSS=VSS VDD=VDD
Xg122718 NAND3X1 $PINS Z=n_3972 A=n_3941 B=n_3394 C=n_896 VSS=VSS VDD=VDD
Xg122719 NAND3X1 $PINS Z=n_3971 A=n_3842 B=n_3579 C=n_3512 VSS=VSS VDD=VDD
Xg122720 NOR2X1 $PINS Z=n_3969 A=n_2751 B=n_3908 VSS=VSS VDD=VDD
Xg122721 NAND3X1 $PINS Z=n_3968 A=n_3936 B=n_3337 C=n_889 VSS=VSS VDD=VDD
Xg122722 NAND3X1 $PINS Z=n_3967 A=n_3844 B=n_3336 C=n_3386 VSS=VSS VDD=VDD
Xg122723 NAND3X1 $PINS Z=n_3966 A=n_6076 B=n_3212 C=n_1167 VSS=VSS VDD=VDD
Xg122724 NAND3X1 $PINS Z=n_3965 A=n_3943 B=n_3232 C=n_3397 VSS=VSS VDD=VDD
Xg122725 NOR2X1 $PINS Z=n_3964 A=n_3489 B=n_3925 VSS=VSS VDD=VDD
Xg122726 NAND3X1 $PINS Z=n_3963 A=n_3914 B=n_3227 C=n_2462 VSS=VSS VDD=VDD
Xg122727 NAND3X1 $PINS Z=n_3961 A=n_3913 B=n_1363 C=n_1360 VSS=VSS VDD=VDD
Xg122728 NAND3X1 $PINS Z=n_3958 A=n_3937 B=n_970 C=n_969 VSS=VSS VDD=VDD
Xg122729 NOR2X1 $PINS Z=n_3957 A=n_3612 B=n_3916 VSS=VSS VDD=VDD
Xg122730 NAND3X1 $PINS Z=n_3956 A=n_3926 B=n_1635 C=n_1247 VSS=VSS VDD=VDD
Xg122731 MUX2X1 $PINS Z=n_3954 A=n_3704 B=n_3876 S=csm_inst_mode VSS=VSS
+ VDD=VDD
Xg122732 XOR2X1 $PINS Z=n_3982 A=csm_inst_right_reg[16] B=n_3835 VSS=VSS
+ VDD=VDD
Xg122733 XOR2X1 $PINS Z=n_3981 A=csm_inst_right_reg[23] B=n_3838 VSS=VSS
+ VDD=VDD
Xg122734 INVX2 $PINS Z=n_3953 A=n_3934 VSS=VSS VDD=VDD
Xg122736 NAND2X1 $PINS Z=n_3951 A=n_3864 B=n_1076 VSS=VSS VDD=VDD
Xg122737 NOR2X1 $PINS Z=n_3950 A=n_3279 B=n_3880 VSS=VSS VDD=VDD
Xg122738 NOR2X1 $PINS Z=n_3948 A=n_900 B=n_3881 VSS=VSS VDD=VDD
Xg122739 NAND3X1 $PINS Z=n_3947 A=n_3791 B=n_3514 C=n_888 VSS=VSS VDD=VDD
Xg122740 NAND3X1 $PINS Z=n_3946 A=n_3804 B=n_3510 C=n_3350 VSS=VSS VDD=VDD
Xg122741 NAND3X1 $PINS Z=n_3945 A=n_3808 B=n_3241 C=n_3398 VSS=VSS VDD=VDD
Xg122742 AND2X1 $PINS Z=n_3943 A=n_3868 B=n_3708 VSS=VSS VDD=VDD
Xg122743 NOR2X1 $PINS Z=n_3941 A=n_1125 B=n_3890 VSS=VSS VDD=VDD
Xg122744 AND2X1 $PINS Z=n_3940 A=n_3850 B=n_3197 VSS=VSS VDD=VDD
Xg122745 NOR2X1 $PINS Z=n_3938 A=n_1030 B=n_3895 VSS=VSS VDD=VDD
Xg122746 NOR2X1 $PINS Z=n_3937 A=n_968 B=n_3898 VSS=VSS VDD=VDD
Xg122747 NOR2X1 $PINS Z=n_3936 A=n_3055 B=n_3901 VSS=VSS VDD=VDD
Xg122748 NAND3X1 $PINS Z=n_3935 A=n_3806 B=n_3624 C=n_1137 VSS=VSS VDD=VDD
Xg122749 NAND3X1 $PINS Z=n_3934 A=n_3830 B=n_3435 C=n_1621 VSS=VSS VDD=VDD
Xg122750 NOR2X1 $PINS Z=n_3933 A=n_3625 B=n_3866 VSS=VSS VDD=VDD
Xg122751 NAND3X1 $PINS Z=n_3932 A=n_3867 B=n_3436 C=n_1614 VSS=VSS VDD=VDD
Xg122752 INVX2 $PINS Z=n_3927 A=n_3919 VSS=VSS VDD=VDD
Xg122753 INVX2 $PINS Z=n_3926 A=n_3917 VSS=VSS VDD=VDD
Xg122754 NAND3X1 $PINS Z=n_3925 A=n_3855 B=n_3486 C=n_1501 VSS=VSS VDD=VDD
Xg122755 NOR2X1 $PINS Z=n_3922 A=n_3472 B=n_3846 VSS=VSS VDD=VDD
Xg122756 NAND3X1 $PINS Z=n_3920 A=n_3861 B=n_3273 C=n_1386 VSS=VSS VDD=VDD
Xg122757 NAND3X1 $PINS Z=n_3919 A=n_3858 B=n_3311 C=n_1122 VSS=VSS VDD=VDD
Xg122758 NAND3X1 $PINS Z=n_3918 A=n_3824 B=n_3257 C=n_1071 VSS=VSS VDD=VDD
Xg122759 NAND3X1 $PINS Z=n_3917 A=n_3832 B=n_3685 C=n_3351 VSS=VSS VDD=VDD
Xg122760 NAND3X1 $PINS Z=n_3916 A=n_3886 B=n_1170 C=n_1171 VSS=VSS VDD=VDD
Xg122761 NAND3X1 $PINS Z=n_3915 A=n_3803 B=n_1151 C=n_1598 VSS=VSS VDD=VDD
Xg122762 NOR2X1 $PINS Z=n_3914 A=n_2453 B=n_3887 VSS=VSS VDD=VDD
Xg122763 NOR2X1 $PINS Z=n_3913 A=n_3814 B=n_3849 VSS=VSS VDD=VDD
Xg122764 NOR2X1 $PINS Z=n_3911 A=n_3481 B=n_3852 VSS=VSS VDD=VDD
Xg122765 NAND3X1 $PINS Z=n_3910 A=n_3902 B=n_1078 C=n_1003 VSS=VSS VDD=VDD
Xg122766 NAND3X1 $PINS Z=n_3908 A=n_3833 B=n_3102 C=n_3338 VSS=VSS VDD=VDD
Xg122767 NAND3X1 $PINS Z=n_3907 A=n_3816 B=n_3187 C=n_3188 VSS=VSS VDD=VDD
Xg122768 NOR2X1 $PINS Z=n_3906 A=n_2744 B=n_3897 VSS=VSS VDD=VDD
Xg122769 NAND3X1 $PINS Z=n_3905 A=n_3817 B=n_3676 C=n_3633 VSS=VSS VDD=VDD
Xg122770 NAND3X1 $PINS Z=n_3904 A=n_3853 B=n_1611 C=n_1570 VSS=VSS VDD=VDD
Xg122771 NAND3X1 $PINS Z=n_3903 A=n_3862 B=n_3360 C=n_1461 VSS=VSS VDD=VDD
Xg122822 INVX2 $PINS Z=n_3902 A=n_3894 VSS=VSS VDD=VDD
Xg122823 NAND3X1 $PINS Z=n_3901 A=n_3700 B=n_3468 C=n_912 VSS=VSS VDD=VDD
Xg122824 NAND3X1 $PINS Z=n_3898 A=n_3811 B=n_3074 C=n_1009 VSS=VSS VDD=VDD
Xg122825 NAND3X1 $PINS Z=n_3897 A=n_3640 B=n_1351 C=n_1379 VSS=VSS VDD=VDD
Xg122826 NAND3X1 $PINS Z=n_3895 A=n_3815 B=n_3340 C=n_3179 VSS=VSS VDD=VDD
Xg122827 NAND3X1 $PINS Z=n_3894 A=n_3642 B=n_3003 C=n_981 VSS=VSS VDD=VDD
Xg122829 NAND3X1 $PINS Z=n_3890 A=n_3646 B=n_3215 C=n_1123 VSS=VSS VDD=VDD
Xg122830 NAND3X1 $PINS Z=n_3887 A=n_3802 B=n_3349 C=n_1147 VSS=VSS VDD=VDD
Xg122831 NOR2X1 $PINS Z=n_3886 A=n_3610 B=n_3788 VSS=VSS VDD=VDD
Xg122832 NOR2X1 $PINS Z=n_3885 A=n_3823 B=n_3822 VSS=VSS VDD=VDD
Xg122833 NAND3X1 $PINS Z=n_3881 A=n_3475 B=n_3650 C=n_3603 VSS=VSS VDD=VDD
Xg122834 NAND3X1 $PINS Z=n_3880 A=n_3828 B=n_3409 C=n_1405 VSS=VSS VDD=VDD
Xg122835 NAND3X1 $PINS Z=n_3876 A=n_3698 B=n_3028 C=n_3295 VSS=VSS VDD=VDD
Xg122836 NOR2X1 $PINS Z=n_3875 A=n_3299 B=n_3797 VSS=VSS VDD=VDD
Xg122837 NAND2X1 $PINS Z=n_3873 A=n_3790 B=n_19 VSS=VSS VDD=VDD
Xg122838 NAND2X1 $PINS Z=n_3868 A=n_3789 B=n_19 VSS=VSS VDD=VDD
Xg122839 NOR2X1 $PINS Z=n_3867 A=n_3438 B=n_3800 VSS=VSS VDD=VDD
Xg122840 NAND2X1 $PINS Z=n_3866 A=n_3829 B=n_1507 VSS=VSS VDD=VDD
Xg122841 NAND2X1 $PINS Z=n_3864 A=n_3796 B=n_2978 VSS=VSS VDD=VDD
Xg122842 NOR2X1 $PINS Z=n_3862 A=n_3411 B=n_3795 VSS=VSS VDD=VDD
Xg122843 AND2X1 $PINS Z=n_3861 A=n_3834 B=n_1251 VSS=VSS VDD=VDD
Xg122844 NAND2X1 $PINS Z=n_3860 A=n_3827 B=csm_inst_mode VSS=VSS VDD=VDD
Xg122845 NOR2X1 $PINS Z=n_3858 A=n_2469 B=n_3793 VSS=VSS VDD=VDD
Xg122846 NOR2X1 $PINS Z=n_3856 A=n_3407 B=n_3807 VSS=VSS VDD=VDD
Xg122847 AND2X1 $PINS Z=n_3855 A=n_3819 B=n_3645 VSS=VSS VDD=VDD
Xg122848 NOR2X1 $PINS Z=n_3853 A=n_2510 B=n_3798 VSS=VSS VDD=VDD
Xg122849 NAND2X1 $PINS Z=n_3852 A=n_3818 B=n_3604 VSS=VSS VDD=VDD
Xg122850 NAND2X1 $PINS Z=n_3850 A=n_3786 B=csm_inst_mode VSS=VSS VDD=VDD
Xg122851 NAND2X1 $PINS Z=n_3849 A=n_3809 B=n_3632 VSS=VSS VDD=VDD
Xg122852 NAND2X1 $PINS Z=n_3846 A=n_3812 B=n_1540 VSS=VSS VDD=VDD
Xg122853 AND2X1 $PINS Z=n_3845 A=n_3801 B=n_1594 VSS=VSS VDD=VDD
Xg122854 NAND2X1 $PINS Z=n_3844 A=n_6078 B=n_3043 VSS=VSS VDD=VDD
Xg122855 NAND2X1 $PINS Z=n_3843 A=n_3826 B=n_19 VSS=VSS VDD=VDD
Xg122856 NAND2X1 $PINS Z=n_3842 A=n_3821 B=csm_inst_mode VSS=VSS VDD=VDD
Xg122857 NAND2X1 $PINS Z=n_3839 A=n_3820 B=csm_inst_mode VSS=VSS VDD=VDD
Xg122859 NAND3X1 $PINS Z=n_3838 A=n_3672 B=n_3652 C=n_1421 VSS=VSS VDD=VDD
Xg122861 NAND3X1 $PINS Z=n_3835 A=n_3709 B=n_3677 C=n_3203 VSS=VSS VDD=VDD
Xg122874 NAND2X1 $PINS Z=n_3834 A=n_3695 B=csm_inst_mode VSS=VSS VDD=VDD
Xg122875 NAND2X1 $PINS Z=n_3833 A=n_3674 B=n_2899 VSS=VSS VDD=VDD
Xg122876 NAND2X1 $PINS Z=n_3832 A=n_3648 B=n_19 VSS=VSS VDD=VDD
Xg122877 NAND2X1 $PINS Z=n_3830 A=n_3656 B=n_240 VSS=VSS VDD=VDD
Xg122878 NAND2X1 $PINS Z=n_3829 A=n_3655 B=csm_inst_mode VSS=VSS VDD=VDD
Xg122879 AND2X1 $PINS Z=n_3828 A=n_3696 B=n_3278 VSS=VSS VDD=VDD
Xg122880 NAND3X1 $PINS Z=n_3827 A=n_3600 B=n_1839 C=n_1075 VSS=VSS VDD=VDD
Xg122881 NAND3X1 $PINS Z=n_3826 A=n_3616 B=n_3517 C=n_3377 VSS=VSS VDD=VDD
Xg122882 NAND2X1 $PINS Z=n_3824 A=n_3649 B=csm_inst_mode VSS=VSS VDD=VDD
Xg122883 NAND2X1 $PINS Z=n_3823 A=n_3661 B=n_1224 VSS=VSS VDD=VDD
Xg122884 NAND3X1 $PINS Z=n_3822 A=n_3611 B=n_3242 C=n_1091 VSS=VSS VDD=VDD
Xg122885 NAND3X1 $PINS Z=n_3821 A=n_3609 B=n_3483 C=n_3218 VSS=VSS VDD=VDD
Xg122886 NAND3X1 $PINS Z=n_3820 A=n_3608 B=n_3210 C=n_3371 VSS=VSS VDD=VDD
Xg122887 NAND2X1 $PINS Z=n_3819 A=n_3706 B=csm_inst_mode VSS=VSS VDD=VDD
Xg122888 NAND2X1 $PINS Z=n_3818 A=n_3644 B=csm_inst_mode VSS=VSS VDD=VDD
Xg122889 NAND3X1 $PINS Z=n_3817 A=n_3636 B=n_3602 C=n_19 VSS=VSS VDD=VDD
Xg122890 NAND2X1 $PINS Z=n_3816 A=n_3641 B=csm_inst_mode VSS=VSS VDD=VDD
Xg122891 AND2X1 $PINS Z=n_3815 A=n_3675 B=n_3178 VSS=VSS VDD=VDD
Xg122892 NAND2X1 $PINS Z=n_3814 A=n_3673 B=n_3100 VSS=VSS VDD=VDD
Xg122893 NAND2X1 $PINS Z=n_3812 A=n_3670 B=csm_inst_mode VSS=VSS VDD=VDD
Xg122894 AND2X1 $PINS Z=n_3811 A=n_3666 B=n_3073 VSS=VSS VDD=VDD
Xg122896 NAND2X1 $PINS Z=n_3809 A=n_3667 B=n_19 VSS=VSS VDD=VDD
Xg122897 NOR2X1 $PINS Z=n_3808 A=n_1196 B=n_3681 VSS=VSS VDD=VDD
Xg122898 NOR2X1 $PINS Z=n_3807 A=csm_inst_mode B=n_3691 VSS=VSS VDD=VDD
Xg122899 NAND2X1 $PINS Z=n_3806 A=n_3654 B=csm_inst_mode VSS=VSS VDD=VDD
Xg122900 MUX2X1 $PINS Z=n_3805 A=spi_inst_shreg_in[10] B=spi_rx_data[11]
+ S=n_3638 VSS=VSS VDD=VDD
Xg122901 NAND2X1 $PINS Z=n_3804 A=n_3683 B=n_19 VSS=VSS VDD=VDD
Xg122902 NAND2X1 $PINS Z=n_3803 A=n_3678 B=csm_inst_mode VSS=VSS VDD=VDD
Xg122903 NAND2X1 $PINS Z=n_3802 A=n_3647 B=n_19 VSS=VSS VDD=VDD
Xg122904 NAND2X1 $PINS Z=n_3801 A=n_3664 B=csm_inst_mode VSS=VSS VDD=VDD
Xg122905 NAND3X1 $PINS Z=n_3800 A=n_3662 B=n_3462 C=n_1491 VSS=VSS VDD=VDD
Xg122906 NAND3X1 $PINS Z=n_3798 A=n_3653 B=n_3306 C=n_3362 VSS=VSS VDD=VDD
Xg122907 NAND3X1 $PINS Z=n_3797 A=n_3594 B=n_1062 C=n_1542 VSS=VSS VDD=VDD
Xg122908 NAND3X1 $PINS Z=n_3796 A=n_3601 B=n_1846 C=n_86 VSS=VSS VDD=VDD
Xg122909 NAND3X1 $PINS Z=n_3795 A=n_3693 B=n_3291 C=n_1452 VSS=VSS VDD=VDD
Xg122910 NAND3X1 $PINS Z=n_3793 A=n_3671 B=n_1359 C=n_1521 VSS=VSS VDD=VDD
Xg122911 NOR2X1 $PINS Z=n_3791 A=n_2479 B=n_3692 VSS=VSS VDD=VDD
Xg122912 NAND3X1 $PINS Z=n_3790 A=n_3686 B=n_3251 C=n_3615 VSS=VSS VDD=VDD
Xg122913 NAND3X1 $PINS Z=n_3789 A=n_3613 B=n_3619 C=n_3374 VSS=VSS VDD=VDD
Xg122914 NAND3X1 $PINS Z=n_3788 A=n_3629 B=n_6081 C=n_1411 VSS=VSS VDD=VDD
Xg122915 NAND3X1 $PINS Z=n_3787 A=n_3707 B=n_1399 C=n_1404 VSS=VSS VDD=VDD
Xg122916 NAND3X1 $PINS Z=n_3786 A=n_3658 B=n_3194 C=n_3366 VSS=VSS VDD=VDD
Xg122917 MUX2X1 $PINS Z=n_3785 A=mosi B=spi_rx_data[0] S=n_3638 VSS=VSS VDD=VDD
Xg122918 MUX2X1 $PINS Z=n_3784 A=spi_inst_shreg_in[0] B=spi_rx_data[1] S=n_3638
+ VSS=VSS VDD=VDD
Xg122919 MUX2X1 $PINS Z=n_3783 A=spi_inst_shreg_in[1] B=spi_rx_data[2] S=n_3638
+ VSS=VSS VDD=VDD
Xg122920 MUX2X1 $PINS Z=n_3782 A=spi_inst_shreg_in[2] B=spi_rx_data[3] S=n_3638
+ VSS=VSS VDD=VDD
Xg122921 MUX2X1 $PINS Z=n_3780 A=spi_inst_shreg_in[3] B=spi_rx_data[4] S=n_3638
+ VSS=VSS VDD=VDD
Xg122922 MUX2X1 $PINS Z=n_3777 A=spi_inst_shreg_in[4] B=spi_rx_data[5] S=n_3638
+ VSS=VSS VDD=VDD
Xg122923 MUX2X1 $PINS Z=n_3776 A=spi_inst_shreg_in[6] B=spi_rx_data[7] S=n_3638
+ VSS=VSS VDD=VDD
Xg122924 MUX2X1 $PINS Z=n_3775 A=spi_inst_shreg_in[7] B=spi_rx_data[8] S=n_3638
+ VSS=VSS VDD=VDD
Xg122925 MUX2X1 $PINS Z=n_3773 A=spi_inst_shreg_in[8] B=spi_rx_data[9] S=n_3638
+ VSS=VSS VDD=VDD
Xg122927 MUX2X1 $PINS Z=n_3772 A=spi_inst_shreg_in[39] B=spi_rx_data[40]
+ S=n_3638 VSS=VSS VDD=VDD
Xg122928 MUX2X1 $PINS Z=n_3771 A=spi_inst_shreg_in[12] B=spi_rx_data[13]
+ S=n_3638 VSS=VSS VDD=VDD
Xg122929 MUX2X1 $PINS Z=n_3770 A=spi_inst_shreg_in[13] B=spi_rx_data[14]
+ S=n_3638 VSS=VSS VDD=VDD
Xg122930 MUX2X1 $PINS Z=n_3769 A=spi_inst_shreg_in[14] B=spi_rx_data[15]
+ S=n_3638 VSS=VSS VDD=VDD
Xg122931 MUX2X1 $PINS Z=n_3768 A=spi_inst_shreg_in[16] B=spi_rx_data[17]
+ S=n_3638 VSS=VSS VDD=VDD
Xg122932 MUX2X1 $PINS Z=n_3767 A=spi_inst_shreg_in[17] B=spi_rx_data[18]
+ S=n_3638 VSS=VSS VDD=VDD
Xg122933 MUX2X1 $PINS Z=n_3766 A=spi_inst_shreg_in[18] B=spi_rx_data[19]
+ S=n_3638 VSS=VSS VDD=VDD
Xg122934 MUX2X1 $PINS Z=n_3765 A=spi_inst_shreg_in[19] B=spi_rx_data[20]
+ S=n_3638 VSS=VSS VDD=VDD
Xg122935 MUX2X1 $PINS Z=n_3764 A=spi_inst_shreg_in[20] B=spi_rx_data[21]
+ S=n_3638 VSS=VSS VDD=VDD
Xg122936 MUX2X1 $PINS Z=n_3763 A=spi_inst_shreg_in[21] B=spi_rx_data[22]
+ S=n_3638 VSS=VSS VDD=VDD
Xg122937 MUX2X1 $PINS Z=n_3762 A=spi_inst_shreg_in[22] B=spi_rx_data[23]
+ S=n_3638 VSS=VSS VDD=VDD
Xg122938 MUX2X1 $PINS Z=n_3761 A=spi_inst_shreg_in[23] B=spi_rx_data[24]
+ S=n_3638 VSS=VSS VDD=VDD
Xg122939 MUX2X1 $PINS Z=n_3758 A=spi_inst_shreg_in[24] B=spi_rx_data[25]
+ S=n_3638 VSS=VSS VDD=VDD
Xg122940 MUX2X1 $PINS Z=n_3757 A=spi_inst_shreg_in[25] B=spi_rx_data[26]
+ S=n_3638 VSS=VSS VDD=VDD
Xg122941 MUX2X1 $PINS Z=n_3756 A=spi_inst_shreg_in[26] B=spi_rx_data[27]
+ S=n_3638 VSS=VSS VDD=VDD
Xg122942 MUX2X1 $PINS Z=n_3754 A=spi_inst_shreg_in[27] B=spi_rx_data[28]
+ S=n_3638 VSS=VSS VDD=VDD
Xg122943 MUX2X1 $PINS Z=n_3753 A=spi_inst_shreg_in[28] B=spi_rx_data[29]
+ S=n_3638 VSS=VSS VDD=VDD
Xg122944 MUX2X1 $PINS Z=n_3752 A=spi_inst_shreg_in[29] B=spi_rx_data[30]
+ S=n_3638 VSS=VSS VDD=VDD
Xg122945 MUX2X1 $PINS Z=n_3751 A=spi_inst_shreg_in[30] B=spi_rx_data[31]
+ S=n_3638 VSS=VSS VDD=VDD
Xg122946 MUX2X1 $PINS Z=n_3750 A=spi_inst_shreg_in[31] B=spi_rx_data[32]
+ S=n_3638 VSS=VSS VDD=VDD
Xg122947 MUX2X1 $PINS Z=n_3748 A=spi_inst_shreg_in[32] B=spi_rx_data[33]
+ S=n_3638 VSS=VSS VDD=VDD
Xg122948 MUX2X1 $PINS Z=n_3747 A=spi_inst_shreg_in[33] B=spi_rx_data[34]
+ S=n_3638 VSS=VSS VDD=VDD
Xg122949 MUX2X1 $PINS Z=n_3745 A=spi_inst_shreg_in[34] B=spi_rx_data[35]
+ S=n_3638 VSS=VSS VDD=VDD
Xg122950 MUX2X1 $PINS Z=n_3744 A=spi_inst_shreg_in[35] B=spi_rx_data[36]
+ S=n_3638 VSS=VSS VDD=VDD
Xg122951 MUX2X1 $PINS Z=n_3743 A=spi_inst_shreg_in[36] B=spi_rx_data[37]
+ S=n_3638 VSS=VSS VDD=VDD
Xg122952 MUX2X1 $PINS Z=n_3742 A=spi_inst_shreg_in[37] B=spi_rx_data[38]
+ S=n_3638 VSS=VSS VDD=VDD
Xg122953 MUX2X1 $PINS Z=n_3741 A=spi_inst_shreg_in[38] B=spi_rx_data[39]
+ S=n_3638 VSS=VSS VDD=VDD
Xg122954 MUX2X1 $PINS Z=n_3740 A=spi_inst_shreg_in[11] B=spi_rx_data[12]
+ S=n_3638 VSS=VSS VDD=VDD
Xg122955 MUX2X1 $PINS Z=n_3739 A=spi_inst_shreg_in[40] B=spi_rx_data[41]
+ S=n_3638 VSS=VSS VDD=VDD
Xg122956 MUX2X1 $PINS Z=n_3738 A=spi_inst_shreg_in[41] B=spi_rx_data[42]
+ S=n_3638 VSS=VSS VDD=VDD
Xg122957 MUX2X1 $PINS Z=n_3737 A=spi_inst_shreg_in[42] B=spi_rx_data[43]
+ S=n_3638 VSS=VSS VDD=VDD
Xg122958 MUX2X1 $PINS Z=n_3736 A=spi_inst_shreg_in[43] B=spi_rx_data[44]
+ S=n_3638 VSS=VSS VDD=VDD
Xg122959 MUX2X1 $PINS Z=n_3735 A=spi_inst_shreg_in[44] B=spi_rx_data[45]
+ S=n_3638 VSS=VSS VDD=VDD
Xg122960 MUX2X1 $PINS Z=n_3734 A=spi_inst_shreg_in[45] B=spi_rx_data[46]
+ S=n_3638 VSS=VSS VDD=VDD
Xg122961 MUX2X1 $PINS Z=n_3733 A=spi_inst_shreg_in[46] B=spi_rx_data[47]
+ S=n_3638 VSS=VSS VDD=VDD
Xg122962 MUX2X1 $PINS Z=n_3730 A=spi_inst_shreg_in[47] B=spi_rx_data[48]
+ S=n_3638 VSS=VSS VDD=VDD
Xg122963 MUX2X1 $PINS Z=n_3728 A=spi_inst_shreg_in[48] B=spi_rx_data[49]
+ S=n_3638 VSS=VSS VDD=VDD
Xg122964 MUX2X1 $PINS Z=n_3727 A=spi_inst_shreg_in[49] B=spi_rx_data[50]
+ S=n_3638 VSS=VSS VDD=VDD
Xg122965 MUX2X1 $PINS Z=n_3726 A=spi_inst_shreg_in[50] B=spi_rx_data[51]
+ S=n_3638 VSS=VSS VDD=VDD
Xg122966 MUX2X1 $PINS Z=n_3725 A=spi_inst_shreg_in[51] B=spi_rx_data[52]
+ S=n_3638 VSS=VSS VDD=VDD
Xg122967 MUX2X1 $PINS Z=n_3724 A=spi_inst_shreg_in[52] B=spi_rx_data[53]
+ S=n_3638 VSS=VSS VDD=VDD
Xg122968 MUX2X1 $PINS Z=n_3723 A=spi_inst_shreg_in[53] B=spi_rx_data[54]
+ S=n_3638 VSS=VSS VDD=VDD
Xg122969 MUX2X1 $PINS Z=n_3722 A=spi_inst_shreg_in[54] B=spi_rx_data[55]
+ S=n_3638 VSS=VSS VDD=VDD
Xg122970 MUX2X1 $PINS Z=n_3721 A=spi_inst_shreg_in[55] B=spi_rx_data[56]
+ S=n_3638 VSS=VSS VDD=VDD
Xg122971 MUX2X1 $PINS Z=n_3720 A=spi_inst_shreg_in[56] B=spi_rx_data[57]
+ S=n_3638 VSS=VSS VDD=VDD
Xg122972 MUX2X1 $PINS Z=n_3719 A=spi_inst_shreg_in[58] B=spi_rx_data[59]
+ S=n_3638 VSS=VSS VDD=VDD
Xg122973 MUX2X1 $PINS Z=n_3718 A=spi_inst_shreg_in[59] B=spi_rx_data[60]
+ S=n_3638 VSS=VSS VDD=VDD
Xg122974 MUX2X1 $PINS Z=n_3717 A=spi_inst_shreg_in[60] B=spi_rx_data[61]
+ S=n_3638 VSS=VSS VDD=VDD
Xg122975 MUX2X1 $PINS Z=n_3716 A=spi_inst_shreg_in[61] B=spi_rx_data[62]
+ S=n_3638 VSS=VSS VDD=VDD
Xg122976 MUX2X1 $PINS Z=n_3715 A=spi_inst_shreg_in[62] B=spi_rx_data[63]
+ S=n_3638 VSS=VSS VDD=VDD
Xg122977 MUX2X1 $PINS Z=n_3714 A=spi_inst_shreg_in[9] B=spi_rx_data[10]
+ S=n_3638 VSS=VSS VDD=VDD
Xg122978 MUX2X1 $PINS Z=n_3713 A=spi_inst_shreg_in[57] B=spi_rx_data[58]
+ S=n_3638 VSS=VSS VDD=VDD
Xg122979 MUX2X1 $PINS Z=n_3712 A=spi_inst_shreg_in[5] B=spi_rx_data[6] S=n_3638
+ VSS=VSS VDD=VDD
Xg122980 MUX2X1 $PINS Z=n_3711 A=spi_inst_shreg_in[15] B=spi_rx_data[16]
+ S=n_3638 VSS=VSS VDD=VDD
Xg122981 NAND2X1 $PINS Z=n_3710 A=n_3617 B=n_89 VSS=VSS VDD=VDD
Xg122982 NAND2X1 $PINS Z=n_3709 A=n_3575 B=n_19 VSS=VSS VDD=VDD
Xg122983 NAND2X1 $PINS Z=n_3708 A=n_3578 B=n_89 VSS=VSS VDD=VDD
Xg122984 NAND2X1 $PINS Z=n_3707 A=n_3576 B=n_89 VSS=VSS VDD=VDD
Xg122985 NAND2X1 $PINS Z=n_3706 A=n_3605 B=n_6083 VSS=VSS VDD=VDD
Xg122986 NOR2X1 $PINS Z=n_3704 A=n_3622 B=n_3598 VSS=VSS VDD=VDD
Xg122987 NAND2X1 $PINS Z=n_3703 A=n_3562 B=n_240 VSS=VSS VDD=VDD
Xg122988 NAND2X1 $PINS Z=n_3700 A=n_3559 B=n_240 VSS=VSS VDD=VDD
Xg122989 NAND2X1 $PINS Z=n_3699 A=n_3626 B=n_1337 VSS=VSS VDD=VDD
Xg122990 NAND2X1 $PINS Z=n_3698 A=n_3592 B=csm_inst_round_counter[1] VSS=VSS
+ VDD=VDD
Xg122991 NOR2X1 $PINS Z=n_3696 A=n_1403 B=n_3588 VSS=VSS VDD=VDD
Xg122992 NAND3X1 $PINS Z=n_3695 A=n_3536 B=n_3537 C=n_3220 VSS=VSS VDD=VDD
Xg122993 NAND2X1 $PINS Z=n_3694 A=n_3638 B=n_3586 VSS=VSS VDD=VDD
Xg122994 NAND2X1 $PINS Z=n_3693 A=n_3590 B=n_19 VSS=VSS VDD=VDD
Xg122995 NAND3X1 $PINS Z=n_3692 A=n_3520 B=n_1107 C=n_1010 VSS=VSS VDD=VDD
Xg122996 NOR2X1 $PINS Z=n_3691 A=n_3254 B=n_3585 VSS=VSS VDD=VDD
Xg122997 NAND2X1 $PINS Z=n_3686 A=n_3583 B=csm_inst_round_counter[1] VSS=VSS
+ VDD=VDD
Xg122998 NAND2X1 $PINS Z=n_3685 A=n_3580 B=n_243 VSS=VSS VDD=VDD
Xg122999 NAND3X1 $PINS Z=n_3683 A=n_3508 B=n_3509 C=n_1839 VSS=VSS VDD=VDD
Xg123000 NAND3X1 $PINS Z=n_3681 A=n_3239 B=n_3505 C=n_3240 VSS=VSS VDD=VDD
Xg123001 NAND3X1 $PINS Z=n_3678 A=n_3499 B=n_3417 C=n_3373 VSS=VSS VDD=VDD
Xg123002 NOR2X1 $PINS Z=n_3677 A=n_3201 B=n_3573 VSS=VSS VDD=VDD
Xg123003 NAND2X1 $PINS Z=n_3676 A=n_3568 B=n_243 VSS=VSS VDD=VDD
Xg123004 NAND2X1 $PINS Z=n_3675 A=n_3567 B=csm_inst_mode VSS=VSS VDD=VDD
Xg123005 NAND3X1 $PINS Z=n_3674 A=n_3463 B=n_1566 C=n_19 VSS=VSS VDD=VDD
Xg123006 NAND2X1 $PINS Z=n_3673 A=n_3563 B=n_243 VSS=VSS VDD=VDD
Xg123008 INVX2 $PINS Z=n_3672 A=n_3651 VSS=VSS VDD=VDD
Xg123009 INVX2 $PINS Z=n_3671 A=n_3639 VSS=VSS VDD=VDD
Xg123010 NAND2X1 $PINS Z=n_3670 A=n_3599 B=n_3083 VSS=VSS VDD=VDD
Xg123011 NAND2X1 $PINS Z=n_3667 A=n_3627 B=n_1597 VSS=VSS VDD=VDD
Xg123012 NAND2X1 $PINS Z=n_3666 A=n_3561 B=csm_inst_mode VSS=VSS VDD=VDD
Xg123013 AND2X1 $PINS Z=n_3665 A=n_3558 B=csm_inst_mode VSS=VSS VDD=VDD
Xg123014 NAND3X1 $PINS Z=n_3664 A=n_3465 B=n_3549 C=n_1456 VSS=VSS VDD=VDD
Xg123016 NOR2X1 $PINS Z=n_3662 A=n_3315 B=n_3596 VSS=VSS VDD=VDD
Xg123017 NAND3X1 $PINS Z=n_3661 A=n_3511 B=n_1222 C=n_85 VSS=VSS VDD=VDD
Xg123018 NAND3X1 $PINS Z=n_3659 A=n_3491 B=n_1301 C=n_85 VSS=VSS VDD=VDD
Xg123019 NAND3X1 $PINS Z=n_3658 A=n_3479 B=n_1083 C=n_47 VSS=VSS VDD=VDD
Xg123020 NAND3X1 $PINS Z=n_3656 A=n_3547 B=n_1136 C=n_1153 VSS=VSS VDD=VDD
Xg123021 NAND3X1 $PINS Z=n_3655 A=n_3637 B=n_3317 C=n_3535 VSS=VSS VDD=VDD
Xg123022 NAND3X1 $PINS Z=n_3654 A=n_3623 B=n_3310 C=n_1049 VSS=VSS VDD=VDD
Xg123023 NOR2X1 $PINS Z=n_3653 A=n_3531 B=n_3595 VSS=VSS VDD=VDD
Xg123024 NOR2X1 $PINS Z=n_3652 A=n_3524 B=n_3589 VSS=VSS VDD=VDD
Xg123025 NAND3X1 $PINS Z=n_3651 A=n_3621 B=n_3286 C=n_2465 VSS=VSS VDD=VDD
Xg123026 NAND3X1 $PINS Z=n_3650 A=n_3464 B=n_1733 C=n_240 VSS=VSS VDD=VDD
Xg123027 NAND3X1 $PINS Z=n_3649 A=n_3581 B=n_3379 C=n_3252 VSS=VSS VDD=VDD
Xg123028 NAND3X1 $PINS Z=n_3648 A=n_3245 B=n_3614 C=n_3246 VSS=VSS VDD=VDD
Xg123029 NAND3X1 $PINS Z=n_3647 A=n_3577 B=n_1140 C=n_1392 VSS=VSS VDD=VDD
Xg123030 NAND3X1 $PINS Z=n_3646 A=n_3492 B=n_1301 C=n_240 VSS=VSS VDD=VDD
Xg123031 NAND3X1 $PINS Z=n_3645 A=n_3485 B=n_1510 C=n_240 VSS=VSS VDD=VDD
Xg123032 NAND3X1 $PINS Z=n_3644 A=n_3447 B=n_3195 C=n_3422 VSS=VSS VDD=VDD
Xg123033 NOR2X1 $PINS Z=n_3642 A=n_3478 B=n_3570 VSS=VSS VDD=VDD
Xg123034 NAND3X1 $PINS Z=n_3641 A=n_3635 B=n_3025 C=n_3319 VSS=VSS VDD=VDD
Xg123035 NAND3X1 $PINS Z=n_3640 A=n_3476 B=n_1014 C=n_89 VSS=VSS VDD=VDD
Xg123036 NAND3X1 $PINS Z=n_3639 A=n_3566 B=n_3408 C=n_3266 VSS=VSS VDD=VDD
Xg123037 NAND3X1 $PINS Z=n_3637 A=n_3388 B=n_3018 C=csm_inst_round_counter[1]
+ VSS=VSS VDD=VDD
Xg123038 NAND3X1 $PINS Z=n_3636 A=n_3136 B=n_2740 C=n_86 VSS=VSS VDD=VDD
Xg123039 NAND2X1 $PINS Z=n_3635 A=n_3445 B=n_3184 VSS=VSS VDD=VDD
Xg123040 MUX2X1 $PINS Z=n_3634 A=n_3062 B=csm_inst_left_reg[21] S=n_20 VSS=VSS
+ VDD=VDD
Xg123041 NAND2X1 $PINS Z=n_3633 A=n_3446 B=n_89 VSS=VSS VDD=VDD
Xg123042 NAND2X1 $PINS Z=n_3632 A=n_3443 B=n_89 VSS=VSS VDD=VDD
Xg123043 NAND2X1 $PINS Z=n_3629 A=n_3449 B=n_881 VSS=VSS VDD=VDD
Xg123044 NAND2X1 $PINS Z=n_3627 A=n_3471 B=n_47 VSS=VSS VDD=VDD
Xg123045 NAND2X1 $PINS Z=n_3626 A=n_3538 B=csm_inst_mode VSS=VSS VDD=VDD
Xg123046 NAND2X1 $PINS Z=n_3625 A=n_3553 B=n_1382 VSS=VSS VDD=VDD
Xg123047 NAND2X1 $PINS Z=n_3624 A=n_3519 B=n_419 VSS=VSS VDD=VDD
Xg123048 AND2X1 $PINS Z=n_3623 A=n_3532 B=n_3383 VSS=VSS VDD=VDD
Xg123049 NOR2X1 $PINS Z=n_3622 A=n_85 B=n_3456 VSS=VSS VDD=VDD
Xg123050 NAND2X1 $PINS Z=n_3621 A=n_3522 B=csm_inst_mode VSS=VSS VDD=VDD
Xg123051 NOR2X1 $PINS Z=n_3620 A=cs_n B=n_3458 VSS=VSS VDD=VDD
Xg123052 NAND2X1 $PINS Z=n_3619 A=n_3503 B=n_1227 VSS=VSS VDD=VDD
Xg123053 NAND2X1 $PINS Z=n_3617 A=n_3539 B=n_1316 VSS=VSS VDD=VDD
Xg123054 AND2X1 $PINS Z=n_3616 A=n_3516 B=n_1588 VSS=VSS VDD=VDD
Xg123055 NAND2X1 $PINS Z=n_3615 A=n_3519 B=n_237 VSS=VSS VDD=VDD
Xg123056 NAND2X1 $PINS Z=n_3614 A=n_3454 B=csm_inst_round_counter[1] VSS=VSS
+ VDD=VDD
Xg123057 NAND2X1 $PINS Z=n_3613 A=n_3502 B=n_1175 VSS=VSS VDD=VDD
Xg123058 NAND2X1 $PINS Z=n_3612 A=n_3450 B=n_3501 VSS=VSS VDD=VDD
Xg123059 NOR2X1 $PINS Z=n_3611 A=n_3233 B=n_3545 VSS=VSS VDD=VDD
Xg123060 NAND2X1 $PINS Z=n_3610 A=n_3500 B=n_1385 VSS=VSS VDD=VDD
Xg123061 AND2X1 $PINS Z=n_3609 A=n_3542 B=n_2212 VSS=VSS VDD=VDD
Xg123062 AND2X1 $PINS Z=n_3608 A=n_3448 B=n_3209 VSS=VSS VDD=VDD
Xg123063 NAND3X1 $PINS Z=n_3605 A=n_3429 B=n_3205 C=n_47 VSS=VSS VDD=VDD
Xg123064 NAND2X1 $PINS Z=n_3604 A=n_3480 B=n_240 VSS=VSS VDD=VDD
Xg123065 NAND2X1 $PINS Z=n_3603 A=n_3477 B=n_243 VSS=VSS VDD=VDD
Xg123066 OR2X1 $PINS Z=n_3602 A=n_240 B=n_3444 VSS=VSS VDD=VDD
Xg123070 OR2X1 $PINS Z=n_3638 A=cs_n B=n_3494 VSS=VSS VDD=VDD
Xg123071 INVX2 $PINS Z=n_3601 A=n_3591 VSS=VSS VDD=VDD
Xg123072 INVX2 $PINS Z=n_3600 A=n_3569 VSS=VSS VDD=VDD
Xg123073 NAND3X1 $PINS Z=n_3599 A=n_3082 B=n_3007 C=csm_inst_round_counter[1]
+ VSS=VSS VDD=VDD
Xg123074 NOR2X1 $PINS Z=n_3598 A=n_240 B=n_3528 VSS=VSS VDD=VDD
Xg123075 NAND3X1 $PINS Z=n_3596 A=n_3543 B=n_2991 C=n_3307 VSS=VSS VDD=VDD
Xg123076 NAND3X1 $PINS Z=n_3595 A=n_1418 B=n_3305 C=n_3304 VSS=VSS VDD=VDD
Xg123077 NOR2X1 $PINS Z=n_3594 A=n_3529 B=n_3457 VSS=VSS VDD=VDD
Xg123078 NAND3X1 $PINS Z=n_3592 A=n_3294 B=n_1624 C=n_1494 VSS=VSS VDD=VDD
Xg123079 NAND3X1 $PINS Z=n_3591 A=n_3292 B=n_3424 C=n_1543 VSS=VSS VDD=VDD
Xg123080 NAND3X1 $PINS Z=n_3590 A=n_3525 B=n_1022 C=n_3290 VSS=VSS VDD=VDD
Xg123081 NAND3X1 $PINS Z=n_3589 A=n_3288 B=n_3410 C=n_1127 VSS=VSS VDD=VDD
Xg123082 NAND3X1 $PINS Z=n_3588 A=n_3550 B=n_1391 C=n_3423 VSS=VSS VDD=VDD
Xg123083 NOR2X1 $PINS Z=n_3587 A=n_3552 B=n_3521 VSS=VSS VDD=VDD
Xg123084 NAND3X1 $PINS Z=n_3586 A=n_3441 B=spi_inst_bit_cnt[6] C=n_30 VSS=VSS
+ VDD=VDD
Xg123085 NAND3X1 $PINS Z=n_3585 A=n_2477 B=n_3253 C=n_3380 VSS=VSS VDD=VDD
Xg123086 NAND3X1 $PINS Z=n_3583 A=n_3378 B=n_1424 C=n_1108 VSS=VSS VDD=VDD
Xg123087 NOR2X1 $PINS Z=n_3581 A=n_2474 B=n_3513 VSS=VSS VDD=VDD
Xg123088 NAND3X1 $PINS Z=n_3580 A=n_3248 B=n_1246 C=n_971 VSS=VSS VDD=VDD
Xg123089 NAND3X1 $PINS Z=n_3579 A=n_3230 B=n_2454 C=n_240 VSS=VSS VDD=VDD
Xg123090 NAND3X1 $PINS Z=n_3578 A=n_3231 B=n_1182 C=n_1164 VSS=VSS VDD=VDD
Xg123091 NOR2X1 $PINS Z=n_3577 A=n_3497 B=n_3498 VSS=VSS VDD=VDD
Xg123092 NAND3X1 $PINS Z=n_3576 A=n_3038 B=n_1114 C=n_1113 VSS=VSS VDD=VDD
Xg123093 NAND3X1 $PINS Z=n_3575 A=n_3482 B=n_1097 C=n_3204 VSS=VSS VDD=VDD
Xg123094 NAND3X1 $PINS Z=n_3573 A=n_3346 B=n_3392 C=n_3199 VSS=VSS VDD=VDD
Xg123095 NAND3X1 $PINS Z=n_3570 A=n_3192 B=n_1015 C=n_3345 VSS=VSS VDD=VDD
Xg123096 NAND3X1 $PINS Z=n_3569 A=n_3365 B=n_3334 C=n_3087 VSS=VSS VDD=VDD
Xg123097 NAND3X1 $PINS Z=n_3568 A=n_3186 B=n_1059 C=n_1368 VSS=VSS VDD=VDD
Xg123098 NAND3X1 $PINS Z=n_3567 A=n_3174 B=n_3155 C=n_3416 VSS=VSS VDD=VDD
Xg123099 NAND3X1 $PINS Z=n_3566 A=n_2939 B=n_3013 C=n_85 VSS=VSS VDD=VDD
Xg123100 NAND3X1 $PINS Z=n_3563 A=n_3088 B=n_1352 C=n_1367 VSS=VSS VDD=VDD
Xg123101 NAND3X1 $PINS Z=n_3562 A=n_3426 B=n_987 C=n_985 VSS=VSS VDD=VDD
Xg123102 NAND3X1 $PINS Z=n_3561 A=n_3470 B=n_3070 C=n_3364 VSS=VSS VDD=VDD
Xg123103 NAND3X1 $PINS Z=n_3559 A=n_3320 B=n_1316 C=n_1471 VSS=VSS VDD=VDD
Xg123104 NAND3X1 $PINS Z=n_3558 A=n_3045 B=n_902 C=n_901 VSS=VSS VDD=VDD
Xg123105 NAND3X1 $PINS Z=n_3557 A=n_3041 B=n_1311 C=n_1057 VSS=VSS VDD=VDD
Xg123106 MUX2X1 $PINS Z=n_3555 A=n_3085 B=csm_inst_left_reg[18] S=n_20 VSS=VSS
+ VDD=VDD
Xg123107 NAND2X1 $PINS Z=n_3553 A=n_3330 B=n_419 VSS=VSS VDD=VDD
Xg123108 NAND2X1 $PINS Z=n_3552 A=n_956 B=n_3226 VSS=VSS VDD=VDD
Xg123109 NOR2X1 $PINS Z=n_3551 A=cs_n B=n_3067 VSS=VSS VDD=VDD
Xg123110 AND2X1 $PINS Z=n_3550 A=n_3358 B=n_1019 VSS=VSS VDD=VDD
Xg123111 NAND2X1 $PINS Z=n_3549 A=n_3059 B=n_47 VSS=VSS VDD=VDD
Xg123112 NAND2X1 $PINS Z=n_3547 A=n_3325 B=n_46 VSS=VSS VDD=VDD
Xg123113 AND2X1 $PINS Z=n_3545 A=n_2889 B=n_89 VSS=VSS VDD=VDD
Xg123114 NAND2X1 $PINS Z=n_3544 A=n_3322 B=n_412 VSS=VSS VDD=VDD
Xg123115 NAND2X1 $PINS Z=n_3543 A=n_3327 B=n_412 VSS=VSS VDD=VDD
Xg123116 NAND2X1 $PINS Z=n_3542 A=n_3332 B=n_238 VSS=VSS VDD=VDD
Xg123117 NAND2X1 $PINS Z=n_3541 A=n_3327 B=n_420 VSS=VSS VDD=VDD
Xg123118 NAND2X1 $PINS Z=n_3539 A=n_3322 B=n_420 VSS=VSS VDD=VDD
Xg123119 NAND2X1 $PINS Z=n_3538 A=n_3384 B=n_2217 VSS=VSS VDD=VDD
Xg123120 AND2X1 $PINS Z=n_3537 A=n_3272 B=n_1275 VSS=VSS VDD=VDD
Xg123121 AND2X1 $PINS Z=n_3536 A=n_3381 B=n_1475 VSS=VSS VDD=VDD
Xg123122 NAND2X1 $PINS Z=n_3535 A=n_3332 B=n_237 VSS=VSS VDD=VDD
Xg123123 NAND2X1 $PINS Z=n_3533 A=n_3314 B=n_1056 VSS=VSS VDD=VDD
Xg123124 NOR2X1 $PINS Z=n_3532 A=n_2761 B=n_3031 VSS=VSS VDD=VDD
Xg123125 NAND2X1 $PINS Z=n_3531 A=n_3413 B=n_1169 VSS=VSS VDD=VDD
Xg123126 NOR2X1 $PINS Z=n_3530 A=n_3303 B=n_2506 VSS=VSS VDD=VDD
Xg123127 NAND2X1 $PINS Z=n_3529 A=n_3297 B=n_1537 VSS=VSS VDD=VDD
Xg123128 NAND3X1 $PINS Z=n_3528 A=n_2498 B=n_1847 C=n_973 VSS=VSS VDD=VDD
Xg123129 NAND2X1 $PINS Z=n_3527 A=n_3328 B=n_419 VSS=VSS VDD=VDD
Xg123130 NAND2X1 $PINS Z=n_3526 A=n_1534 B=n_3293 VSS=VSS VDD=VDD
Xg123131 NOR2X1 $PINS Z=n_3525 A=n_3382 B=n_2975 VSS=VSS VDD=VDD
Xg123132 NAND2X1 $PINS Z=n_3524 A=n_3359 B=n_1183 VSS=VSS VDD=VDD
Xg123133 NAND2X1 $PINS Z=n_3522 A=n_3280 B=n_3421 VSS=VSS VDD=VDD
Xg123134 NAND2X1 $PINS Z=n_3521 A=n_1393 B=n_3276 VSS=VSS VDD=VDD
Xg123171 INVX2 $PINS Z=n_3520 A=n_3455 VSS=VSS VDD=VDD
Xg123172 OR2X1 $PINS Z=n_3518 A=n_884 B=n_3425 VSS=VSS VDD=VDD
Xg123173 AND2X1 $PINS Z=n_3517 A=n_1573 B=n_3420 VSS=VSS VDD=VDD
Xg123174 NAND2X1 $PINS Z=n_3516 A=n_3325 B=n_237 VSS=VSS VDD=VDD
Xg123175 AND2X1 $PINS Z=n_3515 A=n_3323 B=n_419 VSS=VSS VDD=VDD
Xg123176 NAND3X1 $PINS Z=n_3514 A=n_2825 B=n_85 C=n_46 VSS=VSS VDD=VDD
Xg123177 NAND2X1 $PINS Z=n_3513 A=n_3027 B=n_1583 VSS=VSS VDD=VDD
Xg123178 NAND2X1 $PINS Z=n_3512 A=n_3330 B=n_411 VSS=VSS VDD=VDD
Xg123179 NOR2X1 $PINS Z=n_3511 A=n_1219 B=n_3244 VSS=VSS VDD=VDD
Xg123180 AND2X1 $PINS Z=n_3510 A=n_3402 B=n_1218 VSS=VSS VDD=VDD
Xg123181 AND2X1 $PINS Z=n_3509 A=n_1216 B=n_3419 VSS=VSS VDD=VDD
Xg123182 AND2X1 $PINS Z=n_3508 A=n_3243 B=n_3376 VSS=VSS VDD=VDD
Xg123183 AND2X1 $PINS Z=n_3505 A=n_3235 B=n_3234 VSS=VSS VDD=VDD
Xg123184 NAND2X1 $PINS Z=n_3503 A=n_3418 B=n_591 VSS=VSS VDD=VDD
Xg123185 NAND2X1 $PINS Z=n_3502 A=n_3229 B=n_429 VSS=VSS VDD=VDD
Xg123186 NAND2X1 $PINS Z=n_3501 A=n_3331 B=n_419 VSS=VSS VDD=VDD
Xg123187 NAND2X1 $PINS Z=n_3500 A=n_3328 B=n_411 VSS=VSS VDD=VDD
Xg123188 AND2X1 $PINS Z=n_3499 A=n_3222 B=n_3223 VSS=VSS VDD=VDD
Xg123189 NAND2X1 $PINS Z=n_3498 A=n_3221 B=n_6066 VSS=VSS VDD=VDD
Xg123190 NAND2X1 $PINS Z=n_3497 A=n_3372 B=n_1134 VSS=VSS VDD=VDD
Xg123191 OR2X1 $PINS Z=n_3494 A=spi_inst_bit_cnt[6] B=n_3441 VSS=VSS VDD=VDD
Xg123192 NOR2X1 $PINS Z=n_3492 A=n_1121 B=n_3214 VSS=VSS VDD=VDD
Xg123193 NOR2X1 $PINS Z=n_3491 A=n_1633 B=n_3211 VSS=VSS VDD=VDD
Xg123195 NAND2X1 $PINS Z=n_3489 A=n_1473 B=n_3208 VSS=VSS VDD=VDD
Xg123196 NAND2X1 $PINS Z=n_3486 A=n_3321 B=n_411 VSS=VSS VDD=VDD
Xg123197 NOR2X1 $PINS Z=n_3485 A=n_1192 B=n_3207 VSS=VSS VDD=VDD
Xg123198 NOR2X1 $PINS Z=n_3483 A=n_1098 B=n_3200 VSS=VSS VDD=VDD
Xg123199 NOR2X1 $PINS Z=n_3482 A=n_2433 B=n_3370 VSS=VSS VDD=VDD
Xg123200 NAND2X1 $PINS Z=n_3481 A=n_1092 B=n_3391 VSS=VSS VDD=VDD
Xg123201 NAND2X1 $PINS Z=n_3480 A=n_3428 B=n_1088 VSS=VSS VDD=VDD
Xg123202 NOR2X1 $PINS Z=n_3479 A=n_1244 B=n_3196 VSS=VSS VDD=VDD
Xg123203 NAND2X1 $PINS Z=n_3478 A=n_3390 B=n_1077 VSS=VSS VDD=VDD
Xg123204 NAND2X1 $PINS Z=n_3477 A=n_3267 B=n_1547 VSS=VSS VDD=VDD
Xg123205 NOR2X1 $PINS Z=n_3476 A=n_1523 B=n_3108 VSS=VSS VDD=VDD
Xg123206 NAND2X1 $PINS Z=n_3475 A=n_2966 B=n_2970 VSS=VSS VDD=VDD
Xg123207 NAND2X1 $PINS Z=n_3473 A=n_3331 B=n_411 VSS=VSS VDD=VDD
Xg123208 NAND2X1 $PINS Z=n_3472 A=n_1109 B=n_3387 VSS=VSS VDD=VDD
Xg123209 NAND2X1 $PINS Z=n_3471 A=n_3320 B=n_1413 VSS=VSS VDD=VDD
Xg123210 NOR2X1 $PINS Z=n_3470 A=n_3415 B=n_3023 VSS=VSS VDD=VDD
Xg123211 NAND2X1 $PINS Z=n_3469 A=n_3321 B=n_419 VSS=VSS VDD=VDD
Xg123212 AND2X1 $PINS Z=n_3468 A=n_913 B=n_3047 VSS=VSS VDD=VDD
Xg123213 NAND2X1 $PINS Z=n_3467 A=n_3323 B=n_411 VSS=VSS VDD=VDD
Xg123214 AND2X1 $PINS Z=n_3465 A=n_3333 B=n_3042 VSS=VSS VDD=VDD
Xg123215 NOR2X1 $PINS Z=n_3464 A=n_1554 B=n_3006 VSS=VSS VDD=VDD
Xg123216 NOR2X1 $PINS Z=n_3463 A=n_993 B=n_3037 VSS=VSS VDD=VDD
Xg123217 NAND2X1 $PINS Z=n_3462 A=n_3318 B=n_19 VSS=VSS VDD=VDD
Xg123218 NAND2X1 $PINS Z=n_3461 A=n_3202 B=n_85 VSS=VSS VDD=VDD
Xg123219 NAND2X1 $PINS Z=n_3460 A=n_3213 B=n_240 VSS=VSS VDD=VDD
Xg123220 NAND3X1 $PINS Z=n_3459 A=n_6085 B=n_928 C=n_46 VSS=VSS VDD=VDD
Xg123221 XOR2X1 $PINS Z=n_3458 A=spi_inst_bit_cnt[5] B=n_2806 VSS=VSS VDD=VDD
Xg123222 NAND3X1 $PINS Z=n_3457 A=n_1039 B=n_3412 C=n_992 VSS=VSS VDD=VDD
Xg123223 NAND3X1 $PINS Z=n_3456 A=n_3431 B=n_1267 C=n_1504 VSS=VSS VDD=VDD
Xg123224 NAND3X1 $PINS Z=n_3455 A=n_3258 B=n_911 C=n_1617 VSS=VSS VDD=VDD
Xg123225 NAND3X1 $PINS Z=n_3454 A=n_3247 B=n_1232 C=n_1240 VSS=VSS VDD=VDD
Xg123226 NAND3X1 $PINS Z=n_3450 A=n_2249 B=n_89 C=n_46 VSS=VSS VDD=VDD
Xg123227 NAND3X1 $PINS Z=n_3449 A=n_3396 B=n_1509 C=n_1161 VSS=VSS VDD=VDD
Xg123228 NAND3X1 $PINS Z=n_3448 A=n_2838 B=n_2434 C=n_83 VSS=VSS VDD=VDD
Xg123229 NAND3X1 $PINS Z=n_3447 A=n_2838 B=n_2487 C=n_420 VSS=VSS VDD=VDD
Xg123230 NAND3X1 $PINS Z=n_3446 A=n_3191 B=n_1073 C=n_1143 VSS=VSS VDD=VDD
Xg123231 NAND3X1 $PINS Z=n_3445 A=n_6064 B=n_1400 C=n_239 VSS=VSS VDD=VDD
Xg123232 NAND3X1 $PINS Z=n_3444 A=n_3180 B=n_1031 C=n_1033 VSS=VSS VDD=VDD
Xg123233 NAND3X1 $PINS Z=n_3443 A=n_3032 B=n_977 C=n_979 VSS=VSS VDD=VDD
Xg123234 MUX2X1 $PINS Z=n_3442 A=n_1308 B=n_2747 S=csm_inst_round_counter[3]
+ VSS=VSS VDD=VDD
Xg123235 NAND3X1 $PINS Z=n_3519 A=n_2518 B=n_722 C=n_539 VSS=VSS VDD=VDD
Xg123236 NAND2X1 $PINS Z=n_3440 A=n_2198 B=n_412 VSS=VSS VDD=VDD
Xg123237 NAND2X1 $PINS Z=n_3439 A=n_2712 B=n_2534 VSS=VSS VDD=VDD
Xg123238 AND2X1 $PINS Z=n_3438 A=n_2247 B=n_419 VSS=VSS VDD=VDD
Xg123239 NOR2X1 $PINS Z=n_3437 A=n_1819 B=n_2542 VSS=VSS VDD=VDD
Xg123240 NAND2X1 $PINS Z=n_3436 A=n_2369 B=n_411 VSS=VSS VDD=VDD
Xg123241 NAND2X1 $PINS Z=n_3435 A=n_2826 B=n_411 VSS=VSS VDD=VDD
Xg123242 NAND2X1 $PINS Z=n_3433 A=n_2719 B=n_2546 VSS=VSS VDD=VDD
Xg123243 NAND2X1 $PINS Z=n_3431 A=n_2358 B=n_46 VSS=VSS VDD=VDD
Xg123244 OR2X1 $PINS Z=n_3429 A=n_46 B=n_2368 VSS=VSS VDD=VDD
Xg123245 NAND2X1 $PINS Z=n_3428 A=n_2329 B=n_46 VSS=VSS VDD=VDD
Xg123246 NAND2X1 $PINS Z=n_3426 A=n_2398 B=n_46 VSS=VSS VDD=VDD
Xg123247 NOR2X1 $PINS Z=n_3425 A=start_encrypt B=n_2538 VSS=VSS VDD=VDD
Xg123248 NAND2X1 $PINS Z=n_3424 A=n_2186 B=n_456 VSS=VSS VDD=VDD
Xg123249 NAND2X1 $PINS Z=n_3423 A=n_2183 B=n_456 VSS=VSS VDD=VDD
Xg123250 NAND2X1 $PINS Z=n_3422 A=n_2196 B=n_456 VSS=VSS VDD=VDD
Xg123251 NAND2X1 $PINS Z=n_3421 A=n_2184 B=n_80 VSS=VSS VDD=VDD
Xg123252 NAND2X1 $PINS Z=n_3420 A=n_2182 B=n_80 VSS=VSS VDD=VDD
Xg123253 NAND2X1 $PINS Z=n_3419 A=n_2170 B=n_80 VSS=VSS VDD=VDD
Xg123254 NAND2X1 $PINS Z=n_3418 A=n_2168 B=n_80 VSS=VSS VDD=VDD
Xg123255 NAND2X1 $PINS Z=n_3417 A=n_2167 B=n_80 VSS=VSS VDD=VDD
Xg123256 NAND2X1 $PINS Z=n_3416 A=n_2146 B=n_80 VSS=VSS VDD=VDD
Xg123257 AND2X1 $PINS Z=n_3415 A=n_2128 B=n_80 VSS=VSS VDD=VDD
Xg123258 NAND2X1 $PINS Z=n_3413 A=n_2422 B=n_412 VSS=VSS VDD=VDD
Xg123259 NAND2X1 $PINS Z=n_3412 A=n_2362 B=n_412 VSS=VSS VDD=VDD
Xg123260 AND2X1 $PINS Z=n_3411 A=n_2383 B=n_412 VSS=VSS VDD=VDD
Xg123261 NAND2X1 $PINS Z=n_3410 A=n_2360 B=n_412 VSS=VSS VDD=VDD
Xg123262 NAND2X1 $PINS Z=n_3409 A=n_2379 B=n_412 VSS=VSS VDD=VDD
Xg123263 NAND2X1 $PINS Z=n_3408 A=n_2260 B=n_412 VSS=VSS VDD=VDD
Xg123264 AND2X1 $PINS Z=n_3407 A=n_2333 B=n_412 VSS=VSS VDD=VDD
Xg123265 AND2X1 $PINS Z=n_3406 A=n_2320 B=n_412 VSS=VSS VDD=VDD
Xg123266 NAND2X1 $PINS Z=n_3405 A=n_2419 B=n_412 VSS=VSS VDD=VDD
Xg123267 NAND2X1 $PINS Z=n_3402 A=n_2390 B=n_412 VSS=VSS VDD=VDD
Xg123268 NAND2X1 $PINS Z=n_3398 A=n_2299 B=n_412 VSS=VSS VDD=VDD
Xg123269 NAND2X1 $PINS Z=n_3397 A=n_2409 B=n_412 VSS=VSS VDD=VDD
Xg123270 NAND2X1 $PINS Z=n_3396 A=n_2400 B=n_412 VSS=VSS VDD=VDD
Xg123271 NAND2X1 $PINS Z=n_3394 A=n_2416 B=n_412 VSS=VSS VDD=VDD
Xg123272 NAND2X1 $PINS Z=n_3393 A=n_2421 B=n_412 VSS=VSS VDD=VDD
Xg123273 NAND2X1 $PINS Z=n_3392 A=n_2388 B=n_412 VSS=VSS VDD=VDD
Xg123274 NAND2X1 $PINS Z=n_3391 A=n_2326 B=n_412 VSS=VSS VDD=VDD
Xg123275 NAND2X1 $PINS Z=n_3390 A=n_2313 B=n_412 VSS=VSS VDD=VDD
Xg123276 NAND2X1 $PINS Z=n_3389 A=n_2306 B=n_412 VSS=VSS VDD=VDD
Xg123277 OR2X1 $PINS Z=n_3388 A=csm_inst_round_counter[2] B=n_2368 VSS=VSS
+ VDD=VDD
Xg123278 NAND2X1 $PINS Z=n_3387 A=n_2274 B=n_412 VSS=VSS VDD=VDD
Xg123279 NAND2X1 $PINS Z=n_3386 A=n_2251 B=n_412 VSS=VSS VDD=VDD
Xg123280 NAND2X1 $PINS Z=n_3384 A=n_2313 B=n_238 VSS=VSS VDD=VDD
Xg123281 NAND2X1 $PINS Z=n_3383 A=n_2386 B=n_238 VSS=VSS VDD=VDD
Xg123282 AND2X1 $PINS Z=n_3382 A=n_2384 B=n_238 VSS=VSS VDD=VDD
Xg123283 NAND2X1 $PINS Z=n_3381 A=n_2360 B=n_238 VSS=VSS VDD=VDD
Xg123284 NAND2X1 $PINS Z=n_3380 A=n_2415 B=n_238 VSS=VSS VDD=VDD
Xg123285 NAND2X1 $PINS Z=n_3379 A=n_2379 B=n_238 VSS=VSS VDD=VDD
Xg123286 NAND2X1 $PINS Z=n_3378 A=n_2370 B=n_238 VSS=VSS VDD=VDD
Xg123287 NAND2X1 $PINS Z=n_3377 A=n_2369 B=n_238 VSS=VSS VDD=VDD
Xg123288 NAND2X1 $PINS Z=n_3376 A=n_2304 B=n_238 VSS=VSS VDD=VDD
Xg123289 NAND2X1 $PINS Z=n_3374 A=n_2411 B=n_238 VSS=VSS VDD=VDD
Xg123290 NAND2X1 $PINS Z=n_3373 A=n_2374 B=n_238 VSS=VSS VDD=VDD
Xg123291 NAND2X1 $PINS Z=n_3372 A=n_2248 B=n_238 VSS=VSS VDD=VDD
Xg123292 NAND2X1 $PINS Z=n_3371 A=n_2326 B=n_238 VSS=VSS VDD=VDD
Xg123293 AND2X1 $PINS Z=n_3370 A=n_2317 B=n_238 VSS=VSS VDD=VDD
Xg123294 NAND2X1 $PINS Z=n_3366 A=n_2251 B=n_238 VSS=VSS VDD=VDD
Xg123295 NAND2X1 $PINS Z=n_3365 A=n_2353 B=n_238 VSS=VSS VDD=VDD
Xg123296 NAND2X1 $PINS Z=n_3364 A=n_2274 B=n_238 VSS=VSS VDD=VDD
Xg123297 NAND2X1 $PINS Z=n_3363 A=n_420 B=n_2333 VSS=VSS VDD=VDD
Xg123298 NAND2X1 $PINS Z=n_3362 A=n_420 B=n_2362 VSS=VSS VDD=VDD
Xg123299 NAND2X1 $PINS Z=n_3361 A=n_420 B=n_2409 VSS=VSS VDD=VDD
Xg123300 NAND2X1 $PINS Z=n_3360 A=n_2406 B=n_420 VSS=VSS VDD=VDD
Xg123301 NAND2X1 $PINS Z=n_3359 A=n_2419 B=n_420 VSS=VSS VDD=VDD
Xg123302 NAND2X1 $PINS Z=n_3358 A=n_420 B=n_2389 VSS=VSS VDD=VDD
Xg123303 NAND2X1 $PINS Z=n_3356 A=n_2320 B=n_420 VSS=VSS VDD=VDD
Xg123304 NAND2X1 $PINS Z=n_3353 A=n_2260 B=n_420 VSS=VSS VDD=VDD
Xg123305 NAND2X1 $PINS Z=n_3352 A=n_2301 B=n_420 VSS=VSS VDD=VDD
Xg123306 NAND2X1 $PINS Z=n_3351 A=n_420 B=n_2354 VSS=VSS VDD=VDD
Xg123307 NAND2X1 $PINS Z=n_3350 A=n_420 B=n_2382 VSS=VSS VDD=VDD
Xg123308 NAND2X1 $PINS Z=n_3349 A=n_420 B=n_2383 VSS=VSS VDD=VDD
Xg123309 AND2X1 $PINS Z=n_3348 A=n_420 B=n_2421 VSS=VSS VDD=VDD
Xg123310 NAND2X1 $PINS Z=n_3346 A=n_2422 B=n_420 VSS=VSS VDD=VDD
Xg123311 NAND2X1 $PINS Z=n_3345 A=n_420 B=n_2388 VSS=VSS VDD=VDD
Xg123312 NAND2X1 $PINS Z=n_3340 A=n_2305 B=n_420 VSS=VSS VDD=VDD
Xg123313 NAND2X1 $PINS Z=n_3338 A=n_420 B=n_2299 VSS=VSS VDD=VDD
Xg123314 NAND2X1 $PINS Z=n_3337 A=n_420 B=n_2275 VSS=VSS VDD=VDD
Xg123315 NAND2X1 $PINS Z=n_3336 A=n_420 B=n_2416 VSS=VSS VDD=VDD
Xg123316 NAND2X1 $PINS Z=n_3334 A=n_2803 B=n_1579 VSS=VSS VDD=VDD
Xg123317 NAND3X1 $PINS Z=n_3333 A=n_1469 B=n_1384 C=n_80 VSS=VSS VDD=VDD
Xg123371 NAND2X1 $PINS Z=n_3441 A=n_2808 B=spi_inst_bit_cnt[5] VSS=VSS VDD=VDD
Xg123454 NAND2X1 $PINS Z=n_3319 A=n_2305 B=n_237 VSS=VSS VDD=VDD
Xg123455 NAND2X1 $PINS Z=n_3318 A=n_1587 B=n_6065 VSS=VSS VDD=VDD
Xg123456 NAND3X1 $PINS Z=n_3317 A=n_891 B=n_1591 C=n_83 VSS=VSS VDD=VDD
Xg123457 NOR2X1 $PINS Z=n_3315 A=n_1850 B=n_2521 VSS=VSS VDD=VDD
Xg123458 NAND2X1 $PINS Z=n_3314 A=n_2337 B=n_411 VSS=VSS VDD=VDD
Xg123459 NAND2X1 $PINS Z=n_3313 A=n_2709 B=n_2520 VSS=VSS VDD=VDD
Xg123460 NAND2X1 $PINS Z=n_3311 A=n_2316 B=n_419 VSS=VSS VDD=VDD
Xg123461 NAND2X1 $PINS Z=n_3310 A=n_2301 B=n_237 VSS=VSS VDD=VDD
Xg123462 NAND2X1 $PINS Z=n_3309 A=n_2517 B=n_2516 VSS=VSS VDD=VDD
Xg123463 NAND2X1 $PINS Z=n_3308 A=n_897 B=n_2515 VSS=VSS VDD=VDD
Xg123464 NAND2X1 $PINS Z=n_3307 A=n_2511 B=n_89 VSS=VSS VDD=VDD
Xg123465 NAND2X1 $PINS Z=n_3306 A=n_2365 B=n_419 VSS=VSS VDD=VDD
Xg123466 NAND2X1 $PINS Z=n_3305 A=n_2407 B=n_411 VSS=VSS VDD=VDD
Xg123467 NAND2X1 $PINS Z=n_3304 A=n_2720 B=n_456 VSS=VSS VDD=VDD
Xg123468 AND2X1 $PINS Z=n_3303 A=n_2247 B=n_411 VSS=VSS VDD=VDD
Xg123469 NAND2X1 $PINS Z=n_3299 A=n_925 B=n_2219 VSS=VSS VDD=VDD
Xg123470 NAND2X1 $PINS Z=n_3297 A=n_419 B=n_2407 VSS=VSS VDD=VDD
Xg123471 NAND2X1 $PINS Z=n_3296 A=n_2705 B=n_2499 VSS=VSS VDD=VDD
Xg123472 NAND2X1 $PINS Z=n_3295 A=n_2353 B=n_237 VSS=VSS VDD=VDD
Xg123473 NAND3X1 $PINS Z=n_3294 A=n_1486 B=n_1334 C=csm_inst_round_counter[0]
+ VSS=VSS VDD=VDD
Xg123474 NAND2X1 $PINS Z=n_3293 A=n_2411 B=n_411 VSS=VSS VDD=VDD
Xg123475 NAND2X1 $PINS Z=n_3292 A=n_2249 B=n_237 VSS=VSS VDD=VDD
Xg123476 NAND3X1 $PINS Z=n_3291 A=n_1557 B=n_1446 C=n_440 VSS=VSS VDD=VDD
Xg123477 NAND2X1 $PINS Z=n_3290 A=n_2259 B=n_237 VSS=VSS VDD=VDD
Xg123478 NAND2X1 $PINS Z=n_3288 A=n_2830 B=n_419 VSS=VSS VDD=VDD
Xg123479 NAND2X1 $PINS Z=n_3286 A=n_2339 B=n_411 VSS=VSS VDD=VDD
Xg123480 NAND2X1 $PINS Z=n_3281 A=n_2358 B=n_411 VSS=VSS VDD=VDD
Xg123481 NAND3X1 $PINS Z=n_3280 A=n_1053 B=n_1629 C=n_83 VSS=VSS VDD=VDD
Xg123482 AND2X1 $PINS Z=n_3279 A=n_2350 B=n_411 VSS=VSS VDD=VDD
Xg123483 NAND2X1 $PINS Z=n_3278 A=n_2351 B=n_419 VSS=VSS VDD=VDD
Xg123484 NAND2X1 $PINS Z=n_3276 A=n_2357 B=n_419 VSS=VSS VDD=VDD
Xg123485 AND2X1 $PINS Z=n_3274 A=n_2302 B=n_419 VSS=VSS VDD=VDD
Xg123486 NAND2X1 $PINS Z=n_3273 A=n_2830 B=n_411 VSS=VSS VDD=VDD
Xg123487 NAND2X1 $PINS Z=n_3272 A=n_2126 B=n_83 VSS=VSS VDD=VDD
Xg123488 NAND2X1 $PINS Z=n_3270 A=n_2643 B=n_2798 VSS=VSS VDD=VDD
Xg123489 NAND3X1 $PINS Z=n_3267 A=n_445 B=n_1470 C=n_1383 VSS=VSS VDD=VDD
Xg123490 NAND2X1 $PINS Z=n_3266 A=n_2485 B=n_89 VSS=VSS VDD=VDD
Xg123491 NAND2X1 $PINS Z=n_3263 A=n_2351 B=n_411 VSS=VSS VDD=VDD
Xg123492 NAND2X1 $PINS Z=n_3262 A=n_2370 B=n_411 VSS=VSS VDD=VDD
Xg123493 NAND2X1 $PINS Z=n_3258 A=n_2812 B=n_412 VSS=VSS VDD=VDD
Xg123494 NAND2X1 $PINS Z=n_3257 A=n_419 B=n_2371 VSS=VSS VDD=VDD
Xg123495 AND2X1 $PINS Z=n_3254 A=n_2478 B=n_80 VSS=VSS VDD=VDD
Xg123496 NAND2X1 $PINS Z=n_3253 A=n_2316 B=n_237 VSS=VSS VDD=VDD
Xg123497 NAND2X1 $PINS Z=n_3252 A=n_2374 B=n_237 VSS=VSS VDD=VDD
Xg123498 NAND3X1 $PINS Z=n_3251 A=n_1271 B=n_1638 C=n_83 VSS=VSS VDD=VDD
Xg123499 NAND2X1 $PINS Z=n_3249 A=n_2673 B=n_2468 VSS=VSS VDD=VDD
Xg123500 NAND3X1 $PINS Z=n_3248 A=n_1245 B=n_1243 C=csm_inst_round_counter[0]
+ VSS=VSS VDD=VDD
Xg123501 NAND3X1 $PINS Z=n_3247 A=n_917 B=n_1230 C=n_14 VSS=VSS VDD=VDD
Xg123502 NAND2X1 $PINS Z=n_3246 A=n_2357 B=n_237 VSS=VSS VDD=VDD
Xg123503 NAND3X1 $PINS Z=n_3245 A=n_1225 B=n_1226 C=n_83 VSS=VSS VDD=VDD
Xg123504 NOR2X1 $PINS Z=n_3244 A=n_1307 B=n_2466 VSS=VSS VDD=VDD
Xg123505 NAND2X1 $PINS Z=n_3243 A=n_2346 B=n_237 VSS=VSS VDD=VDD
Xg123506 NAND2X1 $PINS Z=n_3242 A=n_2339 B=n_419 VSS=VSS VDD=VDD
Xg123507 NAND2X1 $PINS Z=n_3241 A=n_2829 B=n_420 VSS=VSS VDD=VDD
Xg123508 NAND2X1 $PINS Z=n_3240 A=n_2169 B=n_457 VSS=VSS VDD=VDD
Xg123509 NAND2X1 $PINS Z=n_3239 A=n_2464 B=n_19 VSS=VSS VDD=VDD
Xg123510 NAND2X1 $PINS Z=n_3235 A=n_2300 B=n_419 VSS=VSS VDD=VDD
Xg123511 NAND2X1 $PINS Z=n_3234 A=n_2302 B=n_411 VSS=VSS VDD=VDD
Xg123512 NOR2X1 $PINS Z=n_3233 A=n_1187 B=n_2463 VSS=VSS VDD=VDD
Xg123513 NAND3X1 $PINS Z=n_3232 A=n_1185 B=n_1135 C=n_440 VSS=VSS VDD=VDD
Xg123514 NAND2X1 $PINS Z=n_3231 A=n_2833 B=n_46 VSS=VSS VDD=VDD
Xg123515 OR2X1 $PINS Z=n_3230 A=csm_inst_round_counter[2] B=n_2337 VSS=VSS
+ VDD=VDD
Xg123516 NAND2X1 $PINS Z=n_3229 A=n_2248 B=n_237 VSS=VSS VDD=VDD
Xg123518 NAND2X1 $PINS Z=n_3227 A=n_2833 B=n_412 VSS=VSS VDD=VDD
Xg123519 NAND2X1 $PINS Z=n_3226 A=n_2531 B=n_240 VSS=VSS VDD=VDD
Xg123520 NAND2X1 $PINS Z=n_3225 A=n_2346 B=n_419 VSS=VSS VDD=VDD
Xg123521 AND2X1 $PINS Z=n_3224 A=n_2371 B=n_411 VSS=VSS VDD=VDD
Xg123522 NAND2X1 $PINS Z=n_3223 A=n_2382 B=n_237 VSS=VSS VDD=VDD
Xg123523 NAND3X1 $PINS Z=n_3222 A=n_1200 B=n_1142 C=n_83 VSS=VSS VDD=VDD
Xg123524 NAND2X1 $PINS Z=n_3221 A=n_2384 B=n_237 VSS=VSS VDD=VDD
Xg123525 NAND2X1 $PINS Z=n_3220 A=n_2829 B=n_237 VSS=VSS VDD=VDD
Xg123526 NAND2X1 $PINS Z=n_3219 A=n_2649 B=n_2446 VSS=VSS VDD=VDD
Xg123527 NAND2X1 $PINS Z=n_3218 A=n_2386 B=n_237 VSS=VSS VDD=VDD
Xg123528 NAND2X1 $PINS Z=n_3217 A=n_2332 B=n_411 VSS=VSS VDD=VDD
Xg123529 NAND2X1 $PINS Z=n_3216 A=n_2329 B=n_411 VSS=VSS VDD=VDD
Xg123530 AND2X1 $PINS Z=n_3215 A=n_2199 B=n_1124 VSS=VSS VDD=VDD
Xg123531 NOR2X1 $PINS Z=n_3214 A=csm_inst_round_counter[2] B=n_2245 VSS=VSS
+ VDD=VDD
Xg123532 NAND2X1 $PINS Z=n_3213 A=n_2835 B=n_1120 VSS=VSS VDD=VDD
Xg123533 NAND2X1 $PINS Z=n_3212 A=n_2332 B=n_419 VSS=VSS VDD=VDD
Xg123534 NOR2X1 $PINS Z=n_3211 A=n_768 B=n_2444 VSS=VSS VDD=VDD
Xg123535 NAND2X1 $PINS Z=n_3210 A=n_2804 B=n_1111 VSS=VSS VDD=VDD
Xg123536 NAND2X1 $PINS Z=n_3209 A=n_2190 B=n_237 VSS=VSS VDD=VDD
Xg123537 NAND2X1 $PINS Z=n_3208 A=n_2204 B=n_420 VSS=VSS VDD=VDD
Xg123538 NOR2X1 $PINS Z=n_3207 A=csm_inst_round_counter[2] B=n_2811 VSS=VSS
+ VDD=VDD
Xg123540 NAND2X1 $PINS Z=n_3205 A=n_2439 B=n_1285 VSS=VSS VDD=VDD
Xg123541 NAND2X1 $PINS Z=n_3204 A=n_2365 B=n_237 VSS=VSS VDD=VDD
Xg123542 NAND2X1 $PINS Z=n_3203 A=n_2505 B=n_1096 VSS=VSS VDD=VDD
Xg123543 NAND2X1 $PINS Z=n_3202 A=n_2835 B=n_1093 VSS=VSS VDD=VDD
Xg123544 AND2X1 $PINS Z=n_3201 A=n_2429 B=n_243 VSS=VSS VDD=VDD
Xg123545 NOR2X1 $PINS Z=n_3200 A=n_1572 B=n_2236 VSS=VSS VDD=VDD
Xg123546 NAND2X1 $PINS Z=n_3199 A=n_2436 B=n_89 VSS=VSS VDD=VDD
Xg123547 NAND2X1 $PINS Z=n_3198 A=n_2250 B=n_411 VSS=VSS VDD=VDD
Xg123548 NAND2X1 $PINS Z=n_3197 A=n_2440 B=n_240 VSS=VSS VDD=VDD
Xg123549 NOR2X1 $PINS Z=n_3196 A=n_748 B=n_2459 VSS=VSS VDD=VDD
Xg123550 NAND3X1 $PINS Z=n_3195 A=n_1081 B=n_1082 C=n_83 VSS=VSS VDD=VDD
Xg123551 NAND2X1 $PINS Z=n_3194 A=n_2802 B=n_1577 VSS=VSS VDD=VDD
Xg123552 AND2X1 $PINS Z=n_3193 A=n_2317 B=n_411 VSS=VSS VDD=VDD
Xg123553 NAND2X1 $PINS Z=n_3192 A=n_2826 B=n_419 VSS=VSS VDD=VDD
Xg123554 NAND3X1 $PINS Z=n_3191 A=n_445 B=n_1397 C=n_1069 VSS=VSS VDD=VDD
Xg123555 NAND2X1 $PINS Z=n_3190 A=n_2544 B=n_1775 VSS=VSS VDD=VDD
Xg123556 NAND2X1 $PINS Z=n_3189 A=n_2772 B=n_1771 VSS=VSS VDD=VDD
Xg123557 NAND2X1 $PINS Z=n_3188 A=n_2312 B=n_411 VSS=VSS VDD=VDD
Xg123558 NAND2X1 $PINS Z=n_3187 A=n_2310 B=n_419 VSS=VSS VDD=VDD
Xg123559 NAND3X1 $PINS Z=n_3186 A=n_1048 B=n_1054 C=n_14 VSS=VSS VDD=VDD
Xg123560 NOR2X1 $PINS Z=n_3185 A=n_1767 B=n_2623 VSS=VSS VDD=VDD
Xg123561 OR2X1 $PINS Z=n_3184 A=csm_inst_round_counter[2] B=n_2306 VSS=VSS
+ VDD=VDD
Xg123562 NAND2X1 $PINS Z=n_3183 A=n_2415 B=n_411 VSS=VSS VDD=VDD
Xg123563 NAND2X1 $PINS Z=n_3182 A=n_2710 B=n_2527 VSS=VSS VDD=VDD
Xg123564 NAND2X1 $PINS Z=n_3181 A=n_2622 B=n_2721 VSS=VSS VDD=VDD
Xg123565 NAND3X1 $PINS Z=n_3180 A=n_1026 B=n_909 C=csm_inst_round_counter[2]
+ VSS=VSS VDD=VDD
Xg123566 NAND2X1 $PINS Z=n_3179 A=n_2310 B=n_411 VSS=VSS VDD=VDD
Xg123567 NAND2X1 $PINS Z=n_3178 A=n_2350 B=n_419 VSS=VSS VDD=VDD
Xg123568 NAND2X1 $PINS Z=n_3177 A=n_2620 B=n_2736 VSS=VSS VDD=VDD
Xg123569 NAND3X1 $PINS Z=n_3174 A=n_1457 B=n_1025 C=n_83 VSS=VSS VDD=VDD
Xg123570 NAND2X1 $PINS Z=n_3155 A=n_2389 B=n_237 VSS=VSS VDD=VDD
Xg123571 NAND2X1 $PINS Z=n_3143 A=n_2616 B=n_2450 VSS=VSS VDD=VDD
Xg123572 NAND3X1 $PINS Z=n_3136 A=n_445 B=n_1362 C=n_1012 VSS=VSS VDD=VDD
Xg123573 AND2X1 $PINS Z=n_3130 A=n_2304 B=n_411 VSS=VSS VDD=VDD
Xg123574 NAND2X1 $PINS Z=n_3114 A=n_2312 B=n_419 VSS=VSS VDD=VDD
Xg123575 NOR2X1 $PINS Z=n_3108 A=csm_inst_round_counter[2] B=n_2390 VSS=VSS
+ VDD=VDD
Xg123576 NAND2X1 $PINS Z=n_3103 A=n_2482 B=n_1799 VSS=VSS VDD=VDD
Xg123577 NAND2X1 $PINS Z=n_3102 A=n_2300 B=n_411 VSS=VSS VDD=VDD
Xg123578 NAND2X1 $PINS Z=n_3100 A=n_419 B=n_2286 VSS=VSS VDD=VDD
Xg123579 NAND2X1 $PINS Z=n_3096 A=n_2596 B=n_2755 VSS=VSS VDD=VDD
Xg123580 NOR2X1 $PINS Z=n_3094 A=cs_n B=n_2238 VSS=VSS VDD=VDD
Xg123581 NAND2X1 $PINS Z=n_3088 A=n_2275 B=csm_inst_round_counter[2] VSS=VSS
+ VDD=VDD
Xg123582 NAND2X1 $PINS Z=n_3087 A=n_2354 B=n_237 VSS=VSS VDD=VDD
Xg123583 OR2X1 $PINS Z=n_3085 A=n_1779 B=n_2805 VSS=VSS VDD=VDD
Xg123584 NAND3X1 $PINS Z=n_3083 A=n_982 B=n_1095 C=n_83 VSS=VSS VDD=VDD
Xg123585 OR2X1 $PINS Z=n_3082 A=csm_inst_round_counter[2] B=n_2400 VSS=VSS
+ VDD=VDD
Xg123586 NOR2X1 $PINS Z=n_3078 A=n_2757 B=n_2593 VSS=VSS VDD=VDD
Xg123587 NAND2X1 $PINS Z=n_3074 A=n_2398 B=n_411 VSS=VSS VDD=VDD
Xg123588 NAND2X1 $PINS Z=n_3073 A=n_2259 B=n_419 VSS=VSS VDD=VDD
Xg123589 NAND2X1 $PINS Z=n_3070 A=n_2406 B=n_237 VSS=VSS VDD=VDD
Xg123590 NAND2X1 $PINS Z=n_3068 A=n_2764 B=n_1801 VSS=VSS VDD=VDD
Xg123591 XOR2X1 $PINS Z=n_3067 A=spi_inst_bit_cnt[4] B=n_1830 VSS=VSS VDD=VDD
Xg123592 OR2X1 $PINS Z=n_3062 A=n_1745 B=n_2578 VSS=VSS VDD=VDD
Xg123593 NAND2X1 $PINS Z=n_3061 A=n_2575 B=n_2767 VSS=VSS VDD=VDD
Xg123594 NAND3X1 $PINS Z=n_3059 A=n_883 B=n_887 C=n_1340 VSS=VSS VDD=VDD
Xg123595 AND2X1 $PINS Z=n_3055 A=n_2773 B=n_243 VSS=VSS VDD=VDD
Xg123596 NAND2X1 $PINS Z=n_3051 A=n_2775 B=n_1739 VSS=VSS VDD=VDD
Xg123597 NAND2X1 $PINS Z=n_3047 A=n_2286 B=n_411 VSS=VSS VDD=VDD
Xg123598 NAND2X1 $PINS Z=n_3046 A=n_2566 B=n_2778 VSS=VSS VDD=VDD
Xg123599 NAND2X1 $PINS Z=n_3045 A=n_2783 B=n_440 VSS=VSS VDD=VDD
Xg123600 NOR2X1 $PINS Z=n_3044 A=n_1793 B=n_2559 VSS=VSS VDD=VDD
Xg123601 OR2X1 $PINS Z=n_3043 A=n_85 B=n_2250 VSS=VSS VDD=VDD
Xg123602 NAND2X1 $PINS Z=n_3042 A=n_2812 B=n_238 VSS=VSS VDD=VDD
Xg123603 NAND2X1 $PINS Z=n_3041 A=n_2245 B=csm_inst_round_counter[2] VSS=VSS
+ VDD=VDD
Xg123604 NAND2X1 $PINS Z=n_3040 A=n_2552 B=n_2788 VSS=VSS VDD=VDD
Xg123605 NOR2X1 $PINS Z=n_3039 A=n_2749 B=n_0 VSS=VSS VDD=VDD
Xg123606 NAND2X1 $PINS Z=n_3038 A=n_2791 B=n_1179 VSS=VSS VDD=VDD
Xg123607 NOR2X1 $PINS Z=n_3037 A=n_991 B=n_2796 VSS=VSS VDD=VDD
Xg123608 NAND2X1 $PINS Z=n_3032 A=n_2797 B=n_972 VSS=VSS VDD=VDD
Xg123609 NOR2X1 $PINS Z=n_3031 A=n_2512 B=n_1032 VSS=VSS VDD=VDD
Xg123610 NAND2X1 $PINS Z=n_3028 A=n_2492 B=n_1085 VSS=VSS VDD=VDD
Xg123611 NAND2X1 $PINS Z=n_3027 A=n_2470 B=n_1253 VSS=VSS VDD=VDD
Xg123612 NAND2X1 $PINS Z=n_3025 A=n_2722 B=n_1045 VSS=VSS VDD=VDD
Xg123613 NOR2X1 $PINS Z=n_3023 A=n_2765 B=n_931 VSS=VSS VDD=VDD
Xg123614 NAND2X1 $PINS Z=n_3021 A=n_2811 B=n_411 VSS=VSS VDD=VDD
Xg123615 NAND2X1 $PINS Z=n_3018 A=n_2234 B=n_765 VSS=VSS VDD=VDD
Xg123616 NAND2X1 $PINS Z=n_3013 A=n_2231 B=n_1302 VSS=VSS VDD=VDD
Xg123617 NAND2X1 $PINS Z=n_3007 A=n_2229 B=n_763 VSS=VSS VDD=VDD
Xg123618 NOR2X1 $PINS Z=n_3006 A=n_798 B=n_2233 VSS=VSS VDD=VDD
Xg123619 NAND3X1 $PINS Z=n_3003 A=n_762 B=n_83 C=csm_inst_mode VSS=VSS VDD=VDD
Xg123620 NAND2X1 $PINS Z=n_3000 A=n_2218 B=n_1017 VSS=VSS VDD=VDD
Xg123621 NOR2X1 $PINS Z=n_2994 A=n_414 B=n_2425 VSS=VSS VDD=VDD
Xg123622 NAND2X1 $PINS Z=n_2991 A=n_2428 B=n_420 VSS=VSS VDD=VDD
Xg123623 NAND3X1 $PINS Z=n_2990 A=n_2561 B=n_1728 C=n_1738 VSS=VSS VDD=VDD
Xg123624 NAND3X1 $PINS Z=n_2989 A=n_2713 B=n_1668 C=n_1818 VSS=VSS VDD=VDD
Xg123625 NAND3X1 $PINS Z=n_2988 A=n_2569 B=n_1723 C=n_1816 VSS=VSS VDD=VDD
Xg123626 NAND3X1 $PINS Z=n_2986 A=n_2704 B=n_1720 C=n_1812 VSS=VSS VDD=VDD
Xg123627 NAND3X1 $PINS Z=n_2985 A=n_2708 B=n_1680 C=n_1809 VSS=VSS VDD=VDD
Xg123628 NAND3X1 $PINS Z=n_2984 A=n_2576 B=n_1669 C=n_1740 VSS=VSS VDD=VDD
Xg123629 NAND3X1 $PINS Z=n_2983 A=n_2692 B=n_1711 C=n_1803 VSS=VSS VDD=VDD
Xg123630 NAND3X1 $PINS Z=n_2982 A=n_2707 B=n_1719 C=n_1808 VSS=VSS VDD=VDD
Xg123631 NAND3X1 $PINS Z=n_2981 A=n_2611 B=n_1710 C=n_1744 VSS=VSS VDD=VDD
Xg123632 NAND3X1 $PINS Z=n_2980 A=n_2594 B=n_1645 C=n_1748 VSS=VSS VDD=VDD
Xg123633 NAND3X1 $PINS Z=n_2979 A=n_2615 B=n_1705 C=n_1802 VSS=VSS VDD=VDD
Xg123634 NAND3X1 $PINS Z=n_2978 A=n_1269 B=n_924 C=n_19 VSS=VSS VDD=VDD
Xg123635 NAND3X1 $PINS Z=n_2976 A=n_2697 B=n_1715 C=n_1804 VSS=VSS VDD=VDD
Xg123636 NAND3X1 $PINS Z=n_2975 A=n_1435 B=n_1052 C=n_6063 VSS=VSS VDD=VDD
Xg123637 NAND3X1 $PINS Z=n_2974 A=n_2696 B=n_1722 C=n_1815 VSS=VSS VDD=VDD
Xg123638 NAND3X1 $PINS Z=n_2973 A=n_2685 B=n_1642 C=n_1743 VSS=VSS VDD=VDD
Xg123639 NAND3X1 $PINS Z=n_2970 A=n_1138 B=n_1440 C=csm_inst_mode VSS=VSS
+ VDD=VDD
Xg123640 NAND3X1 $PINS Z=n_2966 A=n_1338 B=n_1608 C=n_87 VSS=VSS VDD=VDD
Xg123641 NAND3X1 $PINS Z=n_2940 A=n_2598 B=n_1702 C=n_1750 VSS=VSS VDD=VDD
Xg123642 NAND3X1 $PINS Z=n_2939 A=n_1317 B=n_751 C=n_46 VSS=VSS VDD=VDD
Xg123643 NAND3X1 $PINS Z=n_2938 A=n_2678 B=n_1700 C=n_1798 VSS=VSS VDD=VDD
Xg123644 NAND3X1 $PINS Z=n_2905 A=n_2677 B=n_1693 C=n_1795 VSS=VSS VDD=VDD
Xg123645 NAND3X1 $PINS Z=n_2904 A=n_2676 B=n_1695 C=n_1796 VSS=VSS VDD=VDD
Xg123646 NAND3X1 $PINS Z=n_2902 A=n_2672 B=n_1692 C=n_1794 VSS=VSS VDD=VDD
Xg123647 NAND3X1 $PINS Z=n_2899 A=n_994 B=n_1560 C=n_241 VSS=VSS VDD=VDD
Xg123648 NAND3X1 $PINS Z=n_2897 A=n_2668 B=n_1679 C=n_1788 VSS=VSS VDD=VDD
Xg123649 NAND3X1 $PINS Z=n_2890 A=n_2667 B=n_1688 C=n_1789 VSS=VSS VDD=VDD
Xg123650 NAND3X1 $PINS Z=n_2889 A=n_1177 B=n_1172 C=n_1174 VSS=VSS VDD=VDD
Xg123651 NAND3X1 $PINS Z=n_2888 A=n_2660 B=n_1682 C=n_1786 VSS=VSS VDD=VDD
Xg123652 NAND3X1 $PINS Z=n_2886 A=n_2655 B=n_1674 C=n_1784 VSS=VSS VDD=VDD
Xg123653 NAND3X1 $PINS Z=n_2885 A=n_2650 B=n_1677 C=n_1785 VSS=VSS VDD=VDD
Xg123654 NAND3X1 $PINS Z=n_2884 A=n_2645 B=n_1672 C=n_1772 VSS=VSS VDD=VDD
Xg123655 NAND3X1 $PINS Z=n_2875 A=n_2684 B=n_1696 C=n_1797 VSS=VSS VDD=VDD
Xg123656 NAND3X1 $PINS Z=n_2874 A=n_2648 B=n_1676 C=n_1782 VSS=VSS VDD=VDD
Xg123657 NAND3X1 $PINS Z=n_2860 A=n_2647 B=n_1671 C=n_1778 VSS=VSS VDD=VDD
Xg123658 NAND3X1 $PINS Z=n_2844 A=n_2562 B=n_1706 C=n_1749 VSS=VSS VDD=VDD
Xg123659 NAND3X1 $PINS Z=n_2843 A=n_2636 B=n_1727 C=n_1806 VSS=VSS VDD=VDD
Xg123660 NAND3X1 $PINS Z=n_2840 A=n_2621 B=n_1664 C=n_1760 VSS=VSS VDD=VDD
Xg123661 NAND3X1 $PINS Z=n_2839 A=n_2610 B=n_1707 C=n_1758 VSS=VSS VDD=VDD
Xg123662 NAND3X1 $PINS Z=n_3332 A=n_1197 B=n_735 C=n_584 VSS=VSS VDD=VDD
Xg123663 NAND3X1 $PINS Z=n_3331 A=n_1381 B=n_560 C=n_574 VSS=VSS VDD=VDD
Xg123664 NAND3X1 $PINS Z=n_3330 A=n_1206 B=n_725 C=n_377 VSS=VSS VDD=VDD
Xg123665 NAND3X1 $PINS Z=n_3328 A=n_908 B=n_572 C=n_564 VSS=VSS VDD=VDD
Xg123666 NAND3X1 $PINS Z=n_3327 A=n_1575 B=n_722 C=n_387 VSS=VSS VDD=VDD
Xg123667 NAND3X1 $PINS Z=n_3325 A=n_906 B=n_735 C=n_582 VSS=VSS VDD=VDD
Xg123668 NAND3X1 $PINS Z=n_3323 A=n_907 B=n_541 C=n_571 VSS=VSS VDD=VDD
Xg123669 NAND3X1 $PINS Z=n_3322 A=n_1626 B=n_725 C=n_573 VSS=VSS VDD=VDD
Xg123670 NAND2X1 $PINS Z=n_3321 A=n_2817 B=n_1178 VSS=VSS VDD=VDD
Xg123671 NAND3X1 $PINS Z=n_3320 A=n_442 B=n_1342 C=n_929 VSS=VSS VDD=VDD
Xg123672 INVX2 $PINS Z=n_2825 A=n_2817 VSS=VSS VDD=VDD
Xg123673 INVX2 $PINS Z=n_2808 A=n_2806 VSS=VSS VDD=VDD
Xg123674 NOR2X1 $PINS Z=n_2805 A=data_reg[45] B=n_1282 VSS=VSS VDD=VDD
Xg123675 NAND2X1 $PINS Z=n_2804 A=n_435 B=n_1110 VSS=VSS VDD=VDD
Xg123676 NAND2X1 $PINS Z=n_2803 A=n_435 B=n_1584 VSS=VSS VDD=VDD
Xg123677 NAND2X1 $PINS Z=n_2802 A=n_435 B=n_1074 VSS=VSS VDD=VDD
Xg123678 NAND2X1 $PINS Z=n_2798 A=n_1582 B=n_21 VSS=VSS VDD=VDD
Xg123679 NAND2X1 $PINS Z=n_2797 A=n_963 B=n_71 VSS=VSS VDD=VDD
Xg123680 NOR2X1 $PINS Z=n_2796 A=n_70 B=n_1561 VSS=VSS VDD=VDD
Xg123681 NAND2X1 $PINS Z=n_2791 A=n_1530 B=n_71 VSS=VSS VDD=VDD
Xg123682 NAND2X1 $PINS Z=n_2788 A=n_1415 B=n_21 VSS=VSS VDD=VDD
Xg123683 AND2X1 $PINS Z=n_2786 A=n_1064 B=n_1065 VSS=VSS VDD=VDD
Xg123684 NAND2X1 $PINS Z=n_2783 A=n_1317 B=n_749 VSS=VSS VDD=VDD
Xg123685 NAND2X1 $PINS Z=n_2778 A=n_1828 B=n_21 VSS=VSS VDD=VDD
Xg123686 NAND2X1 $PINS Z=n_2775 A=n_27 B=n_1565 VSS=VSS VDD=VDD
Xg123687 NAND2X1 $PINS Z=n_2773 A=n_886 B=n_914 VSS=VSS VDD=VDD
Xg123688 NAND2X1 $PINS Z=n_2772 A=n_27 B=n_1571 VSS=VSS VDD=VDD
Xg123689 NOR2X1 $PINS Z=n_2769 A=n_86 B=n_1313 VSS=VSS VDD=VDD
Xg123690 NAND2X1 $PINS Z=n_2767 A=n_1569 B=n_21 VSS=VSS VDD=VDD
Xg123691 NOR2X1 $PINS Z=n_2766 A=cs_n B=n_1281 VSS=VSS VDD=VDD
Xg123692 AND2X1 $PINS Z=n_2765 A=n_591 B=n_930 VSS=VSS VDD=VDD
Xg123693 NAND2X1 $PINS Z=n_2764 A=n_27 B=n_947 VSS=VSS VDD=VDD
Xg123694 NOR2X1 $PINS Z=n_2761 A=n_78 B=n_753 VSS=VSS VDD=VDD
Xg123695 AND2X1 $PINS Z=n_2757 A=n_1426 B=n_21 VSS=VSS VDD=VDD
Xg123696 NAND2X1 $PINS Z=n_2755 A=n_1344 B=n_21 VSS=VSS VDD=VDD
Xg123697 NAND2X1 $PINS Z=n_2751 A=n_1339 B=n_1545 VSS=VSS VDD=VDD
Xg123698 AND2X1 $PINS Z=n_2749 A=n_440 B=n_1310 VSS=VSS VDD=VDD
Xg123699 NAND2X1 $PINS Z=n_2748 A=n_1824 B=n_1428 VSS=VSS VDD=VDD
Xg123700 NAND2X1 $PINS Z=n_2747 A=n_1639 B=n_637 VSS=VSS VDD=VDD
Xg123701 NAND2X1 $PINS Z=n_2744 A=n_1348 B=n_1592 VSS=VSS VDD=VDD
Xg123702 AND2X1 $PINS Z=n_2740 A=n_1228 B=n_920 VSS=VSS VDD=VDD
Xg123703 NAND2X1 $PINS Z=n_2736 A=n_1618 B=n_21 VSS=VSS VDD=VDD
Xg123704 NAND2X1 $PINS Z=n_2726 A=n_1314 B=n_243 VSS=VSS VDD=VDD
Xg123705 AND2X1 $PINS Z=n_2724 A=n_1034 B=n_1036 VSS=VSS VDD=VDD
Xg123707 NAND2X1 $PINS Z=n_2722 A=n_591 B=n_1038 VSS=VSS VDD=VDD
Xg123708 NAND2X1 $PINS Z=n_2721 A=n_1046 B=n_21 VSS=VSS VDD=VDD
Xg123709 NAND2X1 $PINS Z=n_2720 A=n_1844 B=n_750 VSS=VSS VDD=VDD
Xg123710 OR2X1 $PINS Z=n_2719 A=data_reg[39] B=n_1282 VSS=VSS VDD=VDD
Xg123711 NAND2X1 $PINS Z=n_2713 A=n_1282 B=csm_inst_left_reg[16] VSS=VSS
+ VDD=VDD
Xg123712 OR2X1 $PINS Z=n_2712 A=data_reg[23] B=n_1282 VSS=VSS VDD=VDD
Xg123713 OR2X1 $PINS Z=n_2710 A=data_reg[15] B=n_1282 VSS=VSS VDD=VDD
Xg123714 OR2X1 $PINS Z=n_2709 A=data_reg[7] B=n_1282 VSS=VSS VDD=VDD
Xg123715 NAND2X1 $PINS Z=n_2708 A=n_1282 B=csm_inst_left_reg[17] VSS=VSS
+ VDD=VDD
Xg123716 NAND2X1 $PINS Z=n_2707 A=n_1282 B=csm_inst_left_reg[18] VSS=VSS
+ VDD=VDD
Xg123717 OR2X1 $PINS Z=n_2705 A=data_reg[25] B=n_1282 VSS=VSS VDD=VDD
Xg123718 NAND2X1 $PINS Z=n_2704 A=n_1282 B=csm_inst_left_reg[2] VSS=VSS VDD=VDD
Xg123719 NAND2X1 $PINS Z=n_2703 A=n_1282 B=csm_inst_right_reg[1] VSS=VSS
+ VDD=VDD
Xg123720 NAND2X1 $PINS Z=n_2697 A=n_1282 B=csm_inst_left_reg[20] VSS=VSS
+ VDD=VDD
Xg123721 NAND2X1 $PINS Z=n_2696 A=n_1282 B=csm_inst_left_reg[21] VSS=VSS
+ VDD=VDD
Xg123722 NAND2X1 $PINS Z=n_2692 A=n_1282 B=csm_inst_left_reg[3] VSS=VSS VDD=VDD
Xg123723 NAND2X1 $PINS Z=n_2685 A=n_1282 B=csm_inst_left_reg[22] VSS=VSS
+ VDD=VDD
Xg123724 NAND2X1 $PINS Z=n_2684 A=n_1282 B=csm_inst_left_reg[24] VSS=VSS
+ VDD=VDD
Xg123725 NAND2X1 $PINS Z=n_2681 A=n_1282 B=csm_inst_right_reg[0] VSS=VSS
+ VDD=VDD
Xg123726 NAND2X1 $PINS Z=n_2678 A=n_1282 B=csm_inst_left_reg[5] VSS=VSS VDD=VDD
Xg123727 NAND2X1 $PINS Z=n_2677 A=n_1282 B=csm_inst_left_reg[6] VSS=VSS VDD=VDD
Xg123728 NAND2X1 $PINS Z=n_2676 A=n_1282 B=csm_inst_left_reg[25] VSS=VSS
+ VDD=VDD
Xg123729 OR2X1 $PINS Z=n_2673 A=data_reg[9] B=n_1282 VSS=VSS VDD=VDD
Xg123730 NAND2X1 $PINS Z=n_2672 A=n_1282 B=csm_inst_left_reg[26] VSS=VSS
+ VDD=VDD
Xg123731 NAND2X1 $PINS Z=n_2668 A=n_1282 B=csm_inst_left_reg[7] VSS=VSS VDD=VDD
Xg123732 NAND2X1 $PINS Z=n_2667 A=n_1282 B=csm_inst_left_reg[27] VSS=VSS
+ VDD=VDD
Xg123733 NAND2X1 $PINS Z=n_2660 A=n_1282 B=csm_inst_left_reg[28] VSS=VSS
+ VDD=VDD
Xg123734 NAND2X1 $PINS Z=n_2655 A=n_1282 B=csm_inst_left_reg[8] VSS=VSS VDD=VDD
Xg123735 NAND2X1 $PINS Z=n_2650 A=n_1282 B=csm_inst_left_reg[29] VSS=VSS
+ VDD=VDD
Xg123736 OR2X1 $PINS Z=n_2649 A=data_reg[1] B=n_1282 VSS=VSS VDD=VDD
Xg123737 NAND2X1 $PINS Z=n_2648 A=n_1282 B=csm_inst_left_reg[30] VSS=VSS
+ VDD=VDD
Xg123738 NAND2X1 $PINS Z=n_2647 A=n_1282 B=csm_inst_left_reg[31] VSS=VSS
+ VDD=VDD
Xg123739 NAND2X1 $PINS Z=n_2645 A=n_1282 B=csm_inst_left_reg[9] VSS=VSS VDD=VDD
Xg123740 OR2X1 $PINS Z=n_2643 A=data_reg[17] B=n_1282 VSS=VSS VDD=VDD
Xg123741 NAND2X1 $PINS Z=n_2636 A=n_1282 B=csm_inst_left_reg[10] VSS=VSS
+ VDD=VDD
Xg123742 NAND2X1 $PINS Z=n_2635 A=n_1282 B=csm_inst_right_reg[9] VSS=VSS
+ VDD=VDD
Xg123743 NOR2X1 $PINS Z=n_2623 A=data_reg[43] B=n_1282 VSS=VSS VDD=VDD
Xg123744 OR2X1 $PINS Z=n_2622 A=data_reg[35] B=n_1282 VSS=VSS VDD=VDD
Xg123745 NAND2X1 $PINS Z=n_2621 A=n_1282 B=csm_inst_left_reg[11] VSS=VSS
+ VDD=VDD
Xg123746 OR2X1 $PINS Z=n_2620 A=data_reg[27] B=n_1282 VSS=VSS VDD=VDD
Xg123747 OR2X1 $PINS Z=n_2616 A=data_reg[19] B=n_1282 VSS=VSS VDD=VDD
Xg123748 NAND2X1 $PINS Z=n_2615 A=n_1282 B=csm_inst_left_reg[4] VSS=VSS VDD=VDD
Xg123749 NAND2X1 $PINS Z=n_2613 A=n_1282 B=csm_inst_right_reg[14] VSS=VSS
+ VDD=VDD
Xg123750 NAND2X1 $PINS Z=n_2611 A=n_1282 B=csm_inst_left_reg[19] VSS=VSS
+ VDD=VDD
Xg123751 NAND2X1 $PINS Z=n_2610 A=n_1282 B=csm_inst_left_reg[12] VSS=VSS
+ VDD=VDD
Xg123752 NAND2X1 $PINS Z=n_2603 A=n_1282 B=csm_inst_right_reg[16] VSS=VSS
+ VDD=VDD
Xg123753 NAND2X1 $PINS Z=n_2598 A=n_1282 B=csm_inst_left_reg[23] VSS=VSS
+ VDD=VDD
Xg123754 OR2X1 $PINS Z=n_2596 A=data_reg[53] B=n_1282 VSS=VSS VDD=VDD
Xg123755 OR2X1 $PINS Z=n_2595 A=n_1072 B=n_409 VSS=VSS VDD=VDD
Xg123756 NAND2X1 $PINS Z=n_2594 A=n_1282 B=csm_inst_left_reg[13] VSS=VSS
+ VDD=VDD
Xg123757 NOR2X1 $PINS Z=n_2593 A=data_reg[37] B=n_1282 VSS=VSS VDD=VDD
Xg123758 NOR2X1 $PINS Z=n_2578 A=data_reg[21] B=n_1282 VSS=VSS VDD=VDD
Xg123759 NAND2X1 $PINS Z=n_2576 A=n_1282 B=csm_inst_left_reg[14] VSS=VSS
+ VDD=VDD
Xg123760 OR2X1 $PINS Z=n_2575 A=data_reg[33] B=n_1282 VSS=VSS VDD=VDD
Xg123761 NAND2X1 $PINS Z=n_2571 A=n_1282 B=csm_inst_right_reg[22] VSS=VSS
+ VDD=VDD
Xg123762 NAND2X1 $PINS Z=n_2569 A=n_1282 B=csm_inst_left_reg[1] VSS=VSS VDD=VDD
Xg123763 OR2X1 $PINS Z=n_2566 A=data_reg[63] B=n_1282 VSS=VSS VDD=VDD
Xg123764 NAND2X1 $PINS Z=n_2562 A=n_1282 B=csm_inst_left_reg[0] VSS=VSS VDD=VDD
Xg123765 NAND2X1 $PINS Z=n_2561 A=n_1282 B=csm_inst_left_reg[15] VSS=VSS
+ VDD=VDD
Xg123766 NOR2X1 $PINS Z=n_2559 A=data_reg[55] B=n_1282 VSS=VSS VDD=VDD
Xg123767 OR2X1 $PINS Z=n_2552 A=data_reg[47] B=n_1282 VSS=VSS VDD=VDD
Xg123769 NAND2X1 $PINS Z=n_2547 A=n_1822 B=n_1820 VSS=VSS VDD=VDD
Xg123770 NAND2X1 $PINS Z=n_2546 A=n_1482 B=n_21 VSS=VSS VDD=VDD
Xg123771 NAND2X1 $PINS Z=n_2544 A=n_27 B=n_1215 VSS=VSS VDD=VDD
Xg123772 AND2X1 $PINS Z=n_2542 A=n_27 B=n_1139 VSS=VSS VDD=VDD
Xg123773 AND2X1 $PINS Z=n_2538 A=n_1146 B=n_19 VSS=VSS VDD=VDD
Xg123775 NAND2X1 $PINS Z=n_2534 A=n_1157 B=n_21 VSS=VSS VDD=VDD
Xg123776 NAND2X1 $PINS Z=n_2531 A=n_1847 B=n_1304 VSS=VSS VDD=VDD
Xg123777 NAND2X1 $PINS Z=n_2527 A=n_1631 B=n_21 VSS=VSS VDD=VDD
Xg123779 NOR2X1 $PINS Z=n_2521 A=n_918 B=n_415 VSS=VSS VDD=VDD
Xg123780 NAND2X1 $PINS Z=n_2520 A=n_967 B=n_21 VSS=VSS VDD=VDD
Xg123781 NAND3X1 $PINS Z=n_2518 A=n_565 B=n_563 C=n_15 VSS=VSS VDD=VDD
Xg123782 NAND3X1 $PINS Z=n_2517 A=n_20 B=csm_inst_round_counter[0] C=n_47
+ VSS=VSS VDD=VDD
Xg123783 NAND2X1 $PINS Z=n_2516 A=n_1625 B=csm_inst_round_counter[1] VSS=VSS
+ VDD=VDD
Xg123784 NAND2X1 $PINS Z=n_2515 A=n_1396 B=csm_inst_round_counter[2] VSS=VSS
+ VDD=VDD
Xg123785 AND2X1 $PINS Z=n_2512 A=n_591 B=n_1443 VSS=VSS VDD=VDD
Xg123786 NAND2X1 $PINS Z=n_2511 A=n_1068 B=n_1141 VSS=VSS VDD=VDD
Xg123787 NAND2X1 $PINS Z=n_2510 A=n_1159 B=n_1278 VSS=VSS VDD=VDD
Xg123788 NOR2X1 $PINS Z=n_2506 A=n_19 B=n_1845 VSS=VSS VDD=VDD
Xg123789 NAND2X1 $PINS Z=n_2505 A=n_416 B=n_1546 VSS=VSS VDD=VDD
Xg123790 NAND2X1 $PINS Z=n_2499 A=n_1524 B=n_21 VSS=VSS VDD=VDD
Xg123791 AND2X1 $PINS Z=n_2498 A=n_1502 B=n_1531 VSS=VSS VDD=VDD
Xg123792 NAND2X1 $PINS Z=n_2492 A=n_591 B=n_1500 VSS=VSS VDD=VDD
Xg123793 NAND2X1 $PINS Z=n_2487 A=n_1284 B=n_617 VSS=VSS VDD=VDD
Xg123794 NAND2X1 $PINS Z=n_2485 A=n_890 B=n_1330 VSS=VSS VDD=VDD
Xg123795 NAND2X1 $PINS Z=n_2482 A=n_27 B=n_1365 VSS=VSS VDD=VDD
Xg123796 NAND2X1 $PINS Z=n_2480 A=n_1615 B=n_1607 VSS=VSS VDD=VDD
Xg123797 NAND2X1 $PINS Z=n_2479 A=n_1390 B=n_1374 VSS=VSS VDD=VDD
Xg123798 NAND2X1 $PINS Z=n_2478 A=n_1844 B=n_1302 VSS=VSS VDD=VDD
Xg123799 AND2X1 $PINS Z=n_2477 A=n_1492 B=n_1268 VSS=VSS VDD=VDD
Xg123800 AND2X1 $PINS Z=n_2476 A=n_1595 B=n_1067 VSS=VSS VDD=VDD
Xg123801 NOR2X1 $PINS Z=n_2474 A=n_78 B=n_778 VSS=VSS VDD=VDD
Xg123802 NAND2X1 $PINS Z=n_2470 A=n_591 B=n_1541 VSS=VSS VDD=VDD
Xg123803 NOR2X1 $PINS Z=n_2469 A=csm_inst_mode B=n_1845 VSS=VSS VDD=VDD
Xg123804 NAND2X1 $PINS Z=n_2468 A=n_1252 B=n_21 VSS=VSS VDD=VDD
Xg123805 NOR2X1 $PINS Z=n_2467 A=n_87 B=n_1304 VSS=VSS VDD=VDD
Xg123806 NOR2X1 $PINS Z=n_2466 A=n_70 B=n_1209 VSS=VSS VDD=VDD
Xg123807 OR2X1 $PINS Z=n_2465 A=n_86 B=n_1295 VSS=VSS VDD=VDD
Xg123808 NAND2X1 $PINS Z=n_2464 A=n_1846 B=n_1190 VSS=VSS VDD=VDD
Xg123809 NOR2X1 $PINS Z=n_2463 A=n_1176 B=n_415 VSS=VSS VDD=VDD
Xg123810 NAND2X1 $PINS Z=n_2462 A=n_1298 B=n_243 VSS=VSS VDD=VDD
Xg123812 NOR2X1 $PINS Z=n_2459 A=n_70 B=n_1567 VSS=VSS VDD=VDD
Xg123813 NOR2X1 $PINS Z=n_2454 A=n_995 B=n_1149 VSS=VSS VDD=VDD
Xg123814 NAND2X1 $PINS Z=n_2453 A=n_1152 B=n_1829 VSS=VSS VDD=VDD
Xg123815 AND2X1 $PINS Z=n_2451 A=n_1574 B=n_1156 VSS=VSS VDD=VDD
Xg123816 NAND2X1 $PINS Z=n_2450 A=n_1191 B=n_21 VSS=VSS VDD=VDD
Xg123818 NAND2X1 $PINS Z=n_2446 A=n_1118 B=n_21 VSS=VSS VDD=VDD
Xg123819 NOR2X1 $PINS Z=n_2444 A=n_70 B=n_1116 VSS=VSS VDD=VDD
Xg123820 NAND2X1 $PINS Z=n_2440 A=n_1311 B=n_1021 VSS=VSS VDD=VDD
Xg123821 OR2X1 $PINS Z=n_2439 A=n_70 B=n_1103 VSS=VSS VDD=VDD
Xg123822 NAND2X1 $PINS Z=n_2436 A=n_1564 B=n_1578 VSS=VSS VDD=VDD
Xg123823 NAND2X1 $PINS Z=n_2434 A=n_1284 B=n_450 VSS=VSS VDD=VDD
Xg123824 NOR2X1 $PINS Z=n_2433 A=n_82 B=n_1836 VSS=VSS VDD=VDD
Xg123825 NAND2X1 $PINS Z=n_2429 A=n_1559 B=n_1094 VSS=VSS VDD=VDD
Xg123826 NAND2X1 $PINS Z=n_2838 A=n_1284 B=csm_inst_round_counter[0] VSS=VSS
+ VDD=VDD
Xg123827 AND2X1 $PINS Z=n_2835 A=n_1119 B=n_1356 VSS=VSS VDD=VDD
Xg123828 NAND2X1 $PINS Z=n_2833 A=n_1444 B=n_1160 VSS=VSS VDD=VDD
Xg123829 OR2X1 $PINS Z=n_2830 A=n_757 B=n_1307 VSS=VSS VDD=VDD
Xg123830 NAND2X1 $PINS Z=n_2829 A=n_1322 B=n_1309 VSS=VSS VDD=VDD
Xg123831 NAND2X1 $PINS Z=n_2826 A=n_1836 B=n_1318 VSS=VSS VDD=VDD
Xg123833 NAND3X1 $PINS Z=n_2817 A=n_335 B=n_583 C=csm_inst_round_counter[0]
+ VSS=VSS VDD=VDD
Xg123834 NAND2X1 $PINS Z=n_2812 A=n_1285 B=n_893 VSS=VSS VDD=VDD
Xg123835 NAND2X1 $PINS Z=n_2811 A=n_1511 B=n_1133 VSS=VSS VDD=VDD
Xg123839 NAND2X1 $PINS Z=n_2806 A=n_1833 B=spi_inst_bit_cnt[4] VSS=VSS VDD=VDD
Xg123897 INVX2 $PINS Z=n_2428 A=n_2425 VSS=VSS VDD=VDD
Xg123898 XOR2X1 $PINS Z=n_2238 A=spi_inst_bit_cnt[3] B=n_655 VSS=VSS VDD=VDD
Xg123899 AND2X1 $PINS Z=n_2236 A=n_435 B=n_1080 VSS=VSS VDD=VDD
Xg123900 NAND2X1 $PINS Z=n_2234 A=n_1593 B=n_66 VSS=VSS VDD=VDD
Xg123901 NOR2X1 $PINS Z=n_2233 A=n_67 B=n_1549 VSS=VSS VDD=VDD
Xg123902 NAND2X1 $PINS Z=n_2231 A=n_1527 B=n_66 VSS=VSS VDD=VDD
Xg123903 NAND2X1 $PINS Z=n_2229 A=n_1623 B=n_66 VSS=VSS VDD=VDD
Xg123904 NAND2X1 $PINS Z=n_2219 A=n_440 B=n_1843 VSS=VSS VDD=VDD
Xg123905 NAND2X1 $PINS Z=n_2218 A=n_1308 B=csm_inst_round_counter[3] VSS=VSS
+ VDD=VDD
Xg123906 NAND2X1 $PINS Z=n_2217 A=n_1841 B=n_80 VSS=VSS VDD=VDD
Xg123908 NAND3X1 $PINS Z=n_2212 A=n_719 B=n_70 C=n_47 VSS=VSS VDD=VDD
Xg123909 MUX2X1 $PINS Z=n_2204 A=n_449 B=n_599 S=csm_inst_round_counter[0]
+ VSS=VSS VDD=VDD
Xg123910 MUX2X1 $PINS Z=n_2200 A=n_20 B=n_636 S=csm_inst_round_counter[0]
+ VSS=VSS VDD=VDD
Xg123911 NAND3X1 $PINS Z=n_2199 A=n_440 B=n_490 C=csm_inst_round_counter[0]
+ VSS=VSS VDD=VDD
Xg123912 MUX2X1 $PINS Z=n_2198 A=n_605 B=n_534 S=csm_inst_round_counter[0]
+ VSS=VSS VDD=VDD
Xg123913 NAND3X1 $PINS Z=n_2197 A=n_428 B=n_664 C=csm_inst_mode VSS=VSS VDD=VDD
Xg123914 MUX2X1 $PINS Z=n_2196 A=n_668 B=n_641 S=csm_inst_round_counter[0]
+ VSS=VSS VDD=VDD
Xg123915 NAND3X1 $PINS Z=n_2192 A=n_6054 B=n_322 C=n_233 VSS=VSS VDD=VDD
Xg123916 MUX2X1 $PINS Z=n_2190 A=n_668 B=n_479 S=csm_inst_round_counter[0]
+ VSS=VSS VDD=VDD
Xg123917 MUX2X1 $PINS Z=n_2186 A=n_479 B=n_497 S=csm_inst_round_counter[0]
+ VSS=VSS VDD=VDD
Xg123918 MUX2X1 $PINS Z=n_2184 A=n_509 B=n_670 S=csm_inst_round_counter[0]
+ VSS=VSS VDD=VDD
Xg123919 MUX2X1 $PINS Z=n_2183 A=n_630 B=n_534 S=n_14 VSS=VSS VDD=VDD
Xg123920 MUX2X1 $PINS Z=n_2182 A=n_649 B=n_663 S=csm_inst_round_counter[0]
+ VSS=VSS VDD=VDD
Xg123921 MUX2X1 $PINS Z=n_2180 A=des_output[57] B=csm_inst_left_reg[0] S=n_409
+ VSS=VSS VDD=VDD
Xg123922 MUX2X1 $PINS Z=n_2176 A=des_output[25] B=csm_inst_left_reg[4] S=n_409
+ VSS=VSS VDD=VDD
Xg123923 MUX2X1 $PINS Z=n_2173 A=des_output[24] B=csm_inst_right_reg[4] S=n_409
+ VSS=VSS VDD=VDD
Xg123924 MUX2X1 $PINS Z=n_2172 A=data_reg[36] B=spi_rx_data[36] S=n_590 VSS=VSS
+ VDD=VDD
Xg123925 MUX2X1 $PINS Z=n_2171 A=des_output[22] B=csm_inst_right_reg[29]
+ S=n_409 VSS=VSS VDD=VDD
Xg123926 MUX2X1 $PINS Z=n_2170 A=n_462 B=n_734 S=n_14 VSS=VSS VDD=VDD
Xg123927 MUX2X1 $PINS Z=n_2169 A=n_506 B=n_622 S=csm_inst_round_counter[0]
+ VSS=VSS VDD=VDD
Xg123928 MUX2X1 $PINS Z=n_2168 A=n_708 B=n_618 S=csm_inst_round_counter[0]
+ VSS=VSS VDD=VDD
Xg123929 MUX2X1 $PINS Z=n_2167 A=n_669 B=n_642 S=csm_inst_round_counter[0]
+ VSS=VSS VDD=VDD
Xg123930 MUX2X1 $PINS Z=n_2160 A=des_output[54] B=csm_inst_right_reg[25]
+ S=n_409 VSS=VSS VDD=VDD
Xg123931 MUX2X1 $PINS Z=n_2153 A=des_output[42] B=csm_inst_right_reg[10]
+ S=n_409 VSS=VSS VDD=VDD
Xg123932 MUX2X1 $PINS Z=n_2150 A=des_output[21] B=csm_inst_left_reg[21] S=n_409
+ VSS=VSS VDD=VDD
Xg123933 MUX2X1 $PINS Z=n_2149 A=data_reg[28] B=spi_rx_data[28] S=n_590 VSS=VSS
+ VDD=VDD
Xg123934 MUX2X1 $PINS Z=n_2146 A=n_515 B=n_728 S=n_14 VSS=VSS VDD=VDD
Xg123935 MUX2X1 $PINS Z=n_2145 A=data_reg[55] B=spi_rx_data[55] S=n_590 VSS=VSS
+ VDD=VDD
Xg123936 MUX2X1 $PINS Z=n_2134 A=data_reg[16] B=spi_rx_data[16] S=n_590 VSS=VSS
+ VDD=VDD
Xg123937 MUX2X1 $PINS Z=n_2133 A=des_output[45] B=csm_inst_left_reg[18] S=n_409
+ VSS=VSS VDD=VDD
Xg123938 MUX2X1 $PINS Z=n_2132 A=des_output[20] B=csm_inst_right_reg[21]
+ S=n_409 VSS=VSS VDD=VDD
Xg123939 MUX2X1 $PINS Z=n_2131 A=data_reg[34] B=spi_rx_data[34] S=n_590 VSS=VSS
+ VDD=VDD
Xg123940 MUX2X1 $PINS Z=n_2128 A=n_464 B=n_528 S=n_14 VSS=VSS VDD=VDD
Xg123941 MUX2X1 $PINS Z=n_2126 A=n_504 B=n_464 S=n_14 VSS=VSS VDD=VDD
Xg123942 MUX2X1 $PINS Z=n_2124 A=des_output[19] B=csm_inst_left_reg[13] S=n_409
+ VSS=VSS VDD=VDD
Xg123943 MUX2X1 $PINS Z=n_2123 A=des_output[18] B=csm_inst_right_reg[13]
+ S=n_409 VSS=VSS VDD=VDD
Xg123944 MUX2X1 $PINS Z=n_2122 A=data_reg[62] B=spi_rx_data[62] S=n_590 VSS=VSS
+ VDD=VDD
Xg123945 MUX2X1 $PINS Z=n_2121 A=data_reg[48] B=spi_rx_data[48] S=n_590 VSS=VSS
+ VDD=VDD
Xg123946 MUX2X1 $PINS Z=n_2114 A=data_reg[51] B=spi_rx_data[51] S=n_590 VSS=VSS
+ VDD=VDD
Xg123947 MUX2X1 $PINS Z=n_2106 A=data_reg[46] B=spi_rx_data[46] S=n_590 VSS=VSS
+ VDD=VDD
Xg123948 MUX2X1 $PINS Z=n_2105 A=des_output[35] B=csm_inst_left_reg[11] S=n_409
+ VSS=VSS VDD=VDD
Xg123949 MUX2X1 $PINS Z=n_2104 A=des_output[17] B=csm_inst_left_reg[5] S=n_409
+ VSS=VSS VDD=VDD
Xg123950 MUX2X1 $PINS Z=n_2103 A=data_reg[14] B=spi_rx_data[14] S=n_590 VSS=VSS
+ VDD=VDD
Xg123951 NAND2X1 $PINS Z=n_2102 A=n_26 B=n_1825 VSS=VSS VDD=VDD
Xg123952 MUX2X1 $PINS Z=n_2093 A=des_output[56] B=csm_inst_right_reg[0] S=n_409
+ VSS=VSS VDD=VDD
Xg123953 MUX2X1 $PINS Z=n_2092 A=des_output[26] B=csm_inst_right_reg[12]
+ S=n_409 VSS=VSS VDD=VDD
Xg123954 MUX2X1 $PINS Z=n_2091 A=des_output[27] B=csm_inst_left_reg[12] S=n_409
+ VSS=VSS VDD=VDD
Xg123955 MUX2X1 $PINS Z=n_2085 A=data_reg[47] B=spi_rx_data[47] S=n_590 VSS=VSS
+ VDD=VDD
Xg123956 MUX2X1 $PINS Z=n_2082 A=des_output[31] B=csm_inst_left_reg[28] S=n_409
+ VSS=VSS VDD=VDD
Xg123957 MUX2X1 $PINS Z=n_2081 A=des_output[61] B=csm_inst_left_reg[16] S=n_409
+ VSS=VSS VDD=VDD
Xg123958 MUX2X1 $PINS Z=n_2080 A=des_output[32] B=csm_inst_right_reg[3] S=n_409
+ VSS=VSS VDD=VDD
Xg123959 MUX2X1 $PINS Z=n_2079 A=data_reg[0] B=spi_rx_data[0] S=n_590 VSS=VSS
+ VDD=VDD
Xg123960 MUX2X1 $PINS Z=n_2078 A=des_output[33] B=csm_inst_left_reg[3] S=n_409
+ VSS=VSS VDD=VDD
Xg123961 MUX2X1 $PINS Z=n_2077 A=data_reg[1] B=spi_rx_data[1] S=n_590 VSS=VSS
+ VDD=VDD
Xg123962 MUX2X1 $PINS Z=n_2071 A=des_output[34] B=csm_inst_right_reg[11]
+ S=n_409 VSS=VSS VDD=VDD
Xg123963 MUX2X1 $PINS Z=n_2067 A=data_reg[3] B=spi_rx_data[3] S=n_590 VSS=VSS
+ VDD=VDD
Xg123964 MUX2X1 $PINS Z=n_2066 A=data_reg[5] B=spi_rx_data[5] S=n_590 VSS=VSS
+ VDD=VDD
Xg123965 MUX2X1 $PINS Z=n_2065 A=data_reg[6] B=spi_rx_data[6] S=n_590 VSS=VSS
+ VDD=VDD
Xg123966 MUX2X1 $PINS Z=n_2060 A=data_reg[7] B=spi_rx_data[7] S=n_590 VSS=VSS
+ VDD=VDD
Xg123967 MUX2X1 $PINS Z=n_2056 A=data_reg[8] B=spi_rx_data[8] S=n_590 VSS=VSS
+ VDD=VDD
Xg123968 MUX2X1 $PINS Z=n_2055 A=data_reg[9] B=spi_rx_data[9] S=n_590 VSS=VSS
+ VDD=VDD
Xg123969 MUX2X1 $PINS Z=n_2053 A=data_reg[10] B=spi_rx_data[10] S=n_590 VSS=VSS
+ VDD=VDD
Xg123970 MUX2X1 $PINS Z=n_2049 A=data_reg[11] B=spi_rx_data[11] S=n_590 VSS=VSS
+ VDD=VDD
Xg123971 MUX2X1 $PINS Z=n_2044 A=data_reg[13] B=spi_rx_data[13] S=n_590 VSS=VSS
+ VDD=VDD
Xg123972 MUX2X1 $PINS Z=n_2038 A=data_reg[15] B=spi_rx_data[15] S=n_590 VSS=VSS
+ VDD=VDD
Xg123973 MUX2X1 $PINS Z=n_2037 A=data_reg[4] B=spi_rx_data[4] S=n_590 VSS=VSS
+ VDD=VDD
Xg123974 MUX2X1 $PINS Z=n_2030 A=data_reg[17] B=spi_rx_data[17] S=n_590 VSS=VSS
+ VDD=VDD
Xg123975 MUX2X1 $PINS Z=n_2026 A=des_output[36] B=csm_inst_right_reg[19]
+ S=n_409 VSS=VSS VDD=VDD
Xg123976 MUX2X1 $PINS Z=n_2025 A=data_reg[19] B=spi_rx_data[19] S=n_590 VSS=VSS
+ VDD=VDD
Xg123977 MUX2X1 $PINS Z=n_2024 A=data_reg[21] B=spi_rx_data[21] S=n_590 VSS=VSS
+ VDD=VDD
Xg123978 MUX2X1 $PINS Z=n_2023 A=data_reg[22] B=spi_rx_data[22] S=n_590 VSS=VSS
+ VDD=VDD
Xg123979 MUX2X1 $PINS Z=n_2018 A=data_reg[23] B=spi_rx_data[23] S=n_590 VSS=VSS
+ VDD=VDD
Xg123980 MUX2X1 $PINS Z=n_2017 A=data_reg[24] B=spi_rx_data[24] S=n_590 VSS=VSS
+ VDD=VDD
Xg123981 MUX2X1 $PINS Z=n_2016 A=data_reg[25] B=spi_rx_data[25] S=n_590 VSS=VSS
+ VDD=VDD
Xg123982 MUX2X1 $PINS Z=n_2012 A=des_output[37] B=csm_inst_left_reg[19] S=n_409
+ VSS=VSS VDD=VDD
Xg123983 MUX2X1 $PINS Z=n_2007 A=data_reg[27] B=spi_rx_data[27] S=n_590 VSS=VSS
+ VDD=VDD
Xg123984 MUX2X1 $PINS Z=n_2003 A=data_reg[30] B=spi_rx_data[30] S=n_590 VSS=VSS
+ VDD=VDD
Xg123985 MUX2X1 $PINS Z=n_2002 A=des_output[38] B=csm_inst_right_reg[27]
+ S=n_409 VSS=VSS VDD=VDD
Xg123986 MUX2X1 $PINS Z=n_2001 A=data_reg[31] B=spi_rx_data[31] S=n_590 VSS=VSS
+ VDD=VDD
Xg123987 MUX2X1 $PINS Z=n_2000 A=data_reg[32] B=spi_rx_data[32] S=n_590 VSS=VSS
+ VDD=VDD
Xg123988 MUX2X1 $PINS Z=n_1999 A=data_reg[33] B=spi_rx_data[33] S=n_590 VSS=VSS
+ VDD=VDD
Xg123989 MUX2X1 $PINS Z=n_1998 A=data_reg[35] B=spi_rx_data[35] S=n_590 VSS=VSS
+ VDD=VDD
Xg123990 MUX2X1 $PINS Z=n_1997 A=data_reg[37] B=spi_rx_data[37] S=n_590 VSS=VSS
+ VDD=VDD
Xg123991 MUX2X1 $PINS Z=n_1996 A=data_reg[38] B=spi_rx_data[38] S=n_590 VSS=VSS
+ VDD=VDD
Xg123992 MUX2X1 $PINS Z=n_1995 A=des_output[39] B=csm_inst_left_reg[27] S=n_409
+ VSS=VSS VDD=VDD
Xg123993 MUX2X1 $PINS Z=n_1994 A=data_reg[39] B=spi_rx_data[39] S=n_590 VSS=VSS
+ VDD=VDD
Xg123994 MUX2X1 $PINS Z=n_1993 A=data_reg[43] B=spi_rx_data[43] S=n_590 VSS=VSS
+ VDD=VDD
Xg123995 MUX2X1 $PINS Z=n_1990 A=des_output[40] B=csm_inst_right_reg[2] S=n_409
+ VSS=VSS VDD=VDD
Xg123996 MUX2X1 $PINS Z=n_1989 A=data_reg[45] B=spi_rx_data[45] S=n_590 VSS=VSS
+ VDD=VDD
Xg123997 MUX2X1 $PINS Z=n_1984 A=des_output[41] B=csm_inst_left_reg[2] S=n_409
+ VSS=VSS VDD=VDD
Xg123998 MUX2X1 $PINS Z=n_1982 A=data_reg[53] B=spi_rx_data[53] S=n_590 VSS=VSS
+ VDD=VDD
Xg123999 MUX2X1 $PINS Z=n_1981 A=data_reg[57] B=spi_rx_data[57] S=n_590 VSS=VSS
+ VDD=VDD
Xg124000 MUX2X1 $PINS Z=n_1980 A=data_reg[59] B=spi_rx_data[59] S=n_590 VSS=VSS
+ VDD=VDD
Xg124001 MUX2X1 $PINS Z=n_1975 A=data_reg[60] B=spi_rx_data[60] S=n_590 VSS=VSS
+ VDD=VDD
Xg124002 MUX2X1 $PINS Z=n_1974 A=data_reg[61] B=spi_rx_data[61] S=n_590 VSS=VSS
+ VDD=VDD
Xg124003 MUX2X1 $PINS Z=n_1970 A=data_reg[63] B=spi_rx_data[63] S=n_590 VSS=VSS
+ VDD=VDD
Xg124004 MUX2X1 $PINS Z=n_1964 A=des_output[43] B=csm_inst_left_reg[10] S=n_409
+ VSS=VSS VDD=VDD
Xg124005 MUX2X1 $PINS Z=n_1956 A=des_output[44] B=csm_inst_right_reg[18]
+ S=n_409 VSS=VSS VDD=VDD
Xg124006 MUX2X1 $PINS Z=n_1952 A=des_output[29] B=csm_inst_left_reg[20] S=n_409
+ VSS=VSS VDD=VDD
Xg124007 MUX2X1 $PINS Z=n_1948 A=des_output[46] B=csm_inst_right_reg[26]
+ S=n_409 VSS=VSS VDD=VDD
Xg124008 MUX2X1 $PINS Z=n_1943 A=des_output[47] B=csm_inst_left_reg[26] S=n_409
+ VSS=VSS VDD=VDD
Xg124009 MUX2X1 $PINS Z=n_1942 A=des_output[48] B=csm_inst_right_reg[1] S=n_409
+ VSS=VSS VDD=VDD
Xg124010 MUX2X1 $PINS Z=n_1941 A=des_output[49] B=csm_inst_left_reg[1] S=n_409
+ VSS=VSS VDD=VDD
Xg124011 MUX2X1 $PINS Z=n_1940 A=des_output[50] B=csm_inst_right_reg[9] S=n_409
+ VSS=VSS VDD=VDD
Xg124012 MUX2X1 $PINS Z=n_1939 A=des_output[53] B=csm_inst_left_reg[17] S=n_409
+ VSS=VSS VDD=VDD
Xg124013 MUX2X1 $PINS Z=n_1936 A=data_reg[2] B=spi_rx_data[2] S=n_590 VSS=VSS
+ VDD=VDD
Xg124014 MUX2X1 $PINS Z=n_1935 A=data_reg[44] B=spi_rx_data[44] S=n_590 VSS=VSS
+ VDD=VDD
Xg124015 MUX2X1 $PINS Z=n_1932 A=data_reg[42] B=spi_rx_data[42] S=n_590 VSS=VSS
+ VDD=VDD
Xg124016 MUX2X1 $PINS Z=n_1931 A=des_output[59] B=csm_inst_left_reg[8] S=n_409
+ VSS=VSS VDD=VDD
Xg124017 MUX2X1 $PINS Z=n_1929 A=des_output[62] B=csm_inst_right_reg[24]
+ S=n_409 VSS=VSS VDD=VDD
Xg124018 MUX2X1 $PINS Z=n_1926 A=des_output[63] B=csm_inst_left_reg[24] S=n_409
+ VSS=VSS VDD=VDD
Xg124019 MUX2X1 $PINS Z=n_1925 A=data_reg[20] B=spi_rx_data[20] S=n_590 VSS=VSS
+ VDD=VDD
Xg124020 MUX2X1 $PINS Z=n_1924 A=des_output[23] B=csm_inst_left_reg[29] S=n_409
+ VSS=VSS VDD=VDD
Xg124021 MUX2X1 $PINS Z=n_1923 A=des_output[55] B=csm_inst_left_reg[25] S=n_409
+ VSS=VSS VDD=VDD
Xg124022 MUX2X1 $PINS Z=n_1922 A=des_output[30] B=csm_inst_right_reg[28]
+ S=n_409 VSS=VSS VDD=VDD
Xg124023 MUX2X1 $PINS Z=n_1921 A=data_reg[52] B=spi_rx_data[52] S=n_590 VSS=VSS
+ VDD=VDD
Xg124024 MUX2X1 $PINS Z=n_1920 A=des_output[0] B=csm_inst_right_reg[7] S=n_409
+ VSS=VSS VDD=VDD
Xg124025 MUX2X1 $PINS Z=n_1917 A=des_output[52] B=csm_inst_right_reg[17]
+ S=n_409 VSS=VSS VDD=VDD
Xg124026 MUX2X1 $PINS Z=n_1916 A=des_output[58] B=csm_inst_right_reg[8] S=n_409
+ VSS=VSS VDD=VDD
Xg124027 MUX2X1 $PINS Z=n_1914 A=des_output[1] B=csm_inst_left_reg[7] S=n_409
+ VSS=VSS VDD=VDD
Xg124028 MUX2X1 $PINS Z=n_1913 A=data_reg[41] B=spi_rx_data[41] S=n_590 VSS=VSS
+ VDD=VDD
Xg124029 MUX2X1 $PINS Z=n_1912 A=des_output[2] B=csm_inst_right_reg[15] S=n_409
+ VSS=VSS VDD=VDD
Xg124030 MUX2X1 $PINS Z=n_1911 A=des_output[60] B=csm_inst_right_reg[16]
+ S=n_409 VSS=VSS VDD=VDD
Xg124031 MUX2X1 $PINS Z=n_1910 A=data_reg[49] B=spi_rx_data[49] S=n_590 VSS=VSS
+ VDD=VDD
Xg124032 MUX2X1 $PINS Z=n_1909 A=des_output[3] B=csm_inst_left_reg[15] S=n_409
+ VSS=VSS VDD=VDD
Xg124033 MUX2X1 $PINS Z=n_1908 A=data_reg[58] B=spi_rx_data[58] S=n_590 VSS=VSS
+ VDD=VDD
Xg124034 MUX2X1 $PINS Z=n_1906 A=des_output[4] B=csm_inst_right_reg[23] S=n_409
+ VSS=VSS VDD=VDD
Xg124035 MUX2X1 $PINS Z=n_1905 A=des_output[51] B=csm_inst_left_reg[9] S=n_409
+ VSS=VSS VDD=VDD
Xg124036 MUX2X1 $PINS Z=n_1904 A=data_reg[40] B=spi_rx_data[40] S=n_590 VSS=VSS
+ VDD=VDD
Xg124037 MUX2X1 $PINS Z=n_1902 A=des_output[5] B=csm_inst_left_reg[23] S=n_409
+ VSS=VSS VDD=VDD
Xg124038 MUX2X1 $PINS Z=n_1900 A=des_output[6] B=csm_inst_right_reg[31] S=n_409
+ VSS=VSS VDD=VDD
Xg124039 MUX2X1 $PINS Z=n_1899 A=des_output[7] B=csm_inst_left_reg[31] S=n_409
+ VSS=VSS VDD=VDD
Xg124040 MUX2X1 $PINS Z=n_1898 A=data_reg[56] B=spi_rx_data[56] S=n_590 VSS=VSS
+ VDD=VDD
Xg124041 MUX2X1 $PINS Z=n_1896 A=data_reg[54] B=spi_rx_data[54] S=n_590 VSS=VSS
+ VDD=VDD
Xg124042 MUX2X1 $PINS Z=n_1894 A=des_output[8] B=csm_inst_right_reg[6] S=n_409
+ VSS=VSS VDD=VDD
Xg124043 MUX2X1 $PINS Z=n_1891 A=des_output[9] B=csm_inst_left_reg[6] S=n_409
+ VSS=VSS VDD=VDD
Xg124044 MUX2X1 $PINS Z=n_1885 A=des_output[10] B=csm_inst_right_reg[14]
+ S=n_409 VSS=VSS VDD=VDD
Xg124045 MUX2X1 $PINS Z=n_1882 A=data_reg[26] B=spi_rx_data[26] S=n_590 VSS=VSS
+ VDD=VDD
Xg124046 MUX2X1 $PINS Z=n_1880 A=des_output[11] B=csm_inst_left_reg[14] S=n_409
+ VSS=VSS VDD=VDD
Xg124047 MUX2X1 $PINS Z=n_1872 A=data_reg[12] B=spi_rx_data[12] S=n_590 VSS=VSS
+ VDD=VDD
Xg124048 MUX2X1 $PINS Z=n_1866 A=data_reg[18] B=spi_rx_data[18] S=n_590 VSS=VSS
+ VDD=VDD
Xg124049 MUX2X1 $PINS Z=n_1865 A=des_output[28] B=csm_inst_right_reg[20]
+ S=n_409 VSS=VSS VDD=VDD
Xg124050 MUX2X1 $PINS Z=n_1863 A=des_output[12] B=csm_inst_right_reg[22]
+ S=n_409 VSS=VSS VDD=VDD
Xg124051 MUX2X1 $PINS Z=n_1861 A=des_output[13] B=csm_inst_left_reg[22] S=n_409
+ VSS=VSS VDD=VDD
Xg124052 MUX2X1 $PINS Z=n_1858 A=des_output[14] B=csm_inst_right_reg[30]
+ S=n_409 VSS=VSS VDD=VDD
Xg124053 MUX2X1 $PINS Z=n_1857 A=data_reg[50] B=spi_rx_data[50] S=n_590 VSS=VSS
+ VDD=VDD
Xg124054 MUX2X1 $PINS Z=n_1856 A=data_reg[29] B=spi_rx_data[29] S=n_590 VSS=VSS
+ VDD=VDD
Xg124055 MUX2X1 $PINS Z=n_1855 A=des_output[15] B=csm_inst_left_reg[30] S=n_409
+ VSS=VSS VDD=VDD
Xg124056 MUX2X1 $PINS Z=n_1852 A=des_output[16] B=csm_inst_right_reg[5] S=n_409
+ VSS=VSS VDD=VDD
Xg124057 NOR2X1 $PINS Z=n_2425 A=n_1843 B=n_1841 VSS=VSS VDD=VDD
Xg124058 MUX2X1 $PINS Z=n_2422 A=n_694 B=n_612 S=n_14 VSS=VSS VDD=VDD
Xg124059 MUX2X1 $PINS Z=n_2421 A=n_695 B=n_540 S=csm_inst_round_counter[0]
+ VSS=VSS VDD=VDD
Xg124060 MUX2X1 $PINS Z=n_2419 A=n_504 B=n_674 S=n_14 VSS=VSS VDD=VDD
Xg124061 MUX2X1 $PINS Z=n_2416 A=n_530 B=n_532 S=n_14 VSS=VSS VDD=VDD
Xg124062 MUX2X1 $PINS Z=n_2415 A=n_665 B=n_524 S=csm_inst_round_counter[0]
+ VSS=VSS VDD=VDD
Xg124063 MUX2X1 $PINS Z=n_2411 A=n_485 B=n_726 S=csm_inst_round_counter[0]
+ VSS=VSS VDD=VDD
Xg124064 MUX2X1 $PINS Z=n_2409 A=n_677 B=n_732 S=csm_inst_round_counter[0]
+ VSS=VSS VDD=VDD
Xg124065 MUX2X1 $PINS Z=n_2407 A=n_697 B=n_731 S=csm_inst_round_counter[0]
+ VSS=VSS VDD=VDD
Xg124066 MUX2X1 $PINS Z=n_2406 A=n_706 B=n_609 S=csm_inst_round_counter[0]
+ VSS=VSS VDD=VDD
Xg124067 MUX2X1 $PINS Z=n_2400 A=n_479 B=n_602 S=csm_inst_round_counter[0]
+ VSS=VSS VDD=VDD
Xg124068 MUX2X1 $PINS Z=n_2398 A=n_705 B=n_739 S=n_14 VSS=VSS VDD=VDD
Xg124069 MUX2X1 $PINS Z=n_2390 A=n_669 B=n_674 S=csm_inst_round_counter[0]
+ VSS=VSS VDD=VDD
Xg124070 MUX2X1 $PINS Z=n_2389 A=n_644 B=n_743 S=n_14 VSS=VSS VDD=VDD
Xg124071 MUX2X1 $PINS Z=n_2388 A=n_654 B=n_533 S=n_14 VSS=VSS VDD=VDD
Xg124072 MUX2X1 $PINS Z=n_2386 A=n_634 B=n_741 S=n_14 VSS=VSS VDD=VDD
Xg124073 MUX2X1 $PINS Z=n_2384 A=n_708 B=n_500 S=csm_inst_round_counter[0]
+ VSS=VSS VDD=VDD
Xg124074 MUX2X1 $PINS Z=n_2383 A=n_458 B=n_528 S=n_14 VSS=VSS VDD=VDD
Xg124075 MUX2X1 $PINS Z=n_2382 A=n_664 B=n_531 S=n_14 VSS=VSS VDD=VDD
Xg124076 MUX2X1 $PINS Z=n_2379 A=n_605 B=n_728 S=n_14 VSS=VSS VDD=VDD
Xg124077 MUX2X1 $PINS Z=n_2374 A=n_481 B=n_534 S=n_14 VSS=VSS VDD=VDD
Xg124078 MUX2X1 $PINS Z=n_2371 A=n_470 B=n_734 S=n_14 VSS=VSS VDD=VDD
Xg124079 MUX2X1 $PINS Z=n_2370 A=n_521 B=n_693 S=n_14 VSS=VSS VDD=VDD
Xg124080 MUX2X1 $PINS Z=n_2369 A=n_476 B=n_631 S=csm_inst_round_counter[0]
+ VSS=VSS VDD=VDD
Xg124081 MUX2X1 $PINS Z=n_2368 A=n_607 B=n_719 S=csm_inst_round_counter[0]
+ VSS=VSS VDD=VDD
Xg124082 MUX2X1 $PINS Z=n_2365 A=n_469 B=n_639 S=csm_inst_round_counter[0]
+ VSS=VSS VDD=VDD
Xg124083 MUX2X1 $PINS Z=n_2362 A=n_678 B=n_610 S=csm_inst_round_counter[0]
+ VSS=VSS VDD=VDD
Xg124084 MUX2X1 $PINS Z=n_2360 A=n_452 B=n_625 S=csm_inst_round_counter[0]
+ VSS=VSS VDD=VDD
Xg124085 MUX2X1 $PINS Z=n_2358 A=n_611 B=n_739 S=csm_inst_round_counter[0]
+ VSS=VSS VDD=VDD
Xg124086 MUX2X1 $PINS Z=n_2357 A=n_500 B=n_632 S=csm_inst_round_counter[0]
+ VSS=VSS VDD=VDD
Xg124087 MUX2X1 $PINS Z=n_2354 A=n_609 B=n_528 S=csm_inst_round_counter[0]
+ VSS=VSS VDD=VDD
Xg124088 MUX2X1 $PINS Z=n_2353 A=n_714 B=n_706 S=csm_inst_round_counter[0]
+ VSS=VSS VDD=VDD
Xg124089 MUX2X1 $PINS Z=n_2351 A=n_615 B=n_662 S=csm_inst_round_counter[0]
+ VSS=VSS VDD=VDD
Xg124090 MUX2X1 $PINS Z=n_2350 A=n_646 B=n_465 S=csm_inst_round_counter[0]
+ VSS=VSS VDD=VDD
Xg124091 MUX2X1 $PINS Z=n_2346 A=n_499 B=n_688 S=csm_inst_round_counter[0]
+ VSS=VSS VDD=VDD
Xg124092 MUX2X1 $PINS Z=n_2339 A=n_629 B=n_713 S=csm_inst_round_counter[0]
+ VSS=VSS VDD=VDD
Xg124093 MUX2X1 $PINS Z=n_2337 A=n_608 B=n_665 S=csm_inst_round_counter[0]
+ VSS=VSS VDD=VDD
Xg124094 MUX2X1 $PINS Z=n_2333 A=n_672 B=n_741 S=csm_inst_round_counter[0]
+ VSS=VSS VDD=VDD
Xg124095 MUX2X1 $PINS Z=n_2332 A=n_631 B=n_675 S=csm_inst_round_counter[0]
+ VSS=VSS VDD=VDD
Xg124096 MUX2X1 $PINS Z=n_2329 A=n_513 B=n_485 S=csm_inst_round_counter[0]
+ VSS=VSS VDD=VDD
Xg124097 MUX2X1 $PINS Z=n_2326 A=n_732 B=n_742 S=csm_inst_round_counter[0]
+ VSS=VSS VDD=VDD
Xg124098 MUX2X1 $PINS Z=n_2320 A=n_704 B=n_703 S=csm_inst_round_counter[0]
+ VSS=VSS VDD=VDD
Xg124099 MUX2X1 $PINS Z=n_2317 A=n_681 B=n_496 S=csm_inst_round_counter[0]
+ VSS=VSS VDD=VDD
Xg124100 MUX2X1 $PINS Z=n_2316 A=n_495 B=n_660 S=csm_inst_round_counter[0]
+ VSS=VSS VDD=VDD
Xg124101 MUX2X1 $PINS Z=n_2313 A=n_638 B=n_451 S=csm_inst_round_counter[0]
+ VSS=VSS VDD=VDD
Xg124102 MUX2X1 $PINS Z=n_2312 A=n_652 B=n_629 S=csm_inst_round_counter[0]
+ VSS=VSS VDD=VDD
Xg124103 MUX2X1 $PINS Z=n_2310 A=n_600 B=n_506 S=csm_inst_round_counter[0]
+ VSS=VSS VDD=VDD
Xg124104 MUX2X1 $PINS Z=n_2306 A=n_504 B=n_452 S=csm_inst_round_counter[0]
+ VSS=VSS VDD=VDD
Xg124105 MUX2X1 $PINS Z=n_2305 A=n_625 B=n_509 S=csm_inst_round_counter[0]
+ VSS=VSS VDD=VDD
Xg124106 MUX2X1 $PINS Z=n_2304 A=n_713 B=n_455 S=csm_inst_round_counter[0]
+ VSS=VSS VDD=VDD
Xg124107 MUX2X1 $PINS Z=n_2302 A=n_465 B=n_600 S=csm_inst_round_counter[0]
+ VSS=VSS VDD=VDD
Xg124108 NAND3X1 $PINS Z=n_2301 A=n_1353 B=n_579 C=n_566 VSS=VSS VDD=VDD
Xg124109 MUX2X1 $PINS Z=n_2300 A=n_662 B=n_646 S=csm_inst_round_counter[0]
+ VSS=VSS VDD=VDD
Xg124110 MUX2X1 $PINS Z=n_2299 A=n_644 B=n_728 S=csm_inst_round_counter[0]
+ VSS=VSS VDD=VDD
Xg124111 MUX2X1 $PINS Z=n_2286 A=n_693 B=n_525 S=n_14 VSS=VSS VDD=VDD
Xg124112 MUX2X1 $PINS Z=n_2275 A=n_703 B=n_733 S=csm_inst_round_counter[0]
+ VSS=VSS VDD=VDD
Xg124113 MUX2X1 $PINS Z=n_2274 A=n_627 B=n_714 S=csm_inst_round_counter[0]
+ VSS=VSS VDD=VDD
Xg124114 MUX2X1 $PINS Z=n_2260 A=n_719 B=n_614 S=csm_inst_round_counter[0]
+ VSS=VSS VDD=VDD
Xg124115 MUX2X1 $PINS Z=n_2259 A=n_632 B=n_611 S=csm_inst_round_counter[0]
+ VSS=VSS VDD=VDD
Xg124116 MUX2X1 $PINS Z=n_2251 A=n_678 B=n_648 S=n_14 VSS=VSS VDD=VDD
Xg124117 MUX2X1 $PINS Z=n_2250 A=n_666 B=n_731 S=n_14 VSS=VSS VDD=VDD
Xg124118 NAND3X1 $PINS Z=n_2249 A=n_1467 B=n_570 C=n_548 VSS=VSS VDD=VDD
Xg124119 NAND3X1 $PINS Z=n_2248 A=n_1132 B=n_575 C=n_569 VSS=VSS VDD=VDD
Xg124120 NAND3X1 $PINS Z=n_2247 A=n_1606 B=n_580 C=n_551 VSS=VSS VDD=VDD
Xg124121 MUX2X1 $PINS Z=n_2245 A=n_476 B=n_466 S=n_14 VSS=VSS VDD=VDD
Xg124123 INVX2 $PINS Z=n_1833 A=n_1830 VSS=VSS VDD=VDD
Xg124124 NAND2X1 $PINS Z=n_1829 A=n_438 B=n_657 VSS=VSS VDD=VDD
Xg124125 NAND2X1 $PINS Z=n_1828 A=n_410 B=csm_inst_right_reg[24] VSS=VSS
+ VDD=VDD
Xg124126 NAND2X1 $PINS Z=n_1826 A=n_438 B=n_647 VSS=VSS VDD=VDD
Xg124127 NAND2X1 $PINS Z=n_1825 A=n_364 B=transaction_state[1] VSS=VSS VDD=VDD
Xg124128 NAND2X1 $PINS Z=n_1824 A=n_598 B=done_encrypt VSS=VSS VDD=VDD
Xg124129 NAND2X1 $PINS Z=n_1822 A=n_598 B=done_decrypt VSS=VSS VDD=VDD
Xg124130 OR2X1 $PINS Z=n_1820 A=n_19 B=n_667 VSS=VSS VDD=VDD
Xg124131 NOR2X1 $PINS Z=n_1819 A=csm_inst_right_reg[28] B=n_24 VSS=VSS VDD=VDD
Xg124132 NAND2X1 $PINS Z=n_1818 A=n_24 B=data_reg[60] VSS=VSS VDD=VDD
Xg124133 NAND2X1 $PINS Z=n_1816 A=n_24 B=data_reg[48] VSS=VSS VDD=VDD
Xg124134 NAND2X1 $PINS Z=n_1815 A=n_24 B=data_reg[20] VSS=VSS VDD=VDD
Xg124135 NAND2X1 $PINS Z=n_1812 A=n_24 B=data_reg[40] VSS=VSS VDD=VDD
Xg124136 NAND2X1 $PINS Z=n_1809 A=n_24 B=data_reg[52] VSS=VSS VDD=VDD
Xg124137 NAND2X1 $PINS Z=n_1808 A=n_24 B=data_reg[44] VSS=VSS VDD=VDD
Xg124138 NAND2X1 $PINS Z=n_1806 A=n_24 B=data_reg[42] VSS=VSS VDD=VDD
Xg124139 NAND2X1 $PINS Z=n_1805 A=n_24 B=data_reg[49] VSS=VSS VDD=VDD
Xg124140 NAND2X1 $PINS Z=n_1804 A=n_24 B=data_reg[28] VSS=VSS VDD=VDD
Xg124141 NAND2X1 $PINS Z=n_1803 A=n_24 B=data_reg[32] VSS=VSS VDD=VDD
Xg124142 NAND2X1 $PINS Z=n_1802 A=n_24 B=data_reg[24] VSS=VSS VDD=VDD
Xg124143 OR2X1 $PINS Z=n_1801 A=csm_inst_right_reg[20] B=n_24 VSS=VSS VDD=VDD
Xg124144 OR2X1 $PINS Z=n_1799 A=csm_inst_right_reg[15] B=n_24 VSS=VSS VDD=VDD
Xg124145 NAND2X1 $PINS Z=n_1798 A=n_24 B=data_reg[16] VSS=VSS VDD=VDD
Xg124146 NAND2X1 $PINS Z=n_1797 A=n_24 B=data_reg[62] VSS=VSS VDD=VDD
Xg124147 NAND2X1 $PINS Z=n_1796 A=n_24 B=data_reg[54] VSS=VSS VDD=VDD
Xg124148 NAND2X1 $PINS Z=n_1795 A=n_24 B=data_reg[8] VSS=VSS VDD=VDD
Xg124149 NAND2X1 $PINS Z=n_1794 A=n_24 B=data_reg[46] VSS=VSS VDD=VDD
Xg124150 NOR2X1 $PINS Z=n_1793 A=csm_inst_right_reg[25] B=n_24 VSS=VSS VDD=VDD
Xg124151 NAND2X1 $PINS Z=n_1789 A=n_24 B=data_reg[38] VSS=VSS VDD=VDD
Xg124152 NAND2X1 $PINS Z=n_1788 A=n_24 B=data_reg[0] VSS=VSS VDD=VDD
Xg124153 NAND2X1 $PINS Z=n_1786 A=n_24 B=data_reg[30] VSS=VSS VDD=VDD
Xg124154 NAND2X1 $PINS Z=n_1785 A=n_24 B=data_reg[22] VSS=VSS VDD=VDD
Xg124155 NAND2X1 $PINS Z=n_1784 A=n_24 B=data_reg[58] VSS=VSS VDD=VDD
Xg124156 NAND2X1 $PINS Z=n_1782 A=n_24 B=data_reg[14] VSS=VSS VDD=VDD
Xg124157 NOR2X1 $PINS Z=n_1779 A=csm_inst_right_reg[18] B=n_24 VSS=VSS VDD=VDD
Xg124158 NAND2X1 $PINS Z=n_1778 A=n_24 B=data_reg[6] VSS=VSS VDD=VDD
Xg124159 OR2X1 $PINS Z=n_1775 A=csm_inst_right_reg[8] B=n_24 VSS=VSS VDD=VDD
Xg124160 NAND2X1 $PINS Z=n_1772 A=n_24 B=data_reg[50] VSS=VSS VDD=VDD
Xg124161 OR2X1 $PINS Z=n_1771 A=csm_inst_right_reg[2] B=n_24 VSS=VSS VDD=VDD
Xg124162 NAND2X1 $PINS Z=n_1769 A=n_24 B=data_reg[51] VSS=VSS VDD=VDD
Xg124163 NOR2X1 $PINS Z=n_1767 A=csm_inst_right_reg[10] B=n_24 VSS=VSS VDD=VDD
Xg124164 NAND2X1 $PINS Z=n_1763 A=n_24 B=data_reg[57] VSS=VSS VDD=VDD
Xg124165 NAND2X1 $PINS Z=n_1760 A=n_24 B=data_reg[34] VSS=VSS VDD=VDD
Xg124166 NAND2X1 $PINS Z=n_1759 A=n_24 B=data_reg[11] VSS=VSS VDD=VDD
Xg124167 NAND2X1 $PINS Z=n_1758 A=n_24 B=data_reg[26] VSS=VSS VDD=VDD
Xg124168 NAND2X1 $PINS Z=n_1752 A=n_24 B=data_reg[61] VSS=VSS VDD=VDD
Xg124169 NAND2X1 $PINS Z=n_1750 A=n_24 B=data_reg[4] VSS=VSS VDD=VDD
Xg124170 NAND2X1 $PINS Z=n_1749 A=n_24 B=data_reg[56] VSS=VSS VDD=VDD
Xg124171 NAND2X1 $PINS Z=n_1748 A=n_24 B=data_reg[18] VSS=VSS VDD=VDD
Xg124172 NOR2X1 $PINS Z=n_1745 A=csm_inst_right_reg[21] B=n_24 VSS=VSS VDD=VDD
Xg124173 NAND2X1 $PINS Z=n_1744 A=n_24 B=data_reg[36] VSS=VSS VDD=VDD
Xg124174 NAND2X1 $PINS Z=n_1743 A=n_24 B=data_reg[12] VSS=VSS VDD=VDD
Xg124175 NAND2X1 $PINS Z=n_1742 A=n_24 B=data_reg[13] VSS=VSS VDD=VDD
Xg124176 NAND2X1 $PINS Z=n_1740 A=n_24 B=data_reg[10] VSS=VSS VDD=VDD
Xg124177 OR2X1 $PINS Z=n_1739 A=csm_inst_right_reg[23] B=n_24 VSS=VSS VDD=VDD
Xg124178 NAND2X1 $PINS Z=n_1738 A=n_24 B=data_reg[2] VSS=VSS VDD=VDD
Xg124179 AND2X1 $PINS Z=n_1737 A=n_318 B=n_30 VSS=VSS VDD=VDD
Xg124180 OR2X1 $PINS Z=n_1733 A=n_492 B=n_75 VSS=VSS VDD=VDD
Xg124181 NAND2X1 $PINS Z=n_1728 A=n_20 B=csm_inst_right_reg[15] VSS=VSS VDD=VDD
Xg124182 NAND2X1 $PINS Z=n_1727 A=n_20 B=csm_inst_right_reg[10] VSS=VSS VDD=VDD
Xg124183 NAND2X1 $PINS Z=n_1723 A=n_20 B=csm_inst_right_reg[1] VSS=VSS VDD=VDD
Xg124184 NAND2X1 $PINS Z=n_1722 A=n_20 B=csm_inst_right_reg[21] VSS=VSS VDD=VDD
Xg124185 NAND2X1 $PINS Z=n_1720 A=n_20 B=csm_inst_right_reg[2] VSS=VSS VDD=VDD
Xg124186 NAND2X1 $PINS Z=n_1719 A=n_20 B=csm_inst_right_reg[18] VSS=VSS VDD=VDD
Xg124187 NAND2X1 $PINS Z=n_1715 A=n_20 B=csm_inst_right_reg[20] VSS=VSS VDD=VDD
Xg124188 NAND2X1 $PINS Z=n_1711 A=n_20 B=csm_inst_right_reg[3] VSS=VSS VDD=VDD
Xg124189 NAND2X1 $PINS Z=n_1710 A=n_20 B=csm_inst_right_reg[19] VSS=VSS VDD=VDD
Xg124190 NAND2X1 $PINS Z=n_1707 A=n_20 B=csm_inst_right_reg[12] VSS=VSS VDD=VDD
Xg124191 NAND2X1 $PINS Z=n_1706 A=n_20 B=csm_inst_right_reg[0] VSS=VSS VDD=VDD
Xg124192 NAND2X1 $PINS Z=n_1705 A=n_20 B=csm_inst_right_reg[4] VSS=VSS VDD=VDD
Xg124193 NAND2X1 $PINS Z=n_1702 A=n_20 B=csm_inst_right_reg[23] VSS=VSS VDD=VDD
Xg124194 NAND2X1 $PINS Z=n_1700 A=n_20 B=csm_inst_right_reg[5] VSS=VSS VDD=VDD
Xg124195 NAND2X1 $PINS Z=n_1696 A=n_20 B=csm_inst_right_reg[24] VSS=VSS VDD=VDD
Xg124196 NAND2X1 $PINS Z=n_1695 A=n_20 B=csm_inst_right_reg[25] VSS=VSS VDD=VDD
Xg124197 NAND2X1 $PINS Z=n_1693 A=n_20 B=csm_inst_right_reg[6] VSS=VSS VDD=VDD
Xg124198 NAND2X1 $PINS Z=n_1692 A=n_20 B=csm_inst_right_reg[26] VSS=VSS VDD=VDD
Xg124199 NAND2X1 $PINS Z=n_1688 A=n_20 B=csm_inst_right_reg[27] VSS=VSS VDD=VDD
Xg124200 NAND2X1 $PINS Z=n_1682 A=n_20 B=csm_inst_right_reg[28] VSS=VSS VDD=VDD
Xg124201 NAND2X1 $PINS Z=n_1680 A=n_20 B=csm_inst_right_reg[17] VSS=VSS VDD=VDD
Xg124202 NAND2X1 $PINS Z=n_1679 A=n_20 B=csm_inst_right_reg[7] VSS=VSS VDD=VDD
Xg124203 NAND2X1 $PINS Z=n_1677 A=n_20 B=csm_inst_right_reg[29] VSS=VSS VDD=VDD
Xg124204 NAND2X1 $PINS Z=n_1676 A=n_20 B=csm_inst_right_reg[30] VSS=VSS VDD=VDD
Xg124205 NAND2X1 $PINS Z=n_1674 A=n_20 B=csm_inst_right_reg[8] VSS=VSS VDD=VDD
Xg124206 NAND2X1 $PINS Z=n_1672 A=n_20 B=csm_inst_right_reg[9] VSS=VSS VDD=VDD
Xg124207 NAND2X1 $PINS Z=n_1671 A=n_20 B=csm_inst_right_reg[31] VSS=VSS VDD=VDD
Xg124208 NAND2X1 $PINS Z=n_1669 A=n_20 B=csm_inst_right_reg[14] VSS=VSS VDD=VDD
Xg124209 NAND2X1 $PINS Z=n_1668 A=n_20 B=csm_inst_right_reg[16] VSS=VSS VDD=VDD
Xg124210 NAND2X1 $PINS Z=n_1664 A=n_20 B=csm_inst_right_reg[11] VSS=VSS VDD=VDD
Xg124211 NAND2X1 $PINS Z=n_1645 A=n_20 B=csm_inst_right_reg[13] VSS=VSS VDD=VDD
Xg124212 NAND2X1 $PINS Z=n_1642 A=n_20 B=csm_inst_right_reg[22] VSS=VSS VDD=VDD
Xg124213 NAND2X1 $PINS Z=n_1641 A=n_423 B=n_521 VSS=VSS VDD=VDD
Xg124214 NAND2X1 $PINS Z=n_1640 A=n_423 B=n_492 VSS=VSS VDD=VDD
Xg124215 NAND2X1 $PINS Z=n_1639 A=n_435 B=csm_inst_state[1] VSS=VSS VDD=VDD
Xg124216 OR2X1 $PINS Z=n_1638 A=n_620 B=n_428 VSS=VSS VDD=VDD
Xg124217 NAND2X1 $PINS Z=n_1637 A=n_425 B=n_467 VSS=VSS VDD=VDD
Xg124218 OR2X1 $PINS Z=n_1635 A=n_617 B=n_433 VSS=VSS VDD=VDD
Xg124219 NAND2X1 $PINS Z=n_1634 A=n_430 B=n_529 VSS=VSS VDD=VDD
Xg124220 NOR2X1 $PINS Z=n_1633 A=n_68 B=n_649 VSS=VSS VDD=VDD
Xg124221 NAND2X1 $PINS Z=n_1631 A=n_410 B=csm_inst_right_reg[30] VSS=VSS
+ VDD=VDD
Xg124222 OR2X1 $PINS Z=n_1629 A=n_700 B=n_428 VSS=VSS VDD=VDD
Xg124223 NAND2X1 $PINS Z=n_1626 A=n_695 B=csm_inst_round_counter[0] VSS=VSS
+ VDD=VDD
Xg124224 NAND2X1 $PINS Z=n_1625 A=n_637 B=n_231 VSS=VSS VDD=VDD
Xg124225 NAND2X1 $PINS Z=n_1624 A=n_609 B=n_67 VSS=VSS VDD=VDD
Xg124226 OR2X1 $PINS Z=n_1623 A=n_46 B=n_700 VSS=VSS VDD=VDD
Xg124227 NAND2X1 $PINS Z=n_1621 A=n_430 B=n_647 VSS=VSS VDD=VDD
Xg124228 NAND2X1 $PINS Z=n_1618 A=n_410 B=csm_inst_right_reg[12] VSS=VSS
+ VDD=VDD
Xg124229 NAND2X1 $PINS Z=n_1617 A=n_431 B=n_626 VSS=VSS VDD=VDD
Xg124230 NAND2X1 $PINS Z=n_1615 A=n_425 B=n_670 VSS=VSS VDD=VDD
Xg124231 NAND2X1 $PINS Z=n_1614 A=n_430 B=n_679 VSS=VSS VDD=VDD
Xg124232 NAND2X1 $PINS Z=n_1612 A=n_427 B=n_600 VSS=VSS VDD=VDD
Xg124233 NAND2X1 $PINS Z=n_1611 A=n_423 B=n_496 VSS=VSS VDD=VDD
Xg124234 NOR2X1 $PINS Z=n_1609 A=n_459 B=n_426 VSS=VSS VDD=VDD
Xg124235 NAND2X1 $PINS Z=n_1608 A=n_428 B=n_696 VSS=VSS VDD=VDD
Xg124236 NAND2X1 $PINS Z=n_1607 A=n_415 B=n_700 VSS=VSS VDD=VDD
Xg124237 NAND2X1 $PINS Z=n_1606 A=n_466 B=csm_inst_round_counter[0] VSS=VSS
+ VDD=VDD
Xg124239 NAND2X1 $PINS Z=n_1598 A=n_415 B=n_464 VSS=VSS VDD=VDD
Xg124240 NAND2X1 $PINS Z=n_1597 A=n_594 B=n_699 VSS=VSS VDD=VDD
Xg124241 NAND2X1 $PINS Z=n_1595 A=n_434 B=n_733 VSS=VSS VDD=VDD
Xg124242 NAND2X1 $PINS Z=n_1594 A=n_423 B=n_720 VSS=VSS VDD=VDD
Xg124243 OR2X1 $PINS Z=n_1593 A=n_46 B=n_699 VSS=VSS VDD=VDD
Xg124244 NAND2X1 $PINS Z=n_1592 A=n_415 B=n_657 VSS=VSS VDD=VDD
Xg124245 OR2X1 $PINS Z=n_1591 A=n_460 B=n_428 VSS=VSS VDD=VDD
Xg124246 NAND2X1 $PINS Z=n_1588 A=n_428 B=n_466 VSS=VSS VDD=VDD
Xg124247 NAND2X1 $PINS Z=n_1587 A=n_594 B=n_702 VSS=VSS VDD=VDD
Xg124248 NAND2X1 $PINS Z=n_1584 A=n_458 B=n_80 VSS=VSS VDD=VDD
Xg124249 NAND2X1 $PINS Z=n_1583 A=n_436 B=n_727 VSS=VSS VDD=VDD
Xg124250 NAND2X1 $PINS Z=n_1582 A=n_410 B=csm_inst_right_reg[5] VSS=VSS VDD=VDD
Xg124251 OR2X1 $PINS Z=n_1579 A=n_483 B=n_439 VSS=VSS VDD=VDD
Xg124252 NAND2X1 $PINS Z=n_1578 A=n_638 B=n_67 VSS=VSS VDD=VDD
Xg124253 OR2X1 $PINS Z=n_1577 A=n_467 B=n_439 VSS=VSS VDD=VDD
Xg124254 NAND2X1 $PINS Z=n_1575 A=n_648 B=csm_inst_round_counter[0] VSS=VSS
+ VDD=VDD
Xg124255 NAND2X1 $PINS Z=n_1574 A=n_427 B=n_615 VSS=VSS VDD=VDD
Xg124256 NAND2X1 $PINS Z=n_1573 A=n_594 B=n_658 VSS=VSS VDD=VDD
Xg124257 NOR2X1 $PINS Z=n_1572 A=n_453 B=n_439 VSS=VSS VDD=VDD
Xg124258 NAND2X1 $PINS Z=n_1571 A=n_410 B=data_reg[41] VSS=VSS VDD=VDD
Xg124259 NAND2X1 $PINS Z=n_1570 A=n_415 B=n_453 VSS=VSS VDD=VDD
Xg124260 NAND2X1 $PINS Z=n_1569 A=n_410 B=csm_inst_right_reg[3] VSS=VSS VDD=VDD
Xg124261 NOR2X1 $PINS Z=n_1567 A=csm_inst_round_counter[2] B=n_633 VSS=VSS
+ VDD=VDD
Xg124262 NAND2X1 $PINS Z=n_1566 A=n_470 B=n_74 VSS=VSS VDD=VDD
Xg124263 NAND2X1 $PINS Z=n_1565 A=n_410 B=data_reg[5] VSS=VSS VDD=VDD
Xg124264 NAND2X1 $PINS Z=n_1564 A=n_461 B=n_69 VSS=VSS VDD=VDD
Xg124265 AND2X1 $PINS Z=n_1561 A=n_442 B=n_465 VSS=VSS VDD=VDD
Xg124266 NAND2X1 $PINS Z=n_1560 A=n_439 B=n_481 VSS=VSS VDD=VDD
Xg124267 NAND2X1 $PINS Z=n_1559 A=n_610 B=n_70 VSS=VSS VDD=VDD
Xg124268 NAND2X1 $PINS Z=n_1558 A=n_430 B=n_658 VSS=VSS VDD=VDD
Xg124269 OR2X1 $PINS Z=n_1557 A=n_714 B=n_430 VSS=VSS VDD=VDD
Xg124270 NOR2X1 $PINS Z=n_1554 A=n_71 B=n_608 VSS=VSS VDD=VDD
Xg124271 NOR2X1 $PINS Z=n_1549 A=n_46 B=n_461 VSS=VSS VDD=VDD
Xg124272 NAND2X1 $PINS Z=n_1547 A=n_634 B=n_67 VSS=VSS VDD=VDD
Xg124273 NAND2X1 $PINS Z=n_1546 A=n_457 B=n_697 VSS=VSS VDD=VDD
Xg124274 NAND2X1 $PINS Z=n_1545 A=n_423 B=n_734 VSS=VSS VDD=VDD
Xg124275 OR2X1 $PINS Z=n_1543 A=n_617 B=n_429 VSS=VSS VDD=VDD
Xg124276 NAND2X1 $PINS Z=n_1542 A=n_427 B=n_476 VSS=VSS VDD=VDD
Xg124277 NAND2X1 $PINS Z=n_1541 A=n_644 B=n_83 VSS=VSS VDD=VDD
Xg124278 NAND2X1 $PINS Z=n_1540 A=n_423 B=n_611 VSS=VSS VDD=VDD
Xg124279 NAND2X1 $PINS Z=n_1537 A=n_423 B=n_639 VSS=VSS VDD=VDD
Xg124280 NAND2X1 $PINS Z=n_1534 A=n_427 B=n_716 VSS=VSS VDD=VDD
Xg124281 NAND2X1 $PINS Z=n_1531 A=n_475 B=n_74 VSS=VSS VDD=VDD
Xg124282 NAND2X1 $PINS Z=n_1530 A=n_442 B=n_532 VSS=VSS VDD=VDD
Xg124283 OR2X1 $PINS Z=n_1527 A=n_46 B=n_653 VSS=VSS VDD=VDD
Xg124284 NAND2X1 $PINS Z=n_1524 A=n_410 B=csm_inst_right_reg[4] VSS=VSS VDD=VDD
Xg124285 NOR2X1 $PINS Z=n_1523 A=n_66 B=n_625 VSS=VSS VDD=VDD
Xg124286 NAND2X1 $PINS Z=n_1521 A=n_438 B=n_620 VSS=VSS VDD=VDD
Xg124287 NAND2X1 $PINS Z=n_1520 A=n_434 B=n_634 VSS=VSS VDD=VDD
Xg124288 NAND2X1 $PINS Z=n_1511 A=n_660 B=n_14 VSS=VSS VDD=VDD
Xg124289 OR2X1 $PINS Z=n_1510 A=n_66 B=n_738 VSS=VSS VDD=VDD
Xg124290 NAND2X1 $PINS Z=n_1509 A=n_635 B=n_74 VSS=VSS VDD=VDD
Xg124291 NAND2X1 $PINS Z=n_1507 A=n_415 B=n_467 VSS=VSS VDD=VDD
Xg124292 NAND2X1 $PINS Z=n_1504 A=n_717 B=n_67 VSS=VSS VDD=VDD
Xg124293 NAND2X1 $PINS Z=n_1502 A=n_632 B=n_70 VSS=VSS VDD=VDD
Xg124294 NAND2X1 $PINS Z=n_1501 A=n_423 B=n_495 VSS=VSS VDD=VDD
Xg124295 NAND2X1 $PINS Z=n_1500 A=n_479 B=n_83 VSS=VSS VDD=VDD
Xg124296 NAND2X1 $PINS Z=n_1494 A=n_602 B=n_74 VSS=VSS VDD=VDD
Xg124297 NAND2X1 $PINS Z=n_1492 A=n_594 B=n_633 VSS=VSS VDD=VDD
Xg124298 NAND2X1 $PINS Z=n_1491 A=n_431 B=n_695 VSS=VSS VDD=VDD
Xg124299 OR2X1 $PINS Z=n_1486 A=n_69 B=n_627 VSS=VSS VDD=VDD
Xg124300 NAND2X1 $PINS Z=n_1482 A=n_410 B=csm_inst_right_reg[27] VSS=VSS
+ VDD=VDD
Xg124301 NAND2X1 $PINS Z=n_1475 A=n_436 B=n_618 VSS=VSS VDD=VDD
Xg124302 NAND2X1 $PINS Z=n_1473 A=n_425 B=n_679 VSS=VSS VDD=VDD
Xg124303 NAND2X1 $PINS Z=n_1471 A=n_74 B=n_729 VSS=VSS VDD=VDD
Xg124304 OR2X1 $PINS Z=n_1470 A=n_74 B=n_474 VSS=VSS VDD=VDD
Xg124305 OR2X1 $PINS Z=n_1469 A=n_607 B=n_436 VSS=VSS VDD=VDD
Xg124306 AND2X1 $PINS Z=n_1467 A=n_561 B=n_585 VSS=VSS VDD=VDD
Xg124307 NAND2X1 $PINS Z=n_1462 A=n_431 B=n_607 VSS=VSS VDD=VDD
Xg124308 NAND2X1 $PINS Z=n_1461 A=n_434 B=n_518 VSS=VSS VDD=VDD
Xg124309 OR2X1 $PINS Z=n_1457 A=n_452 B=n_594 VSS=VSS VDD=VDD
Xg124310 NAND2X1 $PINS Z=n_1456 A=n_594 B=n_461 VSS=VSS VDD=VDD
Xg124311 NAND2X1 $PINS Z=n_1452 A=n_438 B=n_462 VSS=VSS VDD=VDD
Xg124312 OR2X1 $PINS Z=n_1446 A=n_630 B=n_431 VSS=VSS VDD=VDD
Xg124313 OR2X1 $PINS Z=n_1444 A=n_14 B=n_617 VSS=VSS VDD=VDD
Xg124314 NAND2X1 $PINS Z=n_1443 A=n_672 B=n_83 VSS=VSS VDD=VDD
Xg124315 NAND2X1 $PINS Z=n_1440 A=n_526 B=n_69 VSS=VSS VDD=VDD
Xg124316 NAND2X1 $PINS Z=n_1435 A=n_428 B=n_712 VSS=VSS VDD=VDD
Xg124317 OR2X1 $PINS Z=n_1428 A=csm_inst_mode B=n_667 VSS=VSS VDD=VDD
Xg124318 NAND2X1 $PINS Z=n_1426 A=n_410 B=csm_inst_right_reg[19] VSS=VSS
+ VDD=VDD
Xg124319 NAND2X1 $PINS Z=n_1424 A=n_608 B=n_67 VSS=VSS VDD=VDD
Xg124320 NAND2X1 $PINS Z=n_1421 A=n_415 B=n_676 VSS=VSS VDD=VDD
Xg124321 NAND2X1 $PINS Z=n_1420 A=n_427 B=n_652 VSS=VSS VDD=VDD
Xg124322 NAND2X1 $PINS Z=n_1418 A=n_430 B=n_601 VSS=VSS VDD=VDD
Xg124324 NAND2X1 $PINS Z=n_1415 A=n_410 B=csm_inst_right_reg[26] VSS=VSS
+ VDD=VDD
Xg124325 NAND2X1 $PINS Z=n_1413 A=n_696 B=n_69 VSS=VSS VDD=VDD
Xg124326 NAND2X1 $PINS Z=n_1412 A=n_415 B=n_468 VSS=VSS VDD=VDD
Xg124327 NAND2X1 $PINS Z=n_1411 A=n_415 B=n_606 VSS=VSS VDD=VDD
Xg124328 NAND2X1 $PINS Z=n_1405 A=n_423 B=n_470 VSS=VSS VDD=VDD
Xg124329 NAND2X1 $PINS Z=n_1404 A=n_431 B=n_638 VSS=VSS VDD=VDD
Xg124330 NOR2X1 $PINS Z=n_1403 A=n_450 B=n_426 VSS=VSS VDD=VDD
Xg124331 NAND2X1 $PINS Z=n_1400 A=n_744 B=n_134 VSS=VSS VDD=VDD
Xg124332 NAND2X1 $PINS Z=n_1399 A=n_415 B=n_601 VSS=VSS VDD=VDD
Xg124333 OR2X1 $PINS Z=n_1397 A=n_69 B=n_694 VSS=VSS VDD=VDD
Xg124334 NAND2X1 $PINS Z=n_1396 A=n_637 B=n_546 VSS=VSS VDD=VDD
Xg124335 NAND2X1 $PINS Z=n_1393 A=n_425 B=n_497 VSS=VSS VDD=VDD
Xg124336 NAND2X1 $PINS Z=n_1392 A=n_439 B=n_632 VSS=VSS VDD=VDD
Xg124337 NAND2X1 $PINS Z=n_1391 A=n_430 B=n_635 VSS=VSS VDD=VDD
Xg124338 NAND2X1 $PINS Z=n_1390 A=n_427 B=n_696 VSS=VSS VDD=VDD
Xg124339 NAND2X1 $PINS Z=n_1389 A=n_427 B=n_629 VSS=VSS VDD=VDD
Xg124340 NAND2X1 $PINS Z=n_1388 A=n_425 B=n_642 VSS=VSS VDD=VDD
Xg124341 NAND2X1 $PINS Z=n_1386 A=n_423 B=n_646 VSS=VSS VDD=VDD
Xg124342 NAND2X1 $PINS Z=n_1385 A=n_434 B=n_627 VSS=VSS VDD=VDD
Xg124343 OR2X1 $PINS Z=n_1384 A=n_663 B=n_439 VSS=VSS VDD=VDD
Xg124344 NAND2X1 $PINS Z=n_1383 A=n_463 B=n_68 VSS=VSS VDD=VDD
Xg124345 NAND2X1 $PINS Z=n_1382 A=n_427 B=n_653 VSS=VSS VDD=VDD
Xg124346 NAND2X1 $PINS Z=n_1381 A=n_543 B=n_554 VSS=VSS VDD=VDD
Xg124347 NAND2X1 $PINS Z=n_1380 A=n_415 B=n_702 VSS=VSS VDD=VDD
Xg124348 NAND2X1 $PINS Z=n_1379 A=n_430 B=n_471 VSS=VSS VDD=VDD
Xg124349 NAND2X1 $PINS Z=n_1374 A=n_415 B=n_628 VSS=VSS VDD=VDD
Xg124350 NAND2X1 $PINS Z=n_1368 A=n_612 B=n_70 VSS=VSS VDD=VDD
Xg124351 NAND2X1 $PINS Z=n_1367 A=n_474 B=n_70 VSS=VSS VDD=VDD
Xg124352 NAND2X1 $PINS Z=n_1365 A=n_410 B=data_reg[3] VSS=VSS VDD=VDD
Xg124353 NAND2X1 $PINS Z=n_1363 A=n_427 B=n_492 VSS=VSS VDD=VDD
Xg124354 NAND2X1 $PINS Z=n_1362 A=n_501 B=n_68 VSS=VSS VDD=VDD
Xg124355 NAND2X1 $PINS Z=n_1360 A=n_415 B=n_460 VSS=VSS VDD=VDD
Xg124356 NAND2X1 $PINS Z=n_1359 A=n_430 B=n_683 VSS=VSS VDD=VDD
Xg124357 NAND2X1 $PINS Z=n_1356 A=n_67 B=n_726 VSS=VSS VDD=VDD
Xg124358 NAND2X1 $PINS Z=n_1353 A=n_626 B=csm_inst_round_counter[0] VSS=VSS
+ VDD=VDD
Xg124359 NAND2X1 $PINS Z=n_1352 A=n_467 B=n_74 VSS=VSS VDD=VDD
Xg124360 NAND2X1 $PINS Z=n_1351 A=n_425 B=n_606 VSS=VSS VDD=VDD
Xg124361 NAND2X1 $PINS Z=n_1348 A=n_427 B=n_499 VSS=VSS VDD=VDD
Xg124362 NAND2X1 $PINS Z=n_1344 A=n_410 B=csm_inst_right_reg[17] VSS=VSS
+ VDD=VDD
Xg124363 OR2X1 $PINS Z=n_1342 A=n_67 B=n_738 VSS=VSS VDD=VDD
Xg124364 NAND2X1 $PINS Z=n_1340 A=n_703 B=n_70 VSS=VSS VDD=VDD
Xg124365 NAND2X1 $PINS Z=n_1339 A=n_425 B=n_645 VSS=VSS VDD=VDD
Xg124366 NAND2X1 $PINS Z=n_1338 A=n_594 B=n_663 VSS=VSS VDD=VDD
Xg124368 NAND2X1 $PINS Z=n_1337 A=n_438 B=n_460 VSS=VSS VDD=VDD
Xg124369 OR2X1 $PINS Z=n_1334 A=n_70 B=n_650 VSS=VSS VDD=VDD
Xg124370 NAND2X1 $PINS Z=n_1330 A=n_607 B=n_70 VSS=VSS VDD=VDD
Xg124371 NOR2X1 $PINS Z=n_1850 A=n_737 B=n_439 VSS=VSS VDD=VDD
Xg124372 NAND2X1 $PINS Z=n_1847 A=n_705 B=n_67 VSS=VSS VDD=VDD
Xg124374 NAND2X1 $PINS Z=n_1322 A=n_509 B=n_14 VSS=VSS VDD=VDD
Xg124375 NAND2X1 $PINS Z=n_1846 A=n_594 B=n_740 VSS=VSS VDD=VDD
Xg124376 NAND2X1 $PINS Z=n_1845 A=n_436 B=n_529 VSS=VSS VDD=VDD
Xg124377 NAND2X1 $PINS Z=n_1844 A=n_707 B=csm_inst_round_counter[0] VSS=VSS
+ VDD=VDD
Xg124379 NAND2X1 $PINS Z=n_1843 A=n_556 B=n_539 VSS=VSS VDD=VDD
Xg124382 NAND2X1 $PINS Z=n_1841 A=n_578 B=n_359 VSS=VSS VDD=VDD
Xg124383 NAND2X1 $PINS Z=n_1839 A=n_594 B=n_682 VSS=VSS VDD=VDD
Xg124384 NAND2X1 $PINS Z=n_1318 A=n_649 B=n_14 VSS=VSS VDD=VDD
Xg124385 NAND2X1 $PINS Z=n_1836 A=n_503 B=csm_inst_round_counter[0] VSS=VSS
+ VDD=VDD
Xg124446 NAND2X1 $PINS Z=n_1830 A=n_656 B=spi_inst_bit_cnt[3] VSS=VSS VDD=VDD
Xg124452 INVX2 $PINS Z=n_1314 A=n_1313 VSS=VSS VDD=VDD
Xg124453 INVX2 $PINS Z=n_1310 A=n_1309 VSS=VSS VDD=VDD
Xg124454 INVX2 $PINS Z=n_1298 A=n_1295 VSS=VSS VDD=VDD
Xg124458 XOR2X1 $PINS Z=n_1281 A=spi_inst_bit_cnt[2] B=n_98 VSS=VSS VDD=VDD
Xg124459 NAND2X1 $PINS Z=n_1280 A=n_431 B=n_634 VSS=VSS VDD=VDD
Xg124460 NAND2X1 $PINS Z=n_1278 A=n_427 B=n_666 VSS=VSS VDD=VDD
Xg124461 NAND2X1 $PINS Z=n_1275 A=n_439 B=n_644 VSS=VSS VDD=VDD
Xg124462 OR2X1 $PINS Z=n_1271 A=n_525 B=n_594 VSS=VSS VDD=VDD
Xg124463 NAND2X1 $PINS Z=n_1270 A=n_425 B=n_601 VSS=VSS VDD=VDD
Xg124464 NAND2X1 $PINS Z=n_1269 A=n_483 B=n_74 VSS=VSS VDD=VDD
Xg124465 NAND2X1 $PINS Z=n_1268 A=n_428 B=n_608 VSS=VSS VDD=VDD
Xg124466 NAND2X1 $PINS Z=n_1267 A=n_642 B=n_69 VSS=VSS VDD=VDD
Xg124467 AND2X1 $PINS Z=n_1262 A=n_430 B=n_628 VSS=VSS VDD=VDD
Xg124468 OR2X1 $PINS Z=n_1253 A=n_676 B=n_428 VSS=VSS VDD=VDD
Xg124469 NAND2X1 $PINS Z=n_1252 A=n_410 B=csm_inst_right_reg[6] VSS=VSS VDD=VDD
Xg124470 NAND2X1 $PINS Z=n_1251 A=n_415 B=n_641 VSS=VSS VDD=VDD
Xg124471 MUX2X1 $PINS Z=n_1248 A=key_reg[50] B=spi_rx_data[50] S=n_59 VSS=VSS
+ VDD=VDD
Xg124472 NAND2X1 $PINS Z=n_1247 A=n_438 B=n_635 VSS=VSS VDD=VDD
Xg124473 NAND2X1 $PINS Z=n_1246 A=n_458 B=n_67 VSS=VSS VDD=VDD
Xg124474 OR2X1 $PINS Z=n_1245 A=n_69 B=n_706 VSS=VSS VDD=VDD
Xg124475 NOR2X1 $PINS Z=n_1244 A=n_68 B=n_612 VSS=VSS VDD=VDD
Xg124476 OR2X1 $PINS Z=n_1243 A=n_70 B=n_518 VSS=VSS VDD=VDD
Xg124477 NAND2X1 $PINS Z=n_1240 A=n_645 B=n_69 VSS=VSS VDD=VDD
Xg124478 NAND2X1 $PINS Z=n_1232 A=n_708 B=n_70 VSS=VSS VDD=VDD
Xg124479 NAND2X1 $PINS Z=n_1231 A=n_430 B=n_468 VSS=VSS VDD=VDD
Xg124480 OR2X1 $PINS Z=n_1230 A=n_74 B=n_611 VSS=VSS VDD=VDD
Xg124481 NAND2X1 $PINS Z=n_1228 A=n_681 B=n_70 VSS=VSS VDD=VDD
Xg124482 OR2X1 $PINS Z=n_1227 A=n_80 B=n_650 VSS=VSS VDD=VDD
Xg124483 OR2X1 $PINS Z=n_1226 A=n_468 B=n_428 VSS=VSS VDD=VDD
Xg124484 OR2X1 $PINS Z=n_1225 A=n_716 B=n_594 VSS=VSS VDD=VDD
Xg124485 NAND2X1 $PINS Z=n_1224 A=n_431 B=n_531 VSS=VSS VDD=VDD
Xg124486 MUX2X1 $PINS Z=n_1223 A=key_reg[49] B=spi_rx_data[49] S=n_59 VSS=VSS
+ VDD=VDD
Xg124487 OR2X1 $PINS Z=n_1222 A=n_68 B=n_499 VSS=VSS VDD=VDD
Xg124488 NOR2X1 $PINS Z=n_1219 A=n_66 B=n_455 VSS=VSS VDD=VDD
Xg124489 NAND2X1 $PINS Z=n_1218 A=n_431 B=n_481 VSS=VSS VDD=VDD
Xg124490 NAND2X1 $PINS Z=n_1217 A=n_427 B=n_713 VSS=VSS VDD=VDD
Xg124491 NAND2X1 $PINS Z=n_1216 A=n_428 B=n_629 VSS=VSS VDD=VDD
Xg124492 NAND2X1 $PINS Z=n_1215 A=n_410 B=data_reg[59] VSS=VSS VDD=VDD
Xg124493 NAND2X1 $PINS Z=n_1212 A=n_346 B=n_168 VSS=VSS VDD=VDD
Xg124494 NOR2X1 $PINS Z=n_1209 A=csm_inst_round_counter[2] B=n_630 VSS=VSS
+ VDD=VDD
Xg124495 NAND2X1 $PINS Z=n_1208 A=n_423 B=n_688 VSS=VSS VDD=VDD
Xg124496 NAND2X1 $PINS Z=n_1206 A=n_495 B=csm_inst_round_counter[0] VSS=VSS
+ VDD=VDD
Xg124497 NAND2X1 $PINS Z=n_1204 A=n_430 B=n_462 VSS=VSS VDD=VDD
Xg124498 AND2X1 $PINS Z=n_1201 A=n_434 B=n_605 VSS=VSS VDD=VDD
Xg124499 OR2X1 $PINS Z=n_1200 A=n_605 B=n_594 VSS=VSS VDD=VDD
Xg124500 NAND2X1 $PINS Z=n_1197 A=n_614 B=n_14 VSS=VSS VDD=VDD
Xg124501 AND2X1 $PINS Z=n_1196 A=n_431 B=n_625 VSS=VSS VDD=VDD
Xg124502 NOR2X1 $PINS Z=n_1192 A=n_68 B=n_522 VSS=VSS VDD=VDD
Xg124503 NAND2X1 $PINS Z=n_1191 A=n_410 B=csm_inst_right_reg[13] VSS=VSS
+ VDD=VDD
Xg124504 NAND2X1 $PINS Z=n_1190 A=n_428 B=n_615 VSS=VSS VDD=VDD
Xg124505 MUX2X1 $PINS Z=n_1189 A=key_reg[52] B=spi_rx_data[52] S=n_59 VSS=VSS
+ VDD=VDD
Xg124506 AND2X1 $PINS Z=n_1188 A=n_423 B=n_465 VSS=VSS VDD=VDD
Xg124507 NOR2X1 $PINS Z=n_1187 A=n_635 B=n_439 VSS=VSS VDD=VDD
Xg124508 OR2X1 $PINS Z=n_1185 A=n_458 B=n_430 VSS=VSS VDD=VDD
Xg124509 MUX2X1 $PINS Z=n_1184 A=key_reg[18] B=spi_rx_data[18] S=n_59 VSS=VSS
+ VDD=VDD
Xg124510 NAND2X1 $PINS Z=n_1183 A=n_427 B=n_455 VSS=VSS VDD=VDD
Xg124511 NAND2X1 $PINS Z=n_1182 A=n_475 B=n_69 VSS=VSS VDD=VDD
Xg124512 OR2X1 $PINS Z=n_1179 A=n_67 B=n_490 VSS=VSS VDD=VDD
Xg124513 NAND2X1 $PINS Z=n_1178 A=n_553 B=n_545 VSS=VSS VDD=VDD
Xg124514 NAND2X1 $PINS Z=n_1177 A=n_669 B=n_70 VSS=VSS VDD=VDD
Xg124515 AND2X1 $PINS Z=n_1176 A=n_457 B=n_688 VSS=VSS VDD=VDD
Xg124516 OR2X1 $PINS Z=n_1175 A=n_237 B=n_513 VSS=VSS VDD=VDD
Xg124517 OR2X1 $PINS Z=n_1174 A=n_68 B=n_450 VSS=VSS VDD=VDD
Xg124518 NAND2X1 $PINS Z=n_1173 A=n_431 B=n_451 VSS=VSS VDD=VDD
Xg124519 NAND2X1 $PINS Z=n_1172 A=n_664 B=n_74 VSS=VSS VDD=VDD
Xg124520 NAND2X1 $PINS Z=n_1171 A=n_438 B=n_468 VSS=VSS VDD=VDD
Xg124521 NAND2X1 $PINS Z=n_1170 A=n_430 B=n_645 VSS=VSS VDD=VDD
Xg124522 NAND2X1 $PINS Z=n_1169 A=n_431 B=n_648 VSS=VSS VDD=VDD
Xg124523 NAND2X1 $PINS Z=n_1167 A=n_427 B=n_503 VSS=VSS VDD=VDD
Xg124524 NAND2X1 $PINS Z=n_1164 A=n_67 B=n_742 VSS=VSS VDD=VDD
Xg124525 MUX2X1 $PINS Z=n_1163 A=key_reg[36] B=spi_rx_data[36] S=n_59 VSS=VSS
+ VDD=VDD
Xg124526 MUX2X1 $PINS Z=n_1162 A=key_reg[25] B=spi_rx_data[25] S=n_59 VSS=VSS
+ VDD=VDD
Xg124527 NAND2X1 $PINS Z=n_1161 A=n_705 B=n_70 VSS=VSS VDD=VDD
Xg124528 NAND2X1 $PINS Z=n_1160 A=n_555 B=n_368 VSS=VSS VDD=VDD
Xg124529 NAND2X1 $PINS Z=n_1159 A=n_425 B=n_628 VSS=VSS VDD=VDD
Xg124530 NAND2X1 $PINS Z=n_1157 A=n_410 B=csm_inst_right_reg[29] VSS=VSS
+ VDD=VDD
Xg124531 NAND2X1 $PINS Z=n_1156 A=n_423 B=n_455 VSS=VSS VDD=VDD
Xg124532 NAND2X1 $PINS Z=n_1153 A=n_681 B=n_67 VSS=VSS VDD=VDD
Xg124533 NAND2X1 $PINS Z=n_1152 A=n_431 B=n_609 VSS=VSS VDD=VDD
Xg124534 NAND2X1 $PINS Z=n_1151 A=n_425 B=n_618 VSS=VSS VDD=VDD
Xg124535 NOR2X1 $PINS Z=n_1149 A=n_68 B=n_658 VSS=VSS VDD=VDD
Xg124536 NAND2X1 $PINS Z=n_1148 A=n_425 B=n_462 VSS=VSS VDD=VDD
Xg124537 NAND2X1 $PINS Z=n_1147 A=n_434 B=n_677 VSS=VSS VDD=VDD
Xg124538 NAND2X1 $PINS Z=n_1146 A=n_597 B=start_decrypt VSS=VSS VDD=VDD
Xg124539 NAND2X1 $PINS Z=n_1143 A=n_70 B=n_533 VSS=VSS VDD=VDD
Xg124540 OR2X1 $PINS Z=n_1142 A=n_641 B=n_428 VSS=VSS VDD=VDD
Xg124541 NAND2X1 $PINS Z=n_1141 A=n_678 B=n_67 VSS=VSS VDD=VDD
Xg124542 NAND2X1 $PINS Z=n_1140 A=n_594 B=n_471 VSS=VSS VDD=VDD
Xg124543 NAND2X1 $PINS Z=n_1139 A=n_410 B=data_reg[31] VSS=VSS VDD=VDD
Xg124544 NAND2X1 $PINS Z=n_1138 A=n_626 B=n_67 VSS=VSS VDD=VDD
Xg124545 NAND2X1 $PINS Z=n_1137 A=n_425 B=n_511 VSS=VSS VDD=VDD
Xg124546 NAND2X1 $PINS Z=n_1136 A=n_633 B=n_69 VSS=VSS VDD=VDD
Xg124547 OR2X1 $PINS Z=n_1135 A=n_642 B=n_431 VSS=VSS VDD=VDD
Xg124548 NAND2X1 $PINS Z=n_1134 A=n_436 B=n_670 VSS=VSS VDD=VDD
Xg124549 NAND2X1 $PINS Z=n_1133 A=n_550 B=n_542 VSS=VSS VDD=VDD
Xg124550 AND2X1 $PINS Z=n_1132 A=n_587 B=n_581 VSS=VSS VDD=VDD
Xg124551 MUX2X1 $PINS Z=n_1131 A=key_reg[38] B=spi_rx_data[38] S=n_59 VSS=VSS
+ VDD=VDD
Xg124552 NAND2X1 $PINS Z=n_1130 A=n_415 B=n_630 VSS=VSS VDD=VDD
Xg124553 AND2X1 $PINS Z=n_1128 A=n_423 B=n_517 VSS=VSS VDD=VDD
Xg124554 NAND2X1 $PINS Z=n_1127 A=n_423 B=n_600 VSS=VSS VDD=VDD
Xg124555 AND2X1 $PINS Z=n_1125 A=n_423 B=n_666 VSS=VSS VDD=VDD
Xg124556 NAND2X1 $PINS Z=n_1124 A=n_430 B=n_692 VSS=VSS VDD=VDD
Xg124557 NAND2X1 $PINS Z=n_1123 A=n_434 B=n_648 VSS=VSS VDD=VDD
Xg124558 NAND2X1 $PINS Z=n_1122 A=n_427 B=n_729 VSS=VSS VDD=VDD
Xg124559 NOR2X1 $PINS Z=n_1121 A=n_68 B=n_511 VSS=VSS VDD=VDD
Xg124560 NAND2X1 $PINS Z=n_1120 A=n_717 B=n_74 VSS=VSS VDD=VDD
Xg124561 NAND2X1 $PINS Z=n_1119 A=n_721 B=n_70 VSS=VSS VDD=VDD
Xg124562 NAND2X1 $PINS Z=n_1118 A=n_410 B=csm_inst_right_reg[7] VSS=VSS VDD=VDD
Xg124563 NOR2X1 $PINS Z=n_1116 A=csm_inst_round_counter[2] B=n_707 VSS=VSS
+ VDD=VDD
Xg124564 NAND2X1 $PINS Z=n_1115 A=n_430 B=n_453 VSS=VSS VDD=VDD
Xg124565 NAND2X1 $PINS Z=n_1114 A=n_451 B=n_74 VSS=VSS VDD=VDD
Xg124566 NAND2X1 $PINS Z=n_1113 A=n_628 B=n_69 VSS=VSS VDD=VDD
Xg124567 NAND2X1 $PINS Z=n_1112 A=n_438 B=n_682 VSS=VSS VDD=VDD
Xg124568 OR2X1 $PINS Z=n_1111 A=n_622 B=n_439 VSS=VSS VDD=VDD
Xg124569 NAND2X1 $PINS Z=n_1110 A=n_602 B=n_80 VSS=VSS VDD=VDD
Xg124570 NAND2X1 $PINS Z=n_1109 A=n_425 B=n_676 VSS=VSS VDD=VDD
Xg124571 NAND2X1 $PINS Z=n_1108 A=n_683 B=n_69 VSS=VSS VDD=VDD
Xg124572 NAND2X1 $PINS Z=n_1107 A=n_425 B=n_647 VSS=VSS VDD=VDD
Xg124573 NAND2X1 $PINS Z=n_1106 A=n_614 B=n_80 VSS=VSS VDD=VDD
Xg124574 MUX2X1 $PINS Z=n_1105 A=key_reg[15] B=spi_rx_data[15] S=n_59 VSS=VSS
+ VDD=VDD
Xg124575 NOR2X1 $PINS Z=n_1103 A=csm_inst_round_counter[2] B=n_673 VSS=VSS
+ VDD=VDD
Xg124576 NAND2X1 $PINS Z=n_1101 A=n_434 B=n_672 VSS=VSS VDD=VDD
Xg124577 NAND2X1 $PINS Z=n_1100 A=n_415 B=n_515 VSS=VSS VDD=VDD
Xg124578 AND2X1 $PINS Z=n_1098 A=n_594 B=n_746 VSS=VSS VDD=VDD
Xg124579 OR2X1 $PINS Z=n_1097 A=n_463 B=n_591 VSS=VSS VDD=VDD
Xg124580 OR2X1 $PINS Z=n_1096 A=n_692 B=n_439 VSS=VSS VDD=VDD
Xg124581 OR2X1 $PINS Z=n_1095 A=n_744 B=n_428 VSS=VSS VDD=VDD
Xg124582 NAND2X1 $PINS Z=n_1094 A=n_511 B=n_74 VSS=VSS VDD=VDD
Xg124583 NAND2X1 $PINS Z=n_1093 A=n_716 B=n_69 VSS=VSS VDD=VDD
Xg124584 NAND2X1 $PINS Z=n_1092 A=n_425 B=n_464 VSS=VSS VDD=VDD
Xg124585 NAND2X1 $PINS Z=n_1091 A=n_434 B=n_452 VSS=VSS VDD=VDD
Xg124586 NAND2X1 $PINS Z=n_1090 A=n_415 B=n_647 VSS=VSS VDD=VDD
Xg124587 NAND2X1 $PINS Z=n_1089 A=n_427 B=n_466 VSS=VSS VDD=VDD
Xg124588 NAND2X1 $PINS Z=n_1088 A=n_712 B=n_67 VSS=VSS VDD=VDD
Xg124589 NAND2X1 $PINS Z=n_1087 A=n_423 B=n_469 VSS=VSS VDD=VDD
Xg124590 OR2X1 $PINS Z=n_1085 A=n_618 B=n_428 VSS=VSS VDD=VDD
Xg124591 OR2X1 $PINS Z=n_1083 A=n_66 B=n_610 VSS=VSS VDD=VDD
Xg124592 OR2X1 $PINS Z=n_1082 A=n_482 B=n_428 VSS=VSS VDD=VDD
Xg124593 OR2X1 $PINS Z=n_1081 A=n_518 B=n_594 VSS=VSS VDD=VDD
Xg124594 NAND2X1 $PINS Z=n_1080 A=n_474 B=n_80 VSS=VSS VDD=VDD
Xg124595 NAND2X1 $PINS Z=n_1079 A=n_425 B=n_522 VSS=VSS VDD=VDD
Xg124596 NAND2X1 $PINS Z=n_1078 A=n_427 B=n_469 VSS=VSS VDD=VDD
Xg124597 NAND2X1 $PINS Z=n_1077 A=n_434 B=n_490 VSS=VSS VDD=VDD
Xg124598 NAND2X1 $PINS Z=n_1076 A=n_415 B=n_682 VSS=VSS VDD=VDD
Xg124599 NAND2X1 $PINS Z=n_1075 A=n_428 B=n_627 VSS=VSS VDD=VDD
Xg124600 NAND2X1 $PINS Z=n_1074 A=n_694 B=n_80 VSS=VSS VDD=VDD
Xg124601 NAND2X1 $PINS Z=n_1073 A=n_451 B=n_67 VSS=VSS VDD=VDD
Xg124602 NOR2X1 $PINS Z=n_1072 A=n_168 B=n_667 VSS=VSS VDD=VDD
Xg124603 NAND2X1 $PINS Z=n_1071 A=n_427 B=n_646 VSS=VSS VDD=VDD
Xg124604 MUX2X1 $PINS Z=n_1070 A=key_reg[9] B=spi_rx_data[9] S=n_59 VSS=VSS
+ VDD=VDD
Xg124605 OR2X1 $PINS Z=n_1069 A=n_74 B=n_702 VSS=VSS VDD=VDD
Xg124606 NAND2X1 $PINS Z=n_1068 A=n_472 B=n_69 VSS=VSS VDD=VDD
Xg124607 NAND2X1 $PINS Z=n_1067 A=n_438 B=n_686 VSS=VSS VDD=VDD
Xg124608 NAND2X1 $PINS Z=n_1065 A=n_415 B=n_475 VSS=VSS VDD=VDD
Xg124609 NAND2X1 $PINS Z=n_1064 A=n_425 B=n_538 VSS=VSS VDD=VDD
Xg124610 NAND2X1 $PINS Z=n_1062 A=n_425 B=n_683 VSS=VSS VDD=VDD
Xg124611 NAND2X1 $PINS Z=n_1059 A=n_638 B=n_69 VSS=VSS VDD=VDD
Xg124612 MUX2X1 $PINS Z=n_1058 A=key_reg[37] B=spi_rx_data[37] S=n_59 VSS=VSS
+ VDD=VDD
Xg124613 NAND2X1 $PINS Z=n_1057 A=n_673 B=n_74 VSS=VSS VDD=VDD
Xg124614 NAND2X1 $PINS Z=n_1056 A=n_427 B=n_524 VSS=VSS VDD=VDD
Xg124615 MUX2X1 $PINS Z=n_1055 A=key_reg[11] B=spi_rx_data[11] S=n_59 VSS=VSS
+ VDD=VDD
Xg124616 OR2X1 $PINS Z=n_1054 A=n_67 B=n_737 VSS=VSS VDD=VDD
Xg124617 OR2X1 $PINS Z=n_1053 A=n_669 B=n_594 VSS=VSS VDD=VDD
Xg124618 OR2X1 $PINS Z=n_1052 A=n_450 B=n_435 VSS=VSS VDD=VDD
Xg124619 MUX2X1 $PINS Z=n_1050 A=key_reg[4] B=spi_rx_data[4] S=n_59 VSS=VSS
+ VDD=VDD
Xg124620 NAND2X1 $PINS Z=n_1049 A=n_436 B=n_692 VSS=VSS VDD=VDD
Xg124621 OR2X1 $PINS Z=n_1048 A=n_74 B=n_654 VSS=VSS VDD=VDD
Xg124622 NAND2X1 $PINS Z=n_1046 A=n_410 B=csm_inst_right_reg[11] VSS=VSS
+ VDD=VDD
Xg124623 OR2X1 $PINS Z=n_1045 A=n_650 B=n_428 VSS=VSS VDD=VDD
Xg124624 NAND2X1 $PINS Z=n_1039 A=n_430 B=n_519 VSS=VSS VDD=VDD
Xg124625 NAND2X1 $PINS Z=n_1038 A=n_674 B=n_83 VSS=VSS VDD=VDD
Xg124626 NAND2X1 $PINS Z=n_1036 A=n_415 B=n_497 VSS=VSS VDD=VDD
Xg124627 NAND2X1 $PINS Z=n_1034 A=n_425 B=n_482 VSS=VSS VDD=VDD
Xg124628 NAND2X1 $PINS Z=n_1033 A=n_649 B=n_70 VSS=VSS VDD=VDD
Xg124629 NOR2X1 $PINS Z=n_1032 A=n_472 B=n_428 VSS=VSS VDD=VDD
Xg124630 NAND2X1 $PINS Z=n_1031 A=n_472 B=n_74 VSS=VSS VDD=VDD
Xg124631 AND2X1 $PINS Z=n_1030 A=n_423 B=n_662 VSS=VSS VDD=VDD
Xg124632 MUX2X1 $PINS Z=n_1028 A=key_reg[22] B=spi_rx_data[22] S=n_59 VSS=VSS
+ VDD=VDD
Xg124633 OR2X1 $PINS Z=n_1026 A=n_69 B=n_496 VSS=VSS VDD=VDD
Xg124634 OR2X1 $PINS Z=n_1025 A=n_483 B=n_428 VSS=VSS VDD=VDD
Xg124635 OR2X1 $PINS Z=n_1023 A=n_463 B=n_416 VSS=VSS VDD=VDD
Xg124636 NAND2X1 $PINS Z=n_1022 A=n_594 B=n_622 VSS=VSS VDD=VDD
Xg124637 NAND2X1 $PINS Z=n_1021 A=n_639 B=n_74 VSS=VSS VDD=VDD
Xg124638 NAND2X1 $PINS Z=n_1019 A=n_431 B=n_509 VSS=VSS VDD=VDD
Xg124639 NAND2X1 $PINS Z=n_1018 A=n_423 B=n_506 VSS=VSS VDD=VDD
Xg124640 OR2X1 $PINS Z=n_1017 A=n_168 B=n_598 VSS=VSS VDD=VDD
Xg124641 NAND2X1 $PINS Z=n_1015 A=n_430 B=n_620 VSS=VSS VDD=VDD
Xg124642 OR2X1 $PINS Z=n_1014 A=n_68 B=n_645 VSS=VSS VDD=VDD
Xg124643 OR2X1 $PINS Z=n_1012 A=n_74 B=n_679 VSS=VSS VDD=VDD
Xg124644 MUX2X1 $PINS Z=n_1011 A=key_reg[26] B=spi_rx_data[26] S=n_59 VSS=VSS
+ VDD=VDD
Xg124645 NAND2X1 $PINS Z=n_1010 A=n_438 B=n_633 VSS=VSS VDD=VDD
Xg124646 NAND2X1 $PINS Z=n_1009 A=n_423 B=n_500 VSS=VSS VDD=VDD
Xg124647 MUX2X1 $PINS Z=n_1008 A=key_reg[34] B=spi_rx_data[34] S=n_59 VSS=VSS
+ VDD=VDD
Xg124648 NAND2X1 $PINS Z=n_1007 A=n_434 B=n_530 VSS=VSS VDD=VDD
Xg124649 NAND2X1 $PINS Z=n_1003 A=n_438 B=n_673 VSS=VSS VDD=VDD
Xg124650 MUX2X1 $PINS Z=n_1001 A=key_reg[27] B=spi_rx_data[27] S=n_59 VSS=VSS
+ VDD=VDD
Xg124651 NAND2X1 $PINS Z=n_999 A=n_425 B=n_461 VSS=VSS VDD=VDD
Xg124652 MUX2X1 $PINS Z=n_998 A=key_reg[35] B=spi_rx_data[35] S=n_59 VSS=VSS
+ VDD=VDD
Xg124653 NOR2X1 $PINS Z=n_995 A=n_66 B=n_660 VSS=VSS VDD=VDD
Xg124654 NAND2X1 $PINS Z=n_994 A=n_436 B=n_606 VSS=VSS VDD=VDD
Xg124655 AND2X1 $PINS Z=n_993 A=n_471 B=n_69 VSS=VSS VDD=VDD
Xg124656 NAND2X1 $PINS Z=n_992 A=n_415 B=n_699 VSS=VSS VDD=VDD
Xg124657 NOR2X1 $PINS Z=n_991 A=n_67 B=n_615 VSS=VSS VDD=VDD
Xg124658 NAND2X1 $PINS Z=n_989 A=n_434 B=n_504 VSS=VSS VDD=VDD
Xg124659 NAND2X1 $PINS Z=n_988 A=n_430 B=n_622 VSS=VSS VDD=VDD
Xg124660 NAND2X1 $PINS Z=n_987 A=n_538 B=n_69 VSS=VSS VDD=VDD
Xg124661 NAND2X1 $PINS Z=n_985 A=n_67 B=n_721 VSS=VSS VDD=VDD
Xg124662 MUX2X1 $PINS Z=n_984 A=key_reg[12] B=spi_rx_data[12] S=n_59 VSS=VSS
+ VDD=VDD
Xg124663 OR2X1 $PINS Z=n_982 A=n_668 B=n_594 VSS=VSS VDD=VDD
Xg124664 NAND2X1 $PINS Z=n_981 A=n_423 B=n_523 VSS=VSS VDD=VDD
Xg124665 NAND2X1 $PINS Z=n_979 A=n_519 B=n_69 VSS=VSS VDD=VDD
Xg124666 NAND2X1 $PINS Z=n_977 A=n_626 B=n_74 VSS=VSS VDD=VDD
Xg124667 MUX2X1 $PINS Z=n_975 A=key_reg[13] B=spi_rx_data[13] S=n_59 VSS=VSS
+ VDD=VDD
Xg124668 NAND2X1 $PINS Z=n_973 A=n_517 B=n_69 VSS=VSS VDD=VDD
Xg124669 OR2X1 $PINS Z=n_972 A=n_67 B=n_704 VSS=VSS VDD=VDD
Xg124670 NAND2X1 $PINS Z=n_971 A=n_606 B=n_74 VSS=VSS VDD=VDD
Xg124671 NAND2X1 $PINS Z=n_970 A=n_427 B=n_517 VSS=VSS VDD=VDD
Xg124672 NAND2X1 $PINS Z=n_969 A=n_415 B=n_482 VSS=VSS VDD=VDD
Xg124673 AND2X1 $PINS Z=n_968 A=n_425 B=n_641 VSS=VSS VDD=VDD
Xg124674 NAND2X1 $PINS Z=n_967 A=n_410 B=csm_inst_right_reg[31] VSS=VSS VDD=VDD
Xg124675 NAND2X1 $PINS Z=n_963 A=n_442 B=n_687 VSS=VSS VDD=VDD
Xg124676 NAND2X1 $PINS Z=n_956 A=n_423 B=n_708 VSS=VSS VDD=VDD
Xg124677 NAND2X1 $PINS Z=n_947 A=n_410 B=data_reg[29] VSS=VSS VDD=VDD
Xg124678 NOR2X1 $PINS Z=n_931 A=n_515 B=n_428 VSS=VSS VDD=VDD
Xg124679 NAND2X1 $PINS Z=n_930 A=n_602 B=n_83 VSS=VSS VDD=VDD
Xg124680 OR2X1 $PINS Z=n_929 A=n_521 B=n_70 VSS=VSS VDD=VDD
Xg124681 OR2X1 $PINS Z=n_928 A=n_74 B=n_665 VSS=VSS VDD=VDD
Xg124682 MUX2X1 $PINS Z=n_927 A=key_reg[14] B=spi_rx_data[14] S=n_59 VSS=VSS
+ VDD=VDD
Xg124683 MUX2X1 $PINS Z=n_926 A=key_reg[39] B=spi_rx_data[39] S=n_59 VSS=VSS
+ VDD=VDD
Xg124684 NAND2X1 $PINS Z=n_925 A=n_434 B=n_612 VSS=VSS VDD=VDD
Xg124685 NAND2X1 $PINS Z=n_924 A=n_717 B=n_70 VSS=VSS VDD=VDD
Xg124686 NAND2X1 $PINS Z=n_923 A=n_427 B=n_693 VSS=VSS VDD=VDD
Xg124687 MUX2X1 $PINS Z=n_922 A=key_reg[53] B=spi_rx_data[53] S=n_59 VSS=VSS
+ VDD=VDD
Xg124688 AND2X1 $PINS Z=n_921 A=n_431 B=n_704 VSS=VSS VDD=VDD
Xg124689 NAND2X1 $PINS Z=n_920 A=n_639 B=n_67 VSS=VSS VDD=VDD
Xg124690 NAND2X1 $PINS Z=n_919 A=n_438 B=n_601 VSS=VSS VDD=VDD
Xg124691 AND2X1 $PINS Z=n_918 A=n_457 B=n_675 VSS=VSS VDD=VDD
Xg124692 OR2X1 $PINS Z=n_917 A=n_67 B=n_712 VSS=VSS VDD=VDD
Xg124693 MUX2X1 $PINS Z=n_916 A=key_reg[2] B=spi_rx_data[2] S=n_59 VSS=VSS
+ VDD=VDD
Xg124694 NAND2X1 $PINS Z=n_914 A=n_687 B=n_67 VSS=VSS VDD=VDD
Xg124695 NAND2X1 $PINS Z=n_913 A=n_425 B=n_453 VSS=VSS VDD=VDD
Xg124696 NAND2X1 $PINS Z=n_912 A=n_423 B=n_653 VSS=VSS VDD=VDD
Xg124697 NAND2X1 $PINS Z=n_911 A=n_430 B=n_707 VSS=VSS VDD=VDD
Xg124698 MUX2X1 $PINS Z=n_910 A=key_reg[44] B=spi_rx_data[44] S=n_59 VSS=VSS
+ VDD=VDD
Xg124699 OR2X1 $PINS Z=n_909 A=n_67 B=n_469 VSS=VSS VDD=VDD
Xg124700 NAND2X1 $PINS Z=n_908 A=n_513 B=csm_inst_round_counter[0] VSS=VSS
+ VDD=VDD
Xg124701 NAND2X1 $PINS Z=n_907 A=n_547 B=n_339 VSS=VSS VDD=VDD
Xg124702 NAND2X1 $PINS Z=n_906 A=n_675 B=n_14 VSS=VSS VDD=VDD
Xg124703 NAND2X1 $PINS Z=n_905 A=n_415 B=n_620 VSS=VSS VDD=VDD
Xg124704 NAND2X1 $PINS Z=n_904 A=n_427 B=n_631 VSS=VSS VDD=VDD
Xg124705 NAND2X1 $PINS Z=n_903 A=n_415 B=n_686 VSS=VSS VDD=VDD
Xg124706 NAND2X1 $PINS Z=n_902 A=n_436 B=n_522 VSS=VSS VDD=VDD
Xg124707 NAND2X1 $PINS Z=n_901 A=n_439 B=n_610 VSS=VSS VDD=VDD
Xg124708 AND2X1 $PINS Z=n_900 A=n_431 B=n_614 VSS=VSS VDD=VDD
Xg124709 MUX2X1 $PINS Z=n_899 A=key_reg[41] B=spi_rx_data[41] S=n_59 VSS=VSS
+ VDD=VDD
Xg124710 NAND3X1 $PINS Z=n_897 A=n_20 B=n_134 C=n_46 VSS=VSS VDD=VDD
Xg124711 OR2X1 $PINS Z=n_896 A=n_463 B=n_437 VSS=VSS VDD=VDD
Xg124712 MUX2X1 $PINS Z=n_895 A=key_reg[20] B=spi_rx_data[20] S=n_59 VSS=VSS
+ VDD=VDD
Xg124713 NAND2X1 $PINS Z=n_894 A=n_423 B=n_631 VSS=VSS VDD=VDD
Xg124714 NAND2X1 $PINS Z=n_893 A=n_549 B=n_576 VSS=VSS VDD=VDD
Xg124715 NAND2X1 $PINS Z=n_892 A=n_431 B=n_654 VSS=VSS VDD=VDD
Xg124716 OR2X1 $PINS Z=n_891 A=n_599 B=n_594 VSS=VSS VDD=VDD
Xg124717 NAND2X1 $PINS Z=n_890 A=n_599 B=n_74 VSS=VSS VDD=VDD
Xg124718 NAND2X1 $PINS Z=n_889 A=n_434 B=n_599 VSS=VSS VDD=VDD
Xg124719 NAND2X1 $PINS Z=n_888 A=n_434 B=n_449 VSS=VSS VDD=VDD
Xg124720 NAND2X1 $PINS Z=n_887 A=n_449 B=n_67 VSS=VSS VDD=VDD
Xg124721 NAND2X1 $PINS Z=n_886 A=n_449 B=n_69 VSS=VSS VDD=VDD
Xg124722 NAND2X1 $PINS Z=n_885 A=n_431 B=n_449 VSS=VSS VDD=VDD
Xg124723 AND2X1 $PINS Z=n_884 A=n_598 B=csm_inst_mode VSS=VSS VDD=VDD
Xg124724 NAND2X1 $PINS Z=n_883 A=n_599 B=n_69 VSS=VSS VDD=VDD
Xg124725 MUX2X1 $PINS Z=n_882 A=key_reg[63] B=spi_rx_data[63] S=n_59 VSS=VSS
+ VDD=VDD
Xg124726 NAND2X1 $PINS Z=n_881 A=n_414 B=n_86 VSS=VSS VDD=VDD
Xg124727 MUX2X1 $PINS Z=n_880 A=key_reg[45] B=spi_rx_data[45] S=n_59 VSS=VSS
+ VDD=VDD
Xg124728 NOR2X1 $PINS Z=n_878 A=active B=n_589 VSS=VSS VDD=VDD
Xg124729 NOR2X1 $PINS Z=n_877 A=active B=n_567 VSS=VSS VDD=VDD
Xg124730 MUX2X1 $PINS Z=n_876 A=key_reg[61] B=spi_rx_data[61] S=n_59 VSS=VSS
+ VDD=VDD
Xg124731 MUX2X1 $PINS Z=n_875 A=key_reg[33] B=spi_rx_data[33] S=n_59 VSS=VSS
+ VDD=VDD
Xg124732 MUX2X1 $PINS Z=n_874 A=key_reg[17] B=spi_rx_data[17] S=n_59 VSS=VSS
+ VDD=VDD
Xg124733 MUX2X1 $PINS Z=n_873 A=key_reg[7] B=spi_rx_data[7] S=n_59 VSS=VSS
+ VDD=VDD
Xg124734 MUX2X1 $PINS Z=n_872 A=key_reg[1] B=spi_rx_data[1] S=n_59 VSS=VSS
+ VDD=VDD
Xg124735 MUX2X1 $PINS Z=n_871 A=key_reg[3] B=spi_rx_data[3] S=n_59 VSS=VSS
+ VDD=VDD
Xg124736 MUX2X1 $PINS Z=n_870 A=key_reg[5] B=spi_rx_data[5] S=n_59 VSS=VSS
+ VDD=VDD
Xg124737 MUX2X1 $PINS Z=n_869 A=key_reg[6] B=spi_rx_data[6] S=n_59 VSS=VSS
+ VDD=VDD
Xg124738 MUX2X1 $PINS Z=n_868 A=key_reg[10] B=spi_rx_data[10] S=n_59 VSS=VSS
+ VDD=VDD
Xg124739 MUX2X1 $PINS Z=n_867 A=key_reg[43] B=spi_rx_data[43] S=n_59 VSS=VSS
+ VDD=VDD
Xg124740 MUX2X1 $PINS Z=n_866 A=key_reg[19] B=spi_rx_data[19] S=n_59 VSS=VSS
+ VDD=VDD
Xg124741 MUX2X1 $PINS Z=n_864 A=key_reg[21] B=spi_rx_data[21] S=n_59 VSS=VSS
+ VDD=VDD
Xg124742 MUX2X1 $PINS Z=n_850 A=key_reg[23] B=spi_rx_data[23] S=n_59 VSS=VSS
+ VDD=VDD
Xg124743 MUX2X1 $PINS Z=n_820 A=key_reg[28] B=spi_rx_data[28] S=n_59 VSS=VSS
+ VDD=VDD
Xg124744 MUX2X1 $PINS Z=n_818 A=key_reg[29] B=spi_rx_data[29] S=n_59 VSS=VSS
+ VDD=VDD
Xg124745 MUX2X1 $PINS Z=n_817 A=key_reg[30] B=spi_rx_data[30] S=n_59 VSS=VSS
+ VDD=VDD
Xg124746 MUX2X1 $PINS Z=n_816 A=key_reg[42] B=spi_rx_data[42] S=n_59 VSS=VSS
+ VDD=VDD
Xg124747 MUX2X1 $PINS Z=n_815 A=key_reg[46] B=spi_rx_data[46] S=n_59 VSS=VSS
+ VDD=VDD
Xg124748 MUX2X1 $PINS Z=n_814 A=key_reg[47] B=spi_rx_data[47] S=n_59 VSS=VSS
+ VDD=VDD
Xg124749 MUX2X1 $PINS Z=n_811 A=key_reg[31] B=spi_rx_data[31] S=n_59 VSS=VSS
+ VDD=VDD
Xg124750 MUX2X1 $PINS Z=n_810 A=key_reg[51] B=spi_rx_data[51] S=n_59 VSS=VSS
+ VDD=VDD
Xg124751 MUX2X1 $PINS Z=n_809 A=key_reg[54] B=spi_rx_data[54] S=n_59 VSS=VSS
+ VDD=VDD
Xg124752 MUX2X1 $PINS Z=n_808 A=key_reg[55] B=spi_rx_data[55] S=n_59 VSS=VSS
+ VDD=VDD
Xg124753 MUX2X1 $PINS Z=n_806 A=key_reg[57] B=spi_rx_data[57] S=n_59 VSS=VSS
+ VDD=VDD
Xg124754 MUX2X1 $PINS Z=n_805 A=key_reg[58] B=spi_rx_data[58] S=n_59 VSS=VSS
+ VDD=VDD
Xg124755 MUX2X1 $PINS Z=n_804 A=key_reg[59] B=spi_rx_data[59] S=n_59 VSS=VSS
+ VDD=VDD
Xg124756 MUX2X1 $PINS Z=n_803 A=key_reg[60] B=spi_rx_data[60] S=n_59 VSS=VSS
+ VDD=VDD
Xg124757 MUX2X1 $PINS Z=n_802 A=key_reg[62] B=spi_rx_data[62] S=n_59 VSS=VSS
+ VDD=VDD
Xg124758 AND2X1 $PINS Z=n_798 A=n_495 B=n_14 VSS=VSS VDD=VDD
Xg124759 NAND2X1 $PINS Z=n_778 A=n_531 B=n_14 VSS=VSS VDD=VDD
Xg124760 AND2X1 $PINS Z=n_768 A=n_476 B=csm_inst_round_counter[0] VSS=VSS
+ VDD=VDD
Xg124761 NAND2X1 $PINS Z=n_1317 A=n_686 B=n_14 VSS=VSS VDD=VDD
Xg124762 NAND2X1 $PINS Z=n_1316 A=n_746 B=n_69 VSS=VSS VDD=VDD
Xg124763 NAND2X1 $PINS Z=n_765 A=n_741 B=n_14 VSS=VSS VDD=VDD
Xg124764 NAND2X1 $PINS Z=n_1313 A=n_74 B=n_526 VSS=VSS VDD=VDD
Xg124765 NAND2X1 $PINS Z=n_1311 A=n_697 B=n_70 VSS=VSS VDD=VDD
Xg124766 NOR2X1 $PINS Z=n_764 A=csm_inst_left_reg[21] B=n_410 VSS=VSS VDD=VDD
Xg124767 NAND2X1 $PINS Z=n_763 A=n_706 B=n_14 VSS=VSS VDD=VDD
Xg124768 AND2X1 $PINS Z=n_762 A=n_694 B=csm_inst_round_counter[0] VSS=VSS
+ VDD=VDD
Xg124770 AND2X1 $PINS Z=n_757 A=n_506 B=n_14 VSS=VSS VDD=VDD
Xg124771 NAND2X1 $PINS Z=n_1309 A=n_743 B=csm_inst_round_counter[0] VSS=VSS
+ VDD=VDD
Xg124772 NOR2X1 $PINS Z=n_1308 A=n_410 B=n_435 VSS=VSS VDD=VDD
Xg124773 NAND2X1 $PINS Z=n_753 A=n_704 B=n_14 VSS=VSS VDD=VDD
Xg124775 AND2X1 $PINS Z=n_1307 A=n_652 B=csm_inst_round_counter[0] VSS=VSS
+ VDD=VDD
Xg124776 NAND2X1 $PINS Z=n_751 A=n_524 B=csm_inst_round_counter[0] VSS=VSS
+ VDD=VDD
Xg124777 NAND2X1 $PINS Z=n_1304 A=n_740 B=n_69 VSS=VSS VDD=VDD
Xg124778 NAND2X1 $PINS Z=n_750 A=n_533 B=n_14 VSS=VSS VDD=VDD
Xg124779 NAND2X1 $PINS Z=n_1302 A=n_720 B=n_14 VSS=VSS VDD=VDD
Xg124780 OR2X1 $PINS Z=n_1301 A=n_66 B=n_523 VSS=VSS VDD=VDD
Xg124781 NAND2X1 $PINS Z=n_1295 A=n_74 B=n_727 VSS=VSS VDD=VDD
Xg124782 NAND2X1 $PINS Z=n_749 A=n_540 B=csm_inst_round_counter[0] VSS=VSS
+ VDD=VDD
Xg124783 NAND2X1 $PINS Z=n_1285 A=n_687 B=csm_inst_round_counter[0] VSS=VSS
+ VDD=VDD
Xg124784 AND2X1 $PINS Z=n_748 A=n_530 B=csm_inst_round_counter[0] VSS=VSS
+ VDD=VDD
Xg124785 NAND2X1 $PINS Z=n_1284 A=n_677 B=csm_inst_round_counter[0] VSS=VSS
+ VDD=VDD
Xg124786 NOR2X1 $PINS Z=n_1282 A=n_24 B=n_20 VSS=VSS VDD=VDD
Xg124788 INVX2 $PINS Z=n_656 A=n_655 VSS=VSS VDD=VDD
Xg124789 INVX2 $PINS Z=n_636 A=n_637 VSS=VSS VDD=VDD
Xg124790 INVX2 $PINS Z=n_598 A=n_597 VSS=VSS VDD=VDD
Xg124791 INVX2 $PINS Z=n_591 A=n_594 VSS=VSS VDD=VDD
Xg124793 NAND2X1 $PINS Z=n_589 A=n_55 B=trigger_operation VSS=VSS VDD=VDD
Xg124794 NAND2X1 $PINS Z=n_587 A=n_95 B=key_reg[5] VSS=VSS VDD=VDD
Xg124795 NAND2X1 $PINS Z=n_585 A=n_97 B=key_reg[55] VSS=VSS VDD=VDD
Xg124796 NAND2X1 $PINS Z=n_584 A=n_97 B=key_reg[59] VSS=VSS VDD=VDD
Xg124797 OR2X1 $PINS Z=n_583 A=key_reg[41] B=n_97 VSS=VSS VDD=VDD
Xg124798 NAND2X1 $PINS Z=n_582 A=n_97 B=key_reg[44] VSS=VSS VDD=VDD
Xg124799 NAND2X1 $PINS Z=n_581 A=n_97 B=key_reg[31] VSS=VSS VDD=VDD
Xg124800 NAND2X1 $PINS Z=n_580 A=n_93 B=key_reg[58] VSS=VSS VDD=VDD
Xg124801 NAND2X1 $PINS Z=n_579 A=n_93 B=key_reg[11] VSS=VSS VDD=VDD
Xg124802 NAND2X1 $PINS Z=n_578 A=n_93 B=key_reg[49] VSS=VSS VDD=VDD
Xg124803 OR2X1 $PINS Z=n_576 A=key_reg[10] B=n_90 VSS=VSS VDD=VDD
Xg124804 NAND2X1 $PINS Z=n_575 A=n_93 B=key_reg[15] VSS=VSS VDD=VDD
Xg124805 NAND2X1 $PINS Z=n_574 A=n_93 B=key_reg[13] VSS=VSS VDD=VDD
Xg124806 NAND2X1 $PINS Z=n_573 A=n_90 B=key_reg[44] VSS=VSS VDD=VDD
Xg124807 NAND2X1 $PINS Z=n_572 A=n_93 B=key_reg[45] VSS=VSS VDD=VDD
Xg124808 NAND2X1 $PINS Z=n_571 A=n_93 B=key_reg[51] VSS=VSS VDD=VDD
Xg124809 NAND2X1 $PINS Z=n_570 A=n_93 B=key_reg[6] VSS=VSS VDD=VDD
Xg124810 NAND2X1 $PINS Z=n_569 A=n_90 B=key_reg[54] VSS=VSS VDD=VDD
Xg124811 NAND2X1 $PINS Z=n_567 A=n_235 B=trigger_operation VSS=VSS VDD=VDD
Xg124812 NAND2X1 $PINS Z=n_566 A=n_90 B=key_reg[33] VSS=VSS VDD=VDD
Xg124813 OR2X1 $PINS Z=n_565 A=key_reg[58] B=n_95 VSS=VSS VDD=VDD
Xg124814 NAND2X1 $PINS Z=n_564 A=n_90 B=key_reg[55] VSS=VSS VDD=VDD
Xg124815 OR2X1 $PINS Z=n_563 A=key_reg[11] B=n_90 VSS=VSS VDD=VDD
Xg124816 NAND2X1 $PINS Z=n_561 A=n_95 B=key_reg[45] VSS=VSS VDD=VDD
Xg124817 NAND2X1 $PINS Z=n_560 A=n_90 B=key_reg[23] VSS=VSS VDD=VDD
Xg124818 NAND2X1 $PINS Z=n_556 A=n_95 B=key_reg[27] VSS=VSS VDD=VDD
Xg124819 NAND2X1 $PINS Z=n_555 A=n_91 B=n_230 VSS=VSS VDD=VDD
Xg124820 NAND2X1 $PINS Z=n_554 A=n_96 B=n_51 VSS=VSS VDD=VDD
Xg124821 NAND2X1 $PINS Z=n_553 A=n_91 B=n_229 VSS=VSS VDD=VDD
Xg124822 NAND2X1 $PINS Z=n_551 A=n_90 B=key_reg[1] VSS=VSS VDD=VDD
Xg124823 OR2X1 $PINS Z=n_550 A=key_reg[3] B=n_95 VSS=VSS VDD=VDD
Xg124824 NAND2X1 $PINS Z=n_549 A=n_91 B=n_228 VSS=VSS VDD=VDD
Xg124825 NAND2X1 $PINS Z=n_548 A=n_90 B=key_reg[61] VSS=VSS VDD=VDD
Xg124826 OR2X1 $PINS Z=n_547 A=key_reg[36] B=n_95 VSS=VSS VDD=VDD
Xg124827 OR2X1 $PINS Z=n_546 A=n_34 B=n_134 VSS=VSS VDD=VDD
Xg124828 OR2X1 $PINS Z=n_545 A=key_reg[19] B=n_90 VSS=VSS VDD=VDD
Xg124829 NOR2X1 $PINS Z=n_544 A=n_48 B=n_59 VSS=VSS VDD=VDD
Xg124830 OR2X1 $PINS Z=n_543 A=key_reg[29] B=n_95 VSS=VSS VDD=VDD
Xg124831 NAND2X1 $PINS Z=n_542 A=n_96 B=n_58 VSS=VSS VDD=VDD
Xg124832 NAND2X1 $PINS Z=n_541 A=n_90 B=key_reg[57] VSS=VSS VDD=VDD
Xg124833 NAND2X1 $PINS Z=n_746 A=n_305 B=n_190 VSS=VSS VDD=VDD
Xg124834 NAND2X1 $PINS Z=n_744 A=n_275 B=n_169 VSS=VSS VDD=VDD
Xg124835 NAND2X1 $PINS Z=n_743 A=n_279 B=n_221 VSS=VSS VDD=VDD
Xg124836 NAND2X1 $PINS Z=n_742 A=n_266 B=n_169 VSS=VSS VDD=VDD
Xg124837 NAND2X1 $PINS Z=n_741 A=n_292 B=n_213 VSS=VSS VDD=VDD
Xg124838 NAND2X1 $PINS Z=n_740 A=n_270 B=n_202 VSS=VSS VDD=VDD
Xg124839 NAND2X1 $PINS Z=n_739 A=n_273 B=n_247 VSS=VSS VDD=VDD
Xg124840 NAND2X1 $PINS Z=n_738 A=n_294 B=n_127 VSS=VSS VDD=VDD
Xg124841 NAND2X1 $PINS Z=n_737 A=n_304 B=n_148 VSS=VSS VDD=VDD
Xg124842 NAND2X1 $PINS Z=n_735 A=n_95 B=key_reg[18] VSS=VSS VDD=VDD
Xg124843 NAND2X1 $PINS Z=n_734 A=n_306 B=n_215 VSS=VSS VDD=VDD
Xg124844 NAND2X1 $PINS Z=n_733 A=n_253 B=n_220 VSS=VSS VDD=VDD
Xg124845 NAND2X1 $PINS Z=n_732 A=n_298 B=n_178 VSS=VSS VDD=VDD
Xg124846 NAND2X1 $PINS Z=n_731 A=n_311 B=n_126 VSS=VSS VDD=VDD
Xg124847 NAND2X1 $PINS Z=n_729 A=n_262 B=n_151 VSS=VSS VDD=VDD
Xg124848 NAND2X1 $PINS Z=n_728 A=n_255 B=n_203 VSS=VSS VDD=VDD
Xg124849 NAND2X1 $PINS Z=n_727 A=n_301 B=n_251 VSS=VSS VDD=VDD
Xg124850 NAND2X1 $PINS Z=n_726 A=n_295 B=n_147 VSS=VSS VDD=VDD
Xg124851 NAND2X1 $PINS Z=n_725 A=n_93 B=key_reg[18] VSS=VSS VDD=VDD
Xg124852 NAND2X1 $PINS Z=n_722 A=n_93 B=key_reg[17] VSS=VSS VDD=VDD
Xg124853 NAND2X1 $PINS Z=n_721 A=n_274 B=n_146 VSS=VSS VDD=VDD
Xg124854 NAND2X1 $PINS Z=n_720 A=n_303 B=n_208 VSS=VSS VDD=VDD
Xg124855 NAND2X1 $PINS Z=n_719 A=n_245 B=n_194 VSS=VSS VDD=VDD
Xg124856 NAND2X1 $PINS Z=n_717 A=n_287 B=n_211 VSS=VSS VDD=VDD
Xg124858 NAND2X1 $PINS Z=n_716 A=n_268 B=n_143 VSS=VSS VDD=VDD
Xg124859 NAND2X1 $PINS Z=n_714 A=n_299 B=n_199 VSS=VSS VDD=VDD
Xg124860 NAND2X1 $PINS Z=n_713 A=n_286 B=n_149 VSS=VSS VDD=VDD
Xg124861 NAND2X1 $PINS Z=n_712 A=n_254 B=n_145 VSS=VSS VDD=VDD
Xg124862 NAND2X1 $PINS Z=n_708 A=n_300 B=n_203 VSS=VSS VDD=VDD
Xg124863 NAND2X1 $PINS Z=n_707 A=n_278 B=n_218 VSS=VSS VDD=VDD
Xg124864 NAND2X1 $PINS Z=n_706 A=n_263 B=n_251 VSS=VSS VDD=VDD
Xg124865 NAND2X1 $PINS Z=n_705 A=n_282 B=n_137 VSS=VSS VDD=VDD
Xg124866 NAND2X1 $PINS Z=n_704 A=n_289 B=n_126 VSS=VSS VDD=VDD
Xg124867 NAND2X1 $PINS Z=n_703 A=n_311 B=n_165 VSS=VSS VDD=VDD
Xg124868 NAND2X1 $PINS Z=n_702 A=n_283 B=n_165 VSS=VSS VDD=VDD
Xg124869 NAND2X1 $PINS Z=n_700 A=n_310 B=n_249 VSS=VSS VDD=VDD
Xg124870 NAND2X1 $PINS Z=n_699 A=n_258 B=n_151 VSS=VSS VDD=VDD
Xg124871 NAND2X1 $PINS Z=n_697 A=n_253 B=n_165 VSS=VSS VDD=VDD
Xg124872 NAND2X1 $PINS Z=n_696 A=n_305 B=n_191 VSS=VSS VDD=VDD
Xg124873 NAND2X1 $PINS Z=n_695 A=n_296 B=n_129 VSS=VSS VDD=VDD
Xg124874 NAND2X1 $PINS Z=n_694 A=n_294 B=n_151 VSS=VSS VDD=VDD
Xg124875 NAND2X1 $PINS Z=n_693 A=n_276 B=n_265 VSS=VSS VDD=VDD
Xg124876 NAND2X1 $PINS Z=n_692 A=n_311 B=n_128 VSS=VSS VDD=VDD
Xg124877 NAND2X1 $PINS Z=n_688 A=n_298 B=n_210 VSS=VSS VDD=VDD
Xg124878 NAND2X1 $PINS Z=n_687 A=n_252 B=n_141 VSS=VSS VDD=VDD
Xg124879 NAND2X1 $PINS Z=n_686 A=n_252 B=n_129 VSS=VSS VDD=VDD
Xg124880 NAND2X1 $PINS Z=n_683 A=n_244 B=n_141 VSS=VSS VDD=VDD
Xg124881 NAND2X1 $PINS Z=n_682 A=n_254 B=n_248 VSS=VSS VDD=VDD
Xg124882 NAND2X1 $PINS Z=n_681 A=n_269 B=n_212 VSS=VSS VDD=VDD
Xg124883 NAND2X1 $PINS Z=n_679 A=n_253 B=n_104 VSS=VSS VDD=VDD
Xg124884 NAND2X1 $PINS Z=n_678 A=n_265 B=n_315 VSS=VSS VDD=VDD
Xg124885 NAND2X1 $PINS Z=n_677 A=n_306 B=n_210 VSS=VSS VDD=VDD
Xg124886 NAND2X1 $PINS Z=n_676 A=n_266 B=n_221 VSS=VSS VDD=VDD
Xg124887 NAND2X1 $PINS Z=n_675 A=n_292 B=n_250 VSS=VSS VDD=VDD
Xg124888 NAND2X1 $PINS Z=n_674 A=n_274 B=n_211 VSS=VSS VDD=VDD
Xg124889 NAND2X1 $PINS Z=n_673 A=n_296 B=n_220 VSS=VSS VDD=VDD
Xg124890 NAND2X1 $PINS Z=n_672 A=n_304 B=n_250 VSS=VSS VDD=VDD
Xg124891 NAND2X1 $PINS Z=n_670 A=n_279 B=n_178 VSS=VSS VDD=VDD
Xg124892 NAND2X1 $PINS Z=n_669 A=n_280 B=n_146 VSS=VSS VDD=VDD
Xg124893 NAND2X1 $PINS Z=n_668 A=n_290 B=n_149 VSS=VSS VDD=VDD
Xg124894 NAND3X1 $PINS Z=n_667 A=n_34 B=csm_inst_state[2] C=n_38 VSS=VSS
+ VDD=VDD
Xg124895 NAND2X1 $PINS Z=n_666 A=n_289 B=n_205 VSS=VSS VDD=VDD
Xg124896 NAND2X1 $PINS Z=n_665 A=n_244 B=n_129 VSS=VSS VDD=VDD
Xg124897 NAND2X1 $PINS Z=n_664 A=n_301 B=n_249 VSS=VSS VDD=VDD
Xg124898 NAND2X1 $PINS Z=n_663 A=n_245 B=n_227 VSS=VSS VDD=VDD
Xg124899 NAND2X1 $PINS Z=n_662 A=n_293 B=n_216 VSS=VSS VDD=VDD
Xg124900 NAND2X1 $PINS Z=n_660 A=n_281 B=n_150 VSS=VSS VDD=VDD
Xg124901 NAND2X1 $PINS Z=n_658 A=n_303 B=n_205 VSS=VSS VDD=VDD
Xg124902 NAND2X1 $PINS Z=n_657 A=n_298 B=n_142 VSS=VSS VDD=VDD
Xg124903 NAND2X1 $PINS Z=n_655 A=n_99 B=spi_inst_bit_cnt[2] VSS=VSS VDD=VDD
Xg124904 NAND2X1 $PINS Z=n_654 A=n_278 B=n_208 VSS=VSS VDD=VDD
Xg124905 NAND2X1 $PINS Z=n_653 A=n_278 B=n_217 VSS=VSS VDD=VDD
Xg124906 NAND2X1 $PINS Z=n_652 A=n_257 B=n_248 VSS=VSS VDD=VDD
Xg124907 NAND2X1 $PINS Z=n_650 A=n_267 B=n_146 VSS=VSS VDD=VDD
Xg124908 NAND2X1 $PINS Z=n_649 A=n_277 B=n_194 VSS=VSS VDD=VDD
Xg124909 NAND2X1 $PINS Z=n_648 A=n_305 B=n_227 VSS=VSS VDD=VDD
Xg124910 NAND2X1 $PINS Z=n_647 A=n_261 B=n_217 VSS=VSS VDD=VDD
Xg124911 NAND2X1 $PINS Z=n_646 A=n_267 B=n_139 VSS=VSS VDD=VDD
Xg124912 NAND2X1 $PINS Z=n_645 A=n_273 B=n_210 VSS=VSS VDD=VDD
Xg124913 NAND2X1 $PINS Z=n_644 A=n_275 B=n_201 VSS=VSS VDD=VDD
Xg124914 NAND2X1 $PINS Z=n_642 A=n_274 B=n_216 VSS=VSS VDD=VDD
Xg124915 NAND2X1 $PINS Z=n_641 A=n_286 B=n_203 VSS=VSS VDD=VDD
Xg124916 NAND2X1 $PINS Z=n_639 A=n_252 B=n_220 VSS=VSS VDD=VDD
Xg124917 NAND2X1 $PINS Z=n_638 A=n_303 B=n_150 VSS=VSS VDD=VDD
Xg124918 NOR2X1 $PINS Z=n_637 A=csm_inst_state[2] B=n_224 VSS=VSS VDD=VDD
Xg124919 NAND2X1 $PINS Z=n_635 A=n_306 B=n_247 VSS=VSS VDD=VDD
Xg124920 NAND2X1 $PINS Z=n_634 A=n_258 B=n_114 VSS=VSS VDD=VDD
Xg124921 NAND2X1 $PINS Z=n_633 A=n_256 B=n_198 VSS=VSS VDD=VDD
Xg124922 NAND2X1 $PINS Z=n_632 A=n_275 B=n_221 VSS=VSS VDD=VDD
Xg124923 NAND2X1 $PINS Z=n_631 A=n_258 B=n_213 VSS=VSS VDD=VDD
Xg124924 NAND2X1 $PINS Z=n_630 A=n_268 B=n_177 VSS=VSS VDD=VDD
Xg124925 NAND2X1 $PINS Z=n_629 A=n_297 B=n_219 VSS=VSS VDD=VDD
Xg124926 NAND2X1 $PINS Z=n_628 A=n_212 B=n_313 VSS=VSS VDD=VDD
Xg124927 NAND2X1 $PINS Z=n_627 A=n_257 B=n_177 VSS=VSS VDD=VDD
Xg124928 NAND2X1 $PINS Z=n_626 A=n_309 B=n_205 VSS=VSS VDD=VDD
Xg124929 NAND2X1 $PINS Z=n_625 A=n_282 B=n_247 VSS=VSS VDD=VDD
Xg124930 NAND2X1 $PINS Z=n_622 A=n_257 B=n_143 VSS=VSS VDD=VDD
Xg124931 NAND2X1 $PINS Z=n_620 A=n_292 B=n_127 VSS=VSS VDD=VDD
Xg124932 NAND2X1 $PINS Z=n_618 A=n_255 B=n_149 VSS=VSS VDD=VDD
Xg124933 AND2X1 $PINS Z=n_617 A=n_264 B=n_215 VSS=VSS VDD=VDD
Xg124934 NAND2X1 $PINS Z=n_615 A=n_272 B=n_204 VSS=VSS VDD=VDD
Xg124935 NAND2X1 $PINS Z=n_614 A=n_277 B=n_214 VSS=VSS VDD=VDD
Xg124936 NAND2X1 $PINS Z=n_612 A=n_302 B=n_127 VSS=VSS VDD=VDD
Xg124937 NAND2X1 $PINS Z=n_611 A=n_279 B=n_142 VSS=VSS VDD=VDD
Xg124938 NAND2X1 $PINS Z=n_610 A=n_276 B=n_148 VSS=VSS VDD=VDD
Xg124939 NAND2X1 $PINS Z=n_609 A=n_310 B=n_139 VSS=VSS VDD=VDD
Xg124940 NAND2X1 $PINS Z=n_608 A=n_307 B=n_209 VSS=VSS VDD=VDD
Xg124941 NAND2X1 $PINS Z=n_607 A=n_269 B=n_190 VSS=VSS VDD=VDD
Xg124942 NAND2X1 $PINS Z=n_606 A=n_295 B=n_199 VSS=VSS VDD=VDD
Xg124943 NAND2X1 $PINS Z=n_605 A=n_300 B=n_145 VSS=VSS VDD=VDD
Xg124944 NAND2X1 $PINS Z=n_602 A=n_297 B=n_248 VSS=VSS VDD=VDD
Xg124945 NAND2X1 $PINS Z=n_601 A=n_269 B=n_191 VSS=VSS VDD=VDD
Xg124946 NAND2X1 $PINS Z=n_600 A=n_263 B=n_199 VSS=VSS VDD=VDD
Xg124947 NAND2X1 $PINS Z=n_599 A=n_256 B=n_212 VSS=VSS VDD=VDD
Xg124948 NOR2X1 $PINS Z=n_597 A=csm_inst_state[1] B=n_226 VSS=VSS VDD=VDD
Xg124949 NOR2X1 $PINS Z=n_594 A=csm_inst_round_counter[1] B=n_75 VSS=VSS
+ VDD=VDD
Xg124950 NOR2X1 $PINS Z=n_590 A=transaction_state[1] B=n_225 VSS=VSS VDD=VDD
Xg124951 INVX2 $PINS Z=n_501 A=n_503 VSS=VSS VDD=VDD
Xg124952 INVX2 $PINS Z=n_459 A=n_460 VSS=VSS VDD=VDD
Xg124953 INVX2 $PINS Z=n_442 A=n_445 VSS=VSS VDD=VDD
Xg124954 INVX2 $PINS Z=n_438 A=n_437 VSS=VSS VDD=VDD
Xg124955 INVX2 $PINS Z=n_435 A=n_436 VSS=VSS VDD=VDD
Xg124956 INVX2 $PINS Z=n_434 A=n_433 VSS=VSS VDD=VDD
Xg124958 INVX2 $PINS Z=n_428 A=n_429 VSS=VSS VDD=VDD
Xg124959 INVX2 $PINS Z=n_425 A=n_426 VSS=VSS VDD=VDD
Xg124962 INVX2 $PINS Z=n_415 A=n_416 VSS=VSS VDD=VDD
Xg124963 INVX2 $PINS Z=n_412 A=n_414 VSS=VSS VDD=VDD
Xg124968 INVX2 $PINS Z=n_24 A=n_21 VSS=VSS VDD=VDD
Xg124973 MUX2X1 $PINS Z=n_408 A=spi_inst_shreg_in[25] B=spi_inst_shreg_in[26]
+ S=cs_n VSS=VSS VDD=VDD
Xg124974 MUX2X1 $PINS Z=n_406 A=spi_inst_shreg_in[39] B=spi_inst_shreg_in[40]
+ S=cs_n VSS=VSS VDD=VDD
Xg124975 MUX2X1 $PINS Z=n_404 A=spi_inst_shreg_in[6] B=spi_inst_shreg_in[7]
+ S=cs_n VSS=VSS VDD=VDD
Xg124976 MUX2X1 $PINS Z=n_403 A=spi_inst_shreg_in[16] B=spi_inst_shreg_in[17]
+ S=cs_n VSS=VSS VDD=VDD
Xg124977 MUX2X1 $PINS Z=n_401 A=spi_inst_shreg_in[33] B=spi_inst_shreg_in[34]
+ S=cs_n VSS=VSS VDD=VDD
Xg124978 MUX2X1 $PINS Z=n_399 A=spi_inst_shreg_in[12] B=spi_inst_shreg_in[13]
+ S=cs_n VSS=VSS VDD=VDD
Xg124979 MUX2X1 $PINS Z=n_398 A=spi_inst_shreg_in[58] B=spi_inst_shreg_in[59]
+ S=cs_n VSS=VSS VDD=VDD
Xg124980 MUX2X1 $PINS Z=n_397 A=spi_inst_shreg_in[14] B=spi_inst_shreg_in[15]
+ S=cs_n VSS=VSS VDD=VDD
Xg124981 MUX2X1 $PINS Z=n_396 A=spi_inst_shreg_in[18] B=spi_inst_shreg_in[19]
+ S=cs_n VSS=VSS VDD=VDD
Xg124982 MUX2X1 $PINS Z=n_394 A=spi_inst_shreg_in[21] B=spi_inst_shreg_in[22]
+ S=cs_n VSS=VSS VDD=VDD
Xg124983 NOR2X1 $PINS Z=n_393 A=n_50 B=n_59 VSS=VSS VDD=VDD
Xg124984 MUX2X1 $PINS Z=n_392 A=spi_inst_shreg_in[28] B=spi_inst_shreg_in[29]
+ S=cs_n VSS=VSS VDD=VDD
Xg124985 MUX2X1 $PINS Z=n_391 A=spi_inst_shreg_in[0] B=spi_inst_shreg_in[1]
+ S=cs_n VSS=VSS VDD=VDD
Xg124987 MUX2X1 $PINS Z=n_389 A=spi_inst_shreg_in[27] B=spi_inst_shreg_in[28]
+ S=cs_n VSS=VSS VDD=VDD
Xg124988 MUX2X1 $PINS Z=n_388 A=spi_inst_shreg_in[1] B=spi_inst_shreg_in[2]
+ S=cs_n VSS=VSS VDD=VDD
Xg124989 NAND2X1 $PINS Z=n_387 A=n_90 B=key_reg[11] VSS=VSS VDD=VDD
Xg124990 MUX2X1 $PINS Z=n_386 A=spi_inst_shreg_in[50] B=spi_inst_shreg_in[51]
+ S=cs_n VSS=VSS VDD=VDD
Xg124991 MUX2X1 $PINS Z=n_385 A=spi_inst_shreg_in[55] B=spi_inst_shreg_in[56]
+ S=cs_n VSS=VSS VDD=VDD
Xg124992 MUX2X1 $PINS Z=n_384 A=spi_inst_shreg_in[19] B=spi_inst_shreg_in[20]
+ S=cs_n VSS=VSS VDD=VDD
Xg124993 MUX2X1 $PINS Z=n_383 A=spi_inst_shreg_in[22] B=spi_inst_shreg_in[23]
+ S=cs_n VSS=VSS VDD=VDD
Xg124994 MUX2X1 $PINS Z=n_381 A=spi_inst_shreg_in[26] B=spi_inst_shreg_in[27]
+ S=cs_n VSS=VSS VDD=VDD
Xg124995 MUX2X1 $PINS Z=n_379 A=spi_inst_shreg_in[47] B=spi_inst_shreg_in[48]
+ S=cs_n VSS=VSS VDD=VDD
Xg124996 MUX2X1 $PINS Z=n_378 A=spi_inst_shreg_in[41] B=spi_inst_shreg_in[42]
+ S=cs_n VSS=VSS VDD=VDD
Xg124997 NAND2X1 $PINS Z=n_377 A=n_90 B=key_reg[59] VSS=VSS VDD=VDD
Xg124998 MUX2X1 $PINS Z=n_375 A=spi_inst_shreg_in[32] B=spi_inst_shreg_in[33]
+ S=cs_n VSS=VSS VDD=VDD
Xg124999 MUX2X1 $PINS Z=n_374 A=spi_inst_shreg_in[13] B=spi_inst_shreg_in[14]
+ S=cs_n VSS=VSS VDD=VDD
Xg125000 MUX2X1 $PINS Z=n_372 A=spi_inst_shreg_in[42] B=spi_inst_shreg_in[43]
+ S=cs_n VSS=VSS VDD=VDD
Xg125001 MUX2X1 $PINS Z=n_371 A=spi_inst_shreg_in[29] B=spi_inst_shreg_in[30]
+ S=cs_n VSS=VSS VDD=VDD
Xg125002 MUX2X1 $PINS Z=n_370 A=spi_inst_shreg_in[51] B=spi_inst_shreg_in[52]
+ S=cs_n VSS=VSS VDD=VDD
Xg125003 OR2X1 $PINS Z=n_368 A=key_reg[5] B=n_90 VSS=VSS VDD=VDD
Xg125004 MUX2X1 $PINS Z=n_367 A=spi_inst_shreg_in[5] B=spi_inst_shreg_in[6]
+ S=cs_n VSS=VSS VDD=VDD
Xg125005 MUX2X1 $PINS Z=n_366 A=mosi B=spi_inst_shreg_in[0] S=cs_n VSS=VSS
+ VDD=VDD
Xg125006 MUX2X1 $PINS Z=n_365 A=spi_inst_shreg_in[48] B=spi_inst_shreg_in[49]
+ S=cs_n VSS=VSS VDD=VDD
Xg125007 OR2X1 $PINS Z=n_364 A=active B=n_225 VSS=VSS VDD=VDD
Xg125008 MUX2X1 $PINS Z=n_363 A=spi_inst_shreg_in[15] B=spi_inst_shreg_in[16]
+ S=cs_n VSS=VSS VDD=VDD
Xg125009 MUX2X1 $PINS Z=n_362 A=spi_inst_shreg_in[34] B=spi_inst_shreg_in[35]
+ S=cs_n VSS=VSS VDD=VDD
Xg125010 MUX2X1 $PINS Z=n_361 A=spi_inst_shreg_in[36] B=spi_inst_shreg_in[37]
+ S=cs_n VSS=VSS VDD=VDD
Xg125011 MUX2X1 $PINS Z=n_360 A=spi_inst_shreg_in[30] B=spi_inst_shreg_in[31]
+ S=cs_n VSS=VSS VDD=VDD
Xg125012 OR2X1 $PINS Z=n_359 A=csm_inst_round_counter[0] B=n_244 VSS=VSS
+ VDD=VDD
Xg125013 MUX2X1 $PINS Z=n_357 A=spi_inst_shreg_in[56] B=spi_inst_shreg_in[57]
+ S=cs_n VSS=VSS VDD=VDD
Xg125014 MUX2X1 $PINS Z=n_356 A=spi_inst_shreg_in[57] B=spi_inst_shreg_in[58]
+ S=cs_n VSS=VSS VDD=VDD
Xg125015 MUX2X1 $PINS Z=n_355 A=spi_inst_shreg_in[37] B=spi_inst_shreg_in[38]
+ S=cs_n VSS=VSS VDD=VDD
Xg125016 MUX2X1 $PINS Z=n_351 A=spi_inst_shreg_in[62] B=spi_inst_shreg_in[61]
+ S=n_30 VSS=VSS VDD=VDD
Xg125017 MUX2X1 $PINS Z=n_350 A=spi_inst_shreg_in[17] B=spi_inst_shreg_in[18]
+ S=cs_n VSS=VSS VDD=VDD
Xg125018 MUX2X1 $PINS Z=n_349 A=spi_inst_shreg_in[3] B=spi_inst_shreg_in[4]
+ S=cs_n VSS=VSS VDD=VDD
Xg125019 MUX2X1 $PINS Z=n_348 A=spi_inst_shreg_in[59] B=spi_inst_shreg_in[60]
+ S=cs_n VSS=VSS VDD=VDD
Xg125020 MUX2X1 $PINS Z=n_347 A=spi_inst_shreg_in[54] B=spi_inst_shreg_in[55]
+ S=cs_n VSS=VSS VDD=VDD
Xg125021 NAND2X1 $PINS Z=n_346 A=n_56 B=active VSS=VSS VDD=VDD
Xg125022 MUX2X1 $PINS Z=n_345 A=spi_inst_shreg_in[8] B=spi_inst_shreg_in[9]
+ S=cs_n VSS=VSS VDD=VDD
Xg125023 MUX2X1 $PINS Z=n_343 A=spi_inst_shreg_in[35] B=spi_inst_shreg_in[36]
+ S=cs_n VSS=VSS VDD=VDD
Xg125024 MUX2X1 $PINS Z=n_341 A=spi_inst_shreg_in[43] B=spi_inst_shreg_in[44]
+ S=cs_n VSS=VSS VDD=VDD
Xg125025 MUX2X1 $PINS Z=n_340 A=spi_inst_shreg_in[20] B=spi_inst_shreg_in[21]
+ S=cs_n VSS=VSS VDD=VDD
Xg125026 NAND2X1 $PINS Z=n_339 A=n_96 B=n_53 VSS=VSS VDD=VDD
Xg125027 MUX2X1 $PINS Z=n_338 A=spi_inst_shreg_in[38] B=spi_inst_shreg_in[39]
+ S=cs_n VSS=VSS VDD=VDD
Xg125028 NAND2X1 $PINS Z=n_540 A=n_244 B=n_209 VSS=VSS VDD=VDD
Xg125029 MUX2X1 $PINS Z=n_337 A=spi_inst_shreg_in[53] B=spi_inst_shreg_in[54]
+ S=cs_n VSS=VSS VDD=VDD
Xg125030 MUX2X1 $PINS Z=n_336 A=spi_inst_shreg_in[24] B=spi_inst_shreg_in[25]
+ S=cs_n VSS=VSS VDD=VDD
Xg125031 OR2X1 $PINS Z=n_335 A=key_reg[35] B=n_95 VSS=VSS VDD=VDD
Xg125032 MUX2X1 $PINS Z=n_334 A=spi_inst_shreg_in[4] B=spi_inst_shreg_in[5]
+ S=cs_n VSS=VSS VDD=VDD
Xg125033 MUX2X1 $PINS Z=n_333 A=spi_inst_shreg_in[52] B=spi_inst_shreg_in[53]
+ S=cs_n VSS=VSS VDD=VDD
Xg125034 MUX2X1 $PINS Z=n_332 A=spi_inst_shreg_in[9] B=spi_inst_shreg_in[10]
+ S=cs_n VSS=VSS VDD=VDD
Xg125035 MUX2X1 $PINS Z=n_331 A=spi_inst_shreg_in[2] B=spi_inst_shreg_in[3]
+ S=cs_n VSS=VSS VDD=VDD
Xg125036 MUX2X1 $PINS Z=n_330 A=spi_inst_shreg_in[40] B=spi_inst_shreg_in[41]
+ S=cs_n VSS=VSS VDD=VDD
Xg125037 MUX2X1 $PINS Z=n_329 A=spi_inst_shreg_in[10] B=spi_inst_shreg_in[11]
+ S=cs_n VSS=VSS VDD=VDD
Xg125038 MUX2X1 $PINS Z=n_328 A=spi_inst_shreg_in[46] B=spi_inst_shreg_in[47]
+ S=cs_n VSS=VSS VDD=VDD
Xg125039 MUX2X1 $PINS Z=n_327 A=spi_inst_shreg_in[31] B=spi_inst_shreg_in[32]
+ S=cs_n VSS=VSS VDD=VDD
Xg125040 MUX2X1 $PINS Z=n_326 A=spi_inst_shreg_in[44] B=spi_inst_shreg_in[45]
+ S=cs_n VSS=VSS VDD=VDD
Xg125041 MUX2X1 $PINS Z=n_324 A=spi_inst_shreg_in[45] B=spi_inst_shreg_in[46]
+ S=cs_n VSS=VSS VDD=VDD
Xg125042 MUX2X1 $PINS Z=n_323 A=spi_inst_shreg_in[49] B=spi_inst_shreg_in[50]
+ S=cs_n VSS=VSS VDD=VDD
Xg125043 NAND3X1 $PINS Z=n_322 A=transaction_state[1] B=active
+ C=cs_rise_delayed VSS=VSS VDD=VDD
Xg125044 MUX2X1 $PINS Z=n_321 A=spi_inst_shreg_in[60] B=spi_inst_shreg_in[61]
+ S=cs_n VSS=VSS VDD=VDD
Xg125045 MUX2X1 $PINS Z=n_320 A=spi_inst_shreg_in[23] B=spi_inst_shreg_in[24]
+ S=cs_n VSS=VSS VDD=VDD
Xg125046 MUX2X1 $PINS Z=n_319 A=spi_inst_shreg_in[11] B=spi_inst_shreg_in[12]
+ S=cs_n VSS=VSS VDD=VDD
Xg125047 NOR2X1 $PINS Z=n_318 A=n_234 B=n_99 VSS=VSS VDD=VDD
Xg125048 MUX2X1 $PINS Z=n_317 A=spi_inst_shreg_in[7] B=spi_inst_shreg_in[8]
+ S=cs_n VSS=VSS VDD=VDD
Xg125049 OR2X1 $PINS Z=n_539 A=n_14 B=n_198 VSS=VSS VDD=VDD
Xg125050 NAND2X1 $PINS Z=n_538 A=n_280 B=n_139 VSS=VSS VDD=VDD
Xg125051 NAND2X1 $PINS Z=n_534 A=n_254 B=n_143 VSS=VSS VDD=VDD
Xg125052 NAND2X1 $PINS Z=n_533 A=n_262 B=n_217 VSS=VSS VDD=VDD
Xg125053 NAND2X1 $PINS Z=n_532 A=n_307 B=n_198 VSS=VSS VDD=VDD
Xg125054 NAND2X1 $PINS Z=n_531 A=n_295 B=n_197 VSS=VSS VDD=VDD
Xg125055 NAND2X1 $PINS Z=n_530 A=n_191 B=n_313 VSS=VSS VDD=VDD
Xg125056 NAND2X1 $PINS Z=n_529 A=n_294 B=n_213 VSS=VSS VDD=VDD
Xg125057 NAND2X1 $PINS Z=n_528 A=n_267 B=n_216 VSS=VSS VDD=VDD
Xg125058 NAND2X1 $PINS Z=n_526 A=n_289 B=n_150 VSS=VSS VDD=VDD
Xg125059 NAND2X1 $PINS Z=n_525 A=n_302 B=n_148 VSS=VSS VDD=VDD
Xg125060 NAND2X1 $PINS Z=n_524 A=n_296 B=n_104 VSS=VSS VDD=VDD
Xg125061 NAND2X1 $PINS Z=n_523 A=n_304 B=n_214 VSS=VSS VDD=VDD
Xg125062 NAND2X1 $PINS Z=n_522 A=n_302 B=n_250 VSS=VSS VDD=VDD
Xg125063 MUX2X1 $PINS Z=n_521 A=key_reg[42] B=key_reg[1]
+ S=csm_inst_round_counter[3] VSS=VSS VDD=VDD
Xg125064 NAND2X1 $PINS Z=n_519 A=n_291 B=n_209 VSS=VSS VDD=VDD
Xg125065 NAND2X1 $PINS Z=n_518 A=n_272 B=n_202 VSS=VSS VDD=VDD
Xg125066 NAND2X1 $PINS Z=n_517 A=n_270 B=n_200 VSS=VSS VDD=VDD
Xg125067 NAND2X1 $PINS Z=n_515 A=n_300 B=n_219 VSS=VSS VDD=VDD
Xg125068 NAND2X1 $PINS Z=n_513 A=n_280 B=n_249 VSS=VSS VDD=VDD
Xg125069 NAND2X1 $PINS Z=n_511 A=n_277 B=n_265 VSS=VSS VDD=VDD
Xg125070 NAND2X1 $PINS Z=n_509 A=n_273 B=n_142 VSS=VSS VDD=VDD
Xg125071 NAND2X1 $PINS Z=n_506 A=n_299 B=n_177 VSS=VSS VDD=VDD
Xg125072 NAND2X1 $PINS Z=n_504 A=n_287 B=n_200 VSS=VSS VDD=VDD
Xg125073 NAND2X1 $PINS Z=n_503 A=n_245 B=n_190 VSS=VSS VDD=VDD
Xg125074 NAND2X1 $PINS Z=n_500 A=n_255 B=n_201 VSS=VSS VDD=VDD
Xg125075 NAND2X1 $PINS Z=n_499 A=n_266 B=n_178 VSS=VSS VDD=VDD
Xg125076 NAND2X1 $PINS Z=n_497 A=n_297 B=n_145 VSS=VSS VDD=VDD
Xg125077 NAND2X1 $PINS Z=n_496 A=n_256 B=n_246 VSS=VSS VDD=VDD
Xg125078 NAND2X1 $PINS Z=n_495 A=n_283 B=n_128 VSS=VSS VDD=VDD
Xg125079 MUX2X1 $PINS Z=n_492 A=key_reg[33] B=key_reg[11] S=n_15 VSS=VSS
+ VDD=VDD
Xg125080 NAND2X1 $PINS Z=n_490 A=n_283 B=n_104 VSS=VSS VDD=VDD
Xg125081 NAND2X1 $PINS Z=n_485 A=n_301 B=n_197 VSS=VSS VDD=VDD
Xg125082 NAND2X1 $PINS Z=n_483 A=n_272 B=n_200 VSS=VSS VDD=VDD
Xg125083 NAND2X1 $PINS Z=n_482 A=n_287 B=n_204 VSS=VSS VDD=VDD
Xg125084 NAND2X1 $PINS Z=n_481 A=n_268 B=n_147 VSS=VSS VDD=VDD
Xg125085 NAND2X1 $PINS Z=n_479 A=n_286 B=n_219 VSS=VSS VDD=VDD
Xg125086 NAND2X1 $PINS Z=n_476 A=n_261 B=n_114 VSS=VSS VDD=VDD
Xg125087 NAND2X1 $PINS Z=n_475 A=n_290 B=n_201 VSS=VSS VDD=VDD
Xg125088 NAND2X1 $PINS Z=n_474 A=n_261 B=n_218 VSS=VSS VDD=VDD
Xg125089 NAND2X1 $PINS Z=n_472 A=n_276 B=n_214 VSS=VSS VDD=VDD
Xg125090 NAND2X1 $PINS Z=n_471 A=n_263 B=n_197 VSS=VSS VDD=VDD
Xg125091 NAND2X1 $PINS Z=n_470 A=n_264 B=n_202 VSS=VSS VDD=VDD
Xg125092 NAND2X1 $PINS Z=n_469 A=n_291 B=n_141 VSS=VSS VDD=VDD
Xg125093 NAND2X1 $PINS Z=n_468 A=n_299 B=n_147 VSS=VSS VDD=VDD
Xg125094 NAND2X1 $PINS Z=n_467 A=n_262 B=n_114 VSS=VSS VDD=VDD
Xg125095 NAND2X1 $PINS Z=n_466 A=n_309 B=n_218 VSS=VSS VDD=VDD
Xg125096 NAND2X1 $PINS Z=n_465 A=n_310 B=n_251 VSS=VSS VDD=VDD
Xg125097 NAND2X1 $PINS Z=n_464 A=n_293 B=n_211 VSS=VSS VDD=VDD
Xg125098 AND2X1 $PINS Z=n_463 A=n_194 B=n_315 VSS=VSS VDD=VDD
Xg125099 NAND2X1 $PINS Z=n_462 A=n_264 B=n_137 VSS=VSS VDD=VDD
Xg125100 NAND2X1 $PINS Z=n_461 A=n_281 B=n_126 VSS=VSS VDD=VDD
Xg125101 NAND2X1 $PINS Z=n_460 A=n_307 B=n_246 VSS=VSS VDD=VDD
Xg125102 NAND2X1 $PINS Z=n_458 A=n_293 B=n_204 VSS=VSS VDD=VDD
Xg125103 NOR2X1 $PINS Z=n_457 A=csm_inst_mode B=n_78 VSS=VSS VDD=VDD
Xg125104 NOR2X1 $PINS Z=n_456 A=n_46 B=n_87 VSS=VSS VDD=VDD
Xg125105 NAND2X1 $PINS Z=n_455 A=n_290 B=n_169 VSS=VSS VDD=VDD
Xg125106 NAND2X1 $PINS Z=n_453 A=n_309 B=n_208 VSS=VSS VDD=VDD
Xg125107 NAND2X1 $PINS Z=n_452 A=n_270 B=n_137 VSS=VSS VDD=VDD
Xg125108 NAND2X1 $PINS Z=n_451 A=n_281 B=n_128 VSS=VSS VDD=VDD
Xg125109 AND2X1 $PINS Z=n_450 A=n_282 B=n_215 VSS=VSS VDD=VDD
Xg125110 NAND2X1 $PINS Z=n_449 A=n_291 B=n_246 VSS=VSS VDD=VDD
Xg125111 NOR2X1 $PINS Z=n_445 A=n_67 B=n_70 VSS=VSS VDD=VDD
Xg125112 AND2X1 $PINS Z=n_440 A=n_243 B=n_46 VSS=VSS VDD=VDD
Xg125113 NOR2X1 $PINS Z=n_439 A=csm_inst_round_counter[0] B=n_78 VSS=VSS
+ VDD=VDD
Xg125114 NAND2X1 $PINS Z=n_437 A=n_69 B=n_89 VSS=VSS VDD=VDD
Xg125115 NOR2X1 $PINS Z=n_436 A=n_14 B=n_78 VSS=VSS VDD=VDD
Xg125116 NAND2X1 $PINS Z=n_433 A=n_67 B=n_89 VSS=VSS VDD=VDD
Xg125117 AND2X1 $PINS Z=n_431 A=n_70 B=n_243 VSS=VSS VDD=VDD
Xg125118 AND2X1 $PINS Z=n_430 A=n_74 B=n_243 VSS=VSS VDD=VDD
Xg125119 NAND2X1 $PINS Z=n_429 A=n_83 B=csm_inst_round_counter[0] VSS=VSS
+ VDD=VDD
Xg125120 NOR2X1 $PINS Z=n_427 A=n_241 B=n_66 VSS=VSS VDD=VDD
Xg125121 NAND2X1 $PINS Z=n_426 A=n_74 B=n_85 VSS=VSS VDD=VDD
Xg125122 NOR2X1 $PINS Z=n_423 A=n_86 B=n_71 VSS=VSS VDD=VDD
Xg125123 NOR2X1 $PINS Z=n_420 A=n_19 B=n_239 VSS=VSS VDD=VDD
Xg125124 NOR2X1 $PINS Z=n_419 A=csm_inst_mode B=n_239 VSS=VSS VDD=VDD
Xg125125 NAND2X1 $PINS Z=n_416 A=n_69 B=n_240 VSS=VSS VDD=VDD
Xg125126 NAND2X1 $PINS Z=n_414 A=n_243 B=csm_inst_round_counter[2] VSS=VSS
+ VDD=VDD
Xg125127 NOR2X1 $PINS Z=n_411 A=csm_inst_mode B=n_236 VSS=VSS VDD=VDD
Xg125128 NAND3X1 $PINS Z=n_21 A=n_34 B=n_37 C=csm_inst_state[0] VSS=VSS VDD=VDD
Xg125129 OR2X1 $PINS Z=n_410 A=n_34 B=n_226 VSS=VSS VDD=VDD
Xg125130 NOR2X1 $PINS Z=n_409 A=csm_inst_state[2] B=n_222 VSS=VSS VDD=VDD
Xg125131 INVX2 $PINS Z=n_240 A=n_241 VSS=VSS VDD=VDD
Xg125132 INVX2 $PINS Z=n_238 A=n_239 VSS=VSS VDD=VDD
Xg125133 INVX2 $PINS Z=n_236 A=n_237 VSS=VSS VDD=VDD
Xg125134 NAND2X1 $PINS Z=n_235 A=n_40 B=crypt VSS=VSS VDD=VDD
Xg125135 NOR2X1 $PINS Z=n_234 A=spi_inst_bit_cnt[1] B=spi_inst_bit_cnt[0]
+ VSS=VSS VDD=VDD
Xg125136 NAND2X1 $PINS Z=n_233 A=n_39 B=transaction_state[0] VSS=VSS VDD=VDD
Xg125137 NOR2X1 $PINS Z=n_232 A=cs_n B=spi_inst_bit_cnt[0] VSS=VSS VDD=VDD
Xg125138 NAND2X1 $PINS Z=n_231 A=n_14 B=csm_inst_state[1] VSS=VSS VDD=VDD
Xg125139 NAND2X1 $PINS Z=n_230 A=n_14 B=key_reg[31] VSS=VSS VDD=VDD
Xg125140 NAND2X1 $PINS Z=n_229 A=n_14 B=key_reg[25] VSS=VSS VDD=VDD
Xg125141 NAND2X1 $PINS Z=n_228 A=n_14 B=key_reg[36] VSS=VSS VDD=VDD
Xg125142 NAND2X1 $PINS Z=n_315 A=n_15 B=key_reg[42] VSS=VSS VDD=VDD
Xg125143 NAND2X1 $PINS Z=n_313 A=n_15 B=key_reg[11] VSS=VSS VDD=VDD
Xg125144 NAND2X1 $PINS Z=n_311 A=n_15 B=key_reg[52] VSS=VSS VDD=VDD
Xg125145 NAND2X1 $PINS Z=n_310 A=n_15 B=key_reg[14] VSS=VSS VDD=VDD
Xg125146 NAND2X1 $PINS Z=n_309 A=n_15 B=key_reg[17] VSS=VSS VDD=VDD
Xg125147 NAND2X1 $PINS Z=n_307 A=n_15 B=key_reg[27] VSS=VSS VDD=VDD
Xg125148 NAND2X1 $PINS Z=n_306 A=n_15 B=key_reg[28] VSS=VSS VDD=VDD
Xg125149 NAND2X1 $PINS Z=n_305 A=n_15 B=key_reg[58] VSS=VSS VDD=VDD
Xg125150 NAND2X1 $PINS Z=n_304 A=n_15 B=key_reg[18] VSS=VSS VDD=VDD
Xg125151 NAND2X1 $PINS Z=n_303 A=n_15 B=key_reg[9] VSS=VSS VDD=VDD
Xg125152 NAND2X1 $PINS Z=n_302 A=n_15 B=key_reg[10] VSS=VSS VDD=VDD
Xg125153 NAND2X1 $PINS Z=n_301 A=n_15 B=key_reg[22] VSS=VSS VDD=VDD
Xg125154 NAND2X1 $PINS Z=n_300 A=n_15 B=key_reg[21] VSS=VSS VDD=VDD
Xg125155 NAND2X1 $PINS Z=n_299 A=n_15 B=key_reg[46] VSS=VSS VDD=VDD
Xg125156 NAND2X1 $PINS Z=n_298 A=n_15 B=key_reg[12] VSS=VSS VDD=VDD
Xg125157 NAND2X1 $PINS Z=n_297 A=n_15 B=key_reg[13] VSS=VSS VDD=VDD
Xg125158 NAND2X1 $PINS Z=n_296 A=n_15 B=key_reg[59] VSS=VSS VDD=VDD
Xg125159 NAND2X1 $PINS Z=n_295 A=n_15 B=key_reg[38] VSS=VSS VDD=VDD
Xg125160 NAND2X1 $PINS Z=n_294 A=n_15 B=key_reg[57] VSS=VSS VDD=VDD
Xg125161 NAND2X1 $PINS Z=n_293 A=n_15 B=key_reg[47] VSS=VSS VDD=VDD
Xg125162 NAND2X1 $PINS Z=n_292 A=n_15 B=key_reg[2] VSS=VSS VDD=VDD
Xg125163 NAND2X1 $PINS Z=n_291 A=n_15 B=key_reg[35] VSS=VSS VDD=VDD
Xg125164 NAND2X1 $PINS Z=n_290 A=n_15 B=key_reg[45] VSS=VSS VDD=VDD
Xg125165 NAND2X1 $PINS Z=n_289 A=n_15 B=key_reg[1] VSS=VSS VDD=VDD
Xg125166 NAND2X1 $PINS Z=n_287 A=n_15 B=key_reg[39] VSS=VSS VDD=VDD
Xg125167 NAND2X1 $PINS Z=n_286 A=n_15 B=key_reg[29] VSS=VSS VDD=VDD
Xg125168 NAND2X1 $PINS Z=n_283 A=n_15 B=key_reg[44] VSS=VSS VDD=VDD
Xg125169 NAND2X1 $PINS Z=n_282 A=n_15 B=key_reg[7] VSS=VSS VDD=VDD
Xg125170 NAND2X1 $PINS Z=n_281 A=n_15 B=key_reg[60] VSS=VSS VDD=VDD
Xg125171 NAND2X1 $PINS Z=n_280 A=n_15 B=key_reg[6] VSS=VSS VDD=VDD
Xg125172 NAND2X1 $PINS Z=n_279 A=n_15 B=key_reg[4] VSS=VSS VDD=VDD
Xg125173 NAND2X1 $PINS Z=n_278 A=n_15 B=key_reg[25] VSS=VSS VDD=VDD
Xg125174 NAND2X1 $PINS Z=n_277 A=n_15 B=key_reg[34] VSS=VSS VDD=VDD
Xg125175 NAND2X1 $PINS Z=n_276 A=n_15 B=key_reg[26] VSS=VSS VDD=VDD
Xg125176 NAND2X1 $PINS Z=n_275 A=n_15 B=key_reg[53] VSS=VSS VDD=VDD
Xg125177 NAND2X1 $PINS Z=n_274 A=n_15 B=key_reg[55] VSS=VSS VDD=VDD
Xg125178 NAND2X1 $PINS Z=n_273 A=n_15 B=key_reg[20] VSS=VSS VDD=VDD
Xg125179 NAND2X1 $PINS Z=n_272 A=n_15 B=key_reg[31] VSS=VSS VDD=VDD
Xg125180 NAND2X1 $PINS Z=n_270 A=n_15 B=key_reg[23] VSS=VSS VDD=VDD
Xg125181 NAND2X1 $PINS Z=n_269 A=n_15 B=key_reg[3] VSS=VSS VDD=VDD
Xg125182 NAND2X1 $PINS Z=n_268 A=n_15 B=key_reg[54] VSS=VSS VDD=VDD
Xg125183 NAND2X1 $PINS Z=n_267 A=n_15 B=key_reg[63] VSS=VSS VDD=VDD
Xg125184 NAND2X1 $PINS Z=n_266 A=n_15 B=key_reg[61] VSS=VSS VDD=VDD
Xg125185 NAND2X1 $PINS Z=n_265 A=csm_inst_round_counter[3] B=key_reg[52]
+ VSS=VSS VDD=VDD
Xg125186 NAND2X1 $PINS Z=n_264 A=n_15 B=key_reg[15] VSS=VSS VDD=VDD
Xg125187 NAND2X1 $PINS Z=n_263 A=n_15 B=key_reg[30] VSS=VSS VDD=VDD
Xg125188 NAND2X1 $PINS Z=n_262 A=n_15 B=key_reg[41] VSS=VSS VDD=VDD
Xg125189 NAND2X1 $PINS Z=n_261 A=n_15 B=key_reg[33] VSS=VSS VDD=VDD
Xg125190 NAND2X1 $PINS Z=n_258 A=n_15 B=key_reg[49] VSS=VSS VDD=VDD
Xg125191 NAND2X1 $PINS Z=n_257 A=n_15 B=key_reg[62] VSS=VSS VDD=VDD
Xg125192 NAND2X1 $PINS Z=n_256 A=n_15 B=key_reg[19] VSS=VSS VDD=VDD
Xg125193 NAND2X1 $PINS Z=n_255 A=n_15 B=key_reg[37] VSS=VSS VDD=VDD
Xg125194 NAND2X1 $PINS Z=n_254 A=n_15 B=key_reg[5] VSS=VSS VDD=VDD
Xg125195 NAND2X1 $PINS Z=n_253 A=n_15 B=key_reg[36] VSS=VSS VDD=VDD
Xg125196 NAND2X1 $PINS Z=n_252 A=n_15 B=key_reg[51] VSS=VSS VDD=VDD
Xg125197 NAND2X1 $PINS Z=n_251 A=csm_inst_round_counter[3] B=key_reg[4] VSS=VSS
+ VDD=VDD
Xg125198 NAND2X1 $PINS Z=n_250 A=csm_inst_round_counter[3] B=key_reg[59]
+ VSS=VSS VDD=VDD
Xg125199 NAND2X1 $PINS Z=n_249 A=csm_inst_round_counter[3] B=key_reg[61]
+ VSS=VSS VDD=VDD
Xg125200 NAND2X1 $PINS Z=n_248 A=csm_inst_round_counter[3] B=key_reg[23]
+ VSS=VSS VDD=VDD
Xg125201 NAND2X1 $PINS Z=n_247 A=csm_inst_round_counter[3] B=key_reg[46]
+ VSS=VSS VDD=VDD
Xg125202 NAND2X1 $PINS Z=n_246 A=csm_inst_round_counter[3] B=key_reg[41]
+ VSS=VSS VDD=VDD
Xg125203 NAND2X1 $PINS Z=n_245 A=n_15 B=key_reg[50] VSS=VSS VDD=VDD
Xg125204 NAND2X1 $PINS Z=n_244 A=n_15 B=key_reg[43] VSS=VSS VDD=VDD
Xg125205 NOR2X1 $PINS Z=n_243 A=csm_inst_round_counter[1] B=n_19 VSS=VSS
+ VDD=VDD
Xg125206 NAND2X1 $PINS Z=n_241 A=n_19 B=csm_inst_round_counter[1] VSS=VSS
+ VDD=VDD
Xg125207 NAND2X1 $PINS Z=n_239 A=n_46 B=csm_inst_round_counter[1] VSS=VSS
+ VDD=VDD
Xg125208 NOR2X1 $PINS Z=n_237 A=csm_inst_round_counter[1] B=n_46 VSS=VSS
+ VDD=VDD
Xg125209 INVX2 $PINS Z=n_224 A=n_222 VSS=VSS VDD=VDD
Xg125210 INVX2 $PINS Z=n_99 A=n_98 VSS=VSS VDD=VDD
Xg125211 INVX2 $PINS Z=n_96 A=n_97 VSS=VSS VDD=VDD
Xg125212 INVX2 $PINS Z=n_91 A=n_93 VSS=VSS VDD=VDD
Xg125213 INVX2 $PINS Z=n_87 A=n_89 VSS=VSS VDD=VDD
Xg125214 INVX2 $PINS Z=n_85 A=n_86 VSS=VSS VDD=VDD
Xg125215 INVX2 $PINS Z=n_82 A=n_83 VSS=VSS VDD=VDD
Xg125216 INVX2 $PINS Z=n_78 A=n_80 VSS=VSS VDD=VDD
Xg125217 INVX2 $PINS Z=n_74 A=n_75 VSS=VSS VDD=VDD
Xg125218 INVX2 $PINS Z=n_70 A=n_71 VSS=VSS VDD=VDD
Xg125219 INVX2 $PINS Z=n_68 A=n_69 VSS=VSS VDD=VDD
Xg125220 INVX2 $PINS Z=n_66 A=n_67 VSS=VSS VDD=VDD
Xg125221 NAND2X1 $PINS Z=n_58 A=csm_inst_round_counter[0] B=key_reg[9] VSS=VSS
+ VDD=VDD
Xg125222 NOR2X1 $PINS Z=n_56 A=done_encrypt B=done_decrypt VSS=VSS VDD=VDD
Xg125223 OR2X1 $PINS Z=n_55 A=start_decrypt B=crypt VSS=VSS VDD=VDD
Xg125224 NAND2X1 $PINS Z=n_53 A=csm_inst_round_counter[0] B=key_reg[10] VSS=VSS
+ VDD=VDD
Xg125225 NAND2X1 $PINS Z=n_51 A=csm_inst_round_counter[0] B=key_reg[39] VSS=VSS
+ VDD=VDD
Xg125226 NOR2X1 $PINS Z=n_50 A=done_decrypt_latched B=done_decrypt VSS=VSS
+ VDD=VDD
Xg125227 NOR2X1 $PINS Z=n_48 A=done_encrypt_latched B=done_encrypt VSS=VSS
+ VDD=VDD
Xg125228 NAND2X1 $PINS Z=n_227 A=csm_inst_round_counter[3] B=key_reg[1] VSS=VSS
+ VDD=VDD
Xg125229 NAND2X1 $PINS Z=n_226 A=n_37 B=n_38 VSS=VSS VDD=VDD
Xg125230 NAND2X1 $PINS Z=n_225 A=transaction_state[0] B=cs_rise_delayed VSS=VSS
+ VDD=VDD
Xg125231 NAND2X1 $PINS Z=n_222 A=csm_inst_state[1] B=csm_inst_state[0] VSS=VSS
+ VDD=VDD
Xg125232 NAND2X1 $PINS Z=n_221 A=csm_inst_round_counter[3] B=key_reg[14]
+ VSS=VSS VDD=VDD
Xg125233 NAND2X1 $PINS Z=n_220 A=csm_inst_round_counter[3] B=key_reg[10]
+ VSS=VSS VDD=VDD
Xg125234 NAND2X1 $PINS Z=n_219 A=csm_inst_round_counter[3] B=key_reg[39]
+ VSS=VSS VDD=VDD
Xg125235 NAND2X1 $PINS Z=n_218 A=csm_inst_round_counter[3] B=key_reg[11]
+ VSS=VSS VDD=VDD
Xg125236 NAND2X1 $PINS Z=n_217 A=csm_inst_round_counter[3] B=key_reg[19]
+ VSS=VSS VDD=VDD
Xg125237 NAND2X1 $PINS Z=n_216 A=csm_inst_round_counter[3] B=key_reg[37]
+ VSS=VSS VDD=VDD
Xg125238 NAND2X1 $PINS Z=n_215 A=csm_inst_round_counter[3] B=key_reg[54]
+ VSS=VSS VDD=VDD
Xg125239 NAND2X1 $PINS Z=n_214 A=csm_inst_round_counter[3] B=key_reg[44]
+ VSS=VSS VDD=VDD
Xg125240 NAND2X1 $PINS Z=n_213 A=csm_inst_round_counter[3] B=key_reg[43]
+ VSS=VSS VDD=VDD
Xg125241 NAND2X1 $PINS Z=n_212 A=csm_inst_round_counter[3] B=key_reg[25]
+ VSS=VSS VDD=VDD
Xg125242 NAND2X1 $PINS Z=n_211 A=csm_inst_round_counter[3] B=key_reg[29]
+ VSS=VSS VDD=VDD
Xg125243 NAND2X1 $PINS Z=n_210 A=csm_inst_round_counter[3] B=key_reg[38]
+ VSS=VSS VDD=VDD
Xg125244 NAND2X1 $PINS Z=n_209 A=csm_inst_round_counter[3] B=key_reg[49]
+ VSS=VSS VDD=VDD
Xg125245 NAND2X1 $PINS Z=n_208 A=csm_inst_round_counter[3] B=key_reg[3] VSS=VSS
+ VDD=VDD
Xg125246 NAND2X1 $PINS Z=n_205 A=csm_inst_round_counter[3] B=key_reg[58]
+ VSS=VSS VDD=VDD
Xg125247 NAND2X1 $PINS Z=n_204 A=csm_inst_round_counter[3] B=key_reg[21]
+ VSS=VSS VDD=VDD
Xg125248 NAND2X1 $PINS Z=n_203 A=csm_inst_round_counter[3] B=key_reg[47]
+ VSS=VSS VDD=VDD
Xg125249 NAND2X1 $PINS Z=n_202 A=csm_inst_round_counter[3] B=key_reg[5] VSS=VSS
+ VDD=VDD
Xg125250 NAND2X1 $PINS Z=n_201 A=csm_inst_round_counter[3] B=key_reg[63]
+ VSS=VSS VDD=VDD
Xg125251 NAND2X1 $PINS Z=n_200 A=csm_inst_round_counter[3] B=key_reg[13]
+ VSS=VSS VDD=VDD
Xg125252 NAND2X1 $PINS Z=n_199 A=csm_inst_round_counter[3] B=key_reg[20]
+ VSS=VSS VDD=VDD
Xg125253 NAND2X1 $PINS Z=n_198 A=csm_inst_round_counter[3] B=key_reg[33]
+ VSS=VSS VDD=VDD
Xg125254 NAND2X1 $PINS Z=n_197 A=csm_inst_round_counter[3] B=key_reg[12]
+ VSS=VSS VDD=VDD
Xg125255 NAND2X1 $PINS Z=n_194 A=csm_inst_round_counter[3] B=key_reg[60]
+ VSS=VSS VDD=VDD
Xg125256 NAND2X1 $PINS Z=n_191 A=csm_inst_round_counter[3] B=key_reg[17]
+ VSS=VSS VDD=VDD
Xg125257 NAND2X1 $PINS Z=n_190 A=csm_inst_round_counter[3] B=key_reg[9] VSS=VSS
+ VDD=VDD
Xg125258 NAND2X1 $PINS Z=n_178 A=csm_inst_round_counter[3] B=key_reg[22]
+ VSS=VSS VDD=VDD
Xg125259 NAND2X1 $PINS Z=n_177 A=csm_inst_round_counter[3] B=key_reg[7] VSS=VSS
+ VDD=VDD
Xg125260 NAND2X1 $PINS Z=n_169 A=csm_inst_round_counter[3] B=key_reg[6] VSS=VSS
+ VDD=VDD
Xg125261 NOR2X1 $PINS Z=n_168 A=start_encrypt B=start_decrypt VSS=VSS VDD=VDD
Xg125262 NAND2X1 $PINS Z=n_165 A=csm_inst_round_counter[3] B=key_reg[26]
+ VSS=VSS VDD=VDD
Xg125263 NAND2X1 $PINS Z=n_151 A=csm_inst_round_counter[3] B=key_reg[35]
+ VSS=VSS VDD=VDD
Xg125264 NAND2X1 $PINS Z=n_150 A=csm_inst_round_counter[3] B=key_reg[50]
+ VSS=VSS VDD=VDD
Xg125265 NAND2X1 $PINS Z=n_149 A=csm_inst_round_counter[3] B=key_reg[55]
+ VSS=VSS VDD=VDD
Xg125266 NAND2X1 $PINS Z=n_148 A=csm_inst_round_counter[3] B=key_reg[36]
+ VSS=VSS VDD=VDD
Xg125267 NAND2X1 $PINS Z=n_147 A=csm_inst_round_counter[3] B=key_reg[28]
+ VSS=VSS VDD=VDD
Xg125268 NAND2X1 $PINS Z=n_146 A=csm_inst_round_counter[3] B=key_reg[45]
+ VSS=VSS VDD=VDD
Xg125269 NAND2X1 $PINS Z=n_145 A=csm_inst_round_counter[3] B=key_reg[31]
+ VSS=VSS VDD=VDD
Xg125270 NAND2X1 $PINS Z=n_143 A=csm_inst_round_counter[3] B=key_reg[15]
+ VSS=VSS VDD=VDD
Xg125271 NAND2X1 $PINS Z=n_142 A=csm_inst_round_counter[3] B=key_reg[30]
+ VSS=VSS VDD=VDD
Xg125272 NAND2X1 $PINS Z=n_141 A=csm_inst_round_counter[3] B=key_reg[57]
+ VSS=VSS VDD=VDD
Xg125273 NAND2X1 $PINS Z=n_139 A=csm_inst_round_counter[3] B=key_reg[53]
+ VSS=VSS VDD=VDD
Xg125274 NAND2X1 $PINS Z=n_137 A=csm_inst_round_counter[3] B=key_reg[62]
+ VSS=VSS VDD=VDD
Xg125275 NOR2X1 $PINS Z=n_134 A=n_47 B=n_14 VSS=VSS VDD=VDD
Xg125276 NAND2X1 $PINS Z=n_129 A=csm_inst_round_counter[3] B=key_reg[2] VSS=VSS
+ VDD=VDD
Xg125277 NAND2X1 $PINS Z=n_128 A=csm_inst_round_counter[3] B=key_reg[34]
+ VSS=VSS VDD=VDD
Xg125278 NAND2X1 $PINS Z=n_127 A=csm_inst_round_counter[3] B=key_reg[51]
+ VSS=VSS VDD=VDD
Xg125279 NAND2X1 $PINS Z=n_126 A=csm_inst_round_counter[3] B=key_reg[42]
+ VSS=VSS VDD=VDD
Xg125280 NAND2X1 $PINS Z=n_114 A=csm_inst_round_counter[3] B=key_reg[27]
+ VSS=VSS VDD=VDD
Xg125281 NAND2X1 $PINS Z=n_104 A=csm_inst_round_counter[3] B=key_reg[18]
+ VSS=VSS VDD=VDD
Xg125282 NAND2X1 $PINS Z=n_98 A=spi_inst_bit_cnt[0] B=spi_inst_bit_cnt[1]
+ VSS=VSS VDD=VDD
Xg125283 NOR2X1 $PINS Z=n_97 A=n_15 B=n_14 VSS=VSS VDD=VDD
Xg125284 NOR2X1 $PINS Z=n_95 A=csm_inst_round_counter[3] B=n_14 VSS=VSS VDD=VDD
Xg125285 NOR2X1 $PINS Z=n_93 A=n_15 B=csm_inst_round_counter[0] VSS=VSS VDD=VDD
Xg125286 NOR2X1 $PINS Z=n_90 A=csm_inst_round_counter[3]
+ B=csm_inst_round_counter[0] VSS=VSS VDD=VDD
Xg125287 NOR2X1 $PINS Z=n_89 A=n_47 B=n_19 VSS=VSS VDD=VDD
Xg125288 NAND2X1 $PINS Z=n_86 A=n_19 B=n_47 VSS=VSS VDD=VDD
Xg125289 NOR2X1 $PINS Z=n_83 A=csm_inst_round_counter[1]
+ B=csm_inst_round_counter[2] VSS=VSS VDD=VDD
Xg125290 NOR2X1 $PINS Z=n_80 A=n_47 B=n_46 VSS=VSS VDD=VDD
Xg125291 NAND2X1 $PINS Z=n_75 A=n_14 B=n_46 VSS=VSS VDD=VDD
Xg125292 NAND2X1 $PINS Z=n_71 A=csm_inst_round_counter[0] B=n_46 VSS=VSS
+ VDD=VDD
Xg125293 NOR2X1 $PINS Z=n_69 A=n_46 B=n_14 VSS=VSS VDD=VDD
Xg125294 NOR2X1 $PINS Z=n_67 A=n_46 B=csm_inst_round_counter[0] VSS=VSS VDD=VDD
Xg125295 NOR2X1 $PINS Z=n_59 A=transaction_state[1] B=n_6054 VSS=VSS VDD=VDD
Xg125296 INVX2 $PINS Z=n_47 A=csm_inst_round_counter[1] VSS=VSS VDD=VDD
Xg125297 INVX2 $PINS Z=n_46 A=csm_inst_round_counter[2] VSS=VSS VDD=VDD
Xg125312 INVX4 $PINS Z=n_14 A=csm_inst_round_counter[0] VSS=VSS VDD=VDD
Xg125313 INVX2 $PINS Z=n_40 A=start_encrypt VSS=VSS VDD=VDD
Xg125314 INVX2 $PINS Z=n_39 A=cs_rise_delayed VSS=VSS VDD=VDD
Xg125315 INVX2 $PINS Z=n_38 A=csm_inst_state[0] VSS=VSS VDD=VDD
Xg125316 INVX2 $PINS Z=n_37 A=csm_inst_state[2] VSS=VSS VDD=VDD
Xg125317 INVX2 $PINS Z=n_35 A=csm_inst_left_reg[18] VSS=VSS VDD=VDD
Xg125318 INVX2 $PINS Z=n_34 A=csm_inst_state[1] VSS=VSS VDD=VDD
Xg125319 INVX2 $PINS Z=n_30 A=cs_n VSS=VSS VDD=VDD
Xdrc_bufs125333 INVX2 $PINS Z=n_15 A=csm_inst_round_counter[3] VSS=VSS VDD=VDD
Xdrc_bufs125346 INVX2 $PINS Z=n_26 A=n_590 VSS=VSS VDD=VDD
Xdrc_bufs125398 INVX2 $PINS Z=n_27 A=n_1282 VSS=VSS VDD=VDD
Xdrc_bufs125405 INVX4 $PINS Z=n_20 A=n_410 VSS=VSS VDD=VDD
Xdrc_bufs125412 INVX2 $PINS Z=n_19 A=csm_inst_mode VSS=VSS VDD=VDD
Xg2 AND2X1 $PINS Z=n_0 A=n_657 B=n_430 VSS=VSS VDD=VDD
Xg125413 MUX2X1 $PINS Z=n_6062 A=crypt B=spi_rx_data[0] S=n_5968 VSS=VSS
+ VDD=VDD
Xg125414 NAND3X1 $PINS Z=n_6063 A=n_739 B=n_14 C=n_80 VSS=VSS VDD=VDD
Xg125415 NAND3X1 $PINS Z=n_6064 A=n_743 B=n_14 C=csm_inst_round_counter[1]
+ VSS=VSS VDD=VDD
Xg125416 NAND3X1 $PINS Z=n_6065 A=n_731 B=csm_inst_round_counter[0] C=n_83
+ VSS=VSS VDD=VDD
Xg125417 NAND3X1 $PINS Z=n_6066 A=n_726 B=csm_inst_round_counter[0] C=n_83
+ VSS=VSS VDD=VDD
Xg125418 OR2X1 $PINS Z=n_6068 A=n_6067 B=n_5664 VSS=VSS VDD=VDD
Xg3 NAND3X1 $PINS Z=n_6067 A=n_5628 B=n_5203 C=n_4862 VSS=VSS VDD=VDD
Xg125419 OR2X1 $PINS Z=n_6070 A=n_6069 B=n_5154 VSS=VSS VDD=VDD
Xg125420 NAND3X1 $PINS Z=n_6069 A=n_5401 B=n_4978 C=n_5224 VSS=VSS VDD=VDD
Xg125421 AND2X1 $PINS Z=n_6072 A=n_6071 B=n_4326 VSS=VSS VDD=VDD
Xg125422 OR2X1 $PINS Z=n_6071 A=n_5134 B=n_4770 VSS=VSS VDD=VDD
Xg125423 OR2X1 $PINS Z=n_6074 A=n_6073 B=n_4559 VSS=VSS VDD=VDD
Xg125424 NOR2X1 $PINS Z=n_6073 A=n_4079 B=n_4262 VSS=VSS VDD=VDD
Xg125425 NOR2X1 $PINS Z=n_6076 A=n_6075 B=n_3787 VSS=VSS VDD=VDD
Xg125426 NAND3X1 $PINS Z=n_6075 A=n_3659 B=n_1115 C=n_3393 VSS=VSS VDD=VDD
Xg125427 OR2X1 $PINS Z=n_6078 A=n_6077 B=n_419 VSS=VSS VDD=VDD
Xg125428 AND2X1 $PINS Z=n_6077 A=n_3557 B=n_85 VSS=VSS VDD=VDD
Xg125429 AND2X1 $PINS Z=n_6081 A=n_6079 B=n_6080 VSS=VSS VDD=VDD
Xg125430 NAND3X1 $PINS Z=n_6079 A=n_440 B=n_732 C=csm_inst_round_counter[0]
+ VSS=VSS VDD=VDD
Xg4 NAND2X1 $PINS Z=n_6080 A=n_427 B=n_485 VSS=VSS VDD=VDD
Xg125431 OR2X1 $PINS Z=n_6083 A=n_6082 B=n_1850 VSS=VSS VDD=VDD
Xg125432 AND2X1 $PINS Z=n_6082 A=n_435 B=n_1106 VSS=VSS VDD=VDD
Xg125433 OR2X1 $PINS Z=n_6085 A=n_6084 B=n_423 VSS=VSS VDD=VDD
Xg125434 AND2X1 $PINS Z=n_6084 A=n_519 B=n_85 VSS=VSS VDD=VDD
.ENDS

.SUBCKT top_pad clk rst sclk cs_n mosi miso
Xcorner0 pad_corner $PINS VSS=VSS VDD=VDD
Xcorner1 pad_corner $PINS VSS=VSS VDD=VDD
Xcorner2 pad_corner $PINS VSS=VSS VDD=VDD
Xcorner3 pad_corner $PINS VSS=VSS VDD=VDD
Xvdd0 pad_vdd $PINS VSS=VSS VDD=VDD
Xvss0 pad_gnd $PINS VSS=VSS VDD=VDD
Xclk_pad pad_in $PINS DataIn=clk_PAD pad=clk VSS=VSS VDD=VDD
Xcore TopModule $PINS clk=clk_PAD rst=rst_PAD sclk=sclk_PAD cs_n=cs_n_PAD
+ mosi=mosi_PAD miso=miso_PAD VDD=VDD VSS=VSS
Xcs_n_pad pad_in $PINS DataIn=cs_n_PAD pad=cs_n VSS=VSS VDD=VDD
Xmiso_pad pad_out $PINS pad=miso DataOut=miso_PAD VSS=VSS VDD=VDD
Xmosi_pad pad_in $PINS DataIn=mosi_PAD pad=mosi VSS=VSS VDD=VDD
Xrst_pad pad_in $PINS DataIn=rst_PAD pad=rst VSS=VSS VDD=VDD
Xsclk_pad pad_in $PINS DataIn=sclk_PAD pad=sclk VSS=VSS VDD=VDD
.ENDS
