* SPICE NETLIST
***************************************

*.CALIBRE ABORT_INFO SOFTCHK
.SUBCKT crtmom PLUS MINUS BULK
.ENDS
***************************************
.SUBCKT cfmom PLUS MINUS BULK
.ENDS
***************************************
.SUBCKT cfmom_rf PLUS MINUS BULK
.ENDS
***************************************
.SUBCKT cfmom_mx PLUS1 MINUS1 PLUS2 MINUS2 BULK
.ENDS
***************************************
.SUBCKT lcesd1_rf PLUS MINUS
.ENDS
***************************************
.SUBCKT lcesd2_rf PLUS MINUS
.ENDS
***************************************
.SUBCKT mimcap_2p0_shield PLUS MINUS BULK
.ENDS
***************************************
.SUBCKT mimcap_2p0_sin TOP BOT
.ENDS
***************************************
.SUBCKT mimcap_2p0_sin_3t PLUS MINUS BULK
.ENDS
***************************************
.SUBCKT mimcap_2p0_wos PLUS MINUS BULK
.ENDS
***************************************
.SUBCKT moscap_rf PLUS MINUS BULK
.ENDS
***************************************
.SUBCKT moscap_rf33 PLUS MINUS BULK
.ENDS
***************************************
.SUBCKT moscap_rf33_nw PLUS MINUS BULK
.ENDS
***************************************
.SUBCKT moscap_rf_nw PLUS MINUS BULK
.ENDS
***************************************
.SUBCKT nmos_rf D G S B
.ENDS
***************************************
.SUBCKT nmos_rf33 D G S B
.ENDS
***************************************
.SUBCKT nmos_rf33_6t D G S B NG PG
.ENDS
***************************************
.SUBCKT nmos_rf_6t D G S B NG PG
.ENDS
***************************************
.SUBCKT nmoscap PLUS MINUS
.ENDS
***************************************
.SUBCKT nmoscap_33 PLUS MINUS
.ENDS
***************************************
.SUBCKT pmos_rf D G S B
.ENDS
***************************************
.SUBCKT pmos_rf33 D G S B
.ENDS
***************************************
.SUBCKT pmos_rf33_5t D G S B PG
.ENDS
***************************************
.SUBCKT pmos_rf33_nw D G S B
.ENDS
***************************************
.SUBCKT pmos_rf33_nw_5t D G S B PG
.ENDS
***************************************
.SUBCKT pmos_rf_5t D G S B PG
.ENDS
***************************************
.SUBCKT pmos_rf_nw D G S B
.ENDS
***************************************
.SUBCKT pmos_rf_nw_5t D G S B PG
.ENDS
***************************************
.SUBCKT rnod_m PLUS MINUS B
.ENDS
***************************************
.SUBCKT rnodrpo_m PLUS MINUS B
.ENDS
***************************************
.SUBCKT rnodw_m PLUS MINUS B
.ENDS
***************************************
.SUBCKT rnpo1_dis PLUS MINUS B
.ENDS
***************************************
.SUBCKT rnpo1rpo_dis PLUS MINUS B
.ENDS
***************************************
.SUBCKT rnpo1w_dis PLUS MINUS B
.ENDS
***************************************
.SUBCKT rnwod_m PLUS MINUS B
.ENDS
***************************************
.SUBCKT rnwsti_m PLUS MINUS B
.ENDS
***************************************
.SUBCKT rpod_m PLUS MINUS B
.ENDS
***************************************
.SUBCKT rpodrpo_m PLUS MINUS B
.ENDS
***************************************
.SUBCKT rpodw_m PLUS MINUS B
.ENDS
***************************************
.SUBCKT rppo1_dis PLUS MINUS B
.ENDS
***************************************
.SUBCKT rppo1rpo_dis PLUS MINUS B
.ENDS
***************************************
.SUBCKT rppo1w_dis PLUS MINUS B
.ENDS
***************************************
.SUBCKT rppolyhri_dis PLUS MINUS B
.ENDS
***************************************
.SUBCKT rppolyhri_rf PLUS MINUS BULK
.ENDS
***************************************
.SUBCKT rppolyl_rf PLUS MINUS BULK
.ENDS
***************************************
.SUBCKT rppolys_rf PLUS MINUS BULK
.ENDS
***************************************
.SUBCKT rppolywo_rf PLUS MINUS BULK
.ENDS
***************************************
.SUBCKT sbd_rf PLUS MINUS BULK
.ENDS
***************************************
.SUBCKT sbd_rf_nw PLUS MINUS BULK
.ENDS
***************************************
.SUBCKT spiral_std_mu_x_40k PLUS MINUS BULK
.ENDS
***************************************
.SUBCKT spiral_sym_ct_mu_x_40k PLUS MINUS BULK CTAP
.ENDS
***************************************
.SUBCKT spiral_sym_mu_x_40k PLUS MINUS BULK
.ENDS
***************************************
.SUBCKT xjvar_nr36 PLUS MINUS BULK
.ENDS
***************************************
.SUBCKT xjvar_w40 PLUS MINUS BULK
.ENDS
***************************************
.SUBCKT tsmc_c018_sealring_corner_1p6m
** N=3 EP=0 IP=0 FDC=0
.ENDS
***************************************
.SUBCKT tsmc_c018_seal_ring_edge_1p6m
** N=3 EP=0 IP=0 FDC=0
.ENDS
***************************************
.SUBCKT ICV_10
** N=3 EP=0 IP=6 FDC=0
.ENDS
***************************************
.SUBCKT ICV_11
** N=3 EP=0 IP=6 FDC=0
.ENDS
***************************************
.SUBCKT ICV_12
** N=3 EP=0 IP=6 FDC=0
.ENDS
***************************************
.SUBCKT ICV_13
** N=3 EP=0 IP=6 FDC=0
.ENDS
***************************************
.SUBCKT ICV_15
** N=3 EP=0 IP=6 FDC=0
.ENDS
***************************************
.SUBCKT ICV_16
** N=3 EP=0 IP=6 FDC=0
.ENDS
***************************************
.SUBCKT ICV_17
** N=3 EP=0 IP=6 FDC=0
.ENDS
***************************************
.SUBCKT ICV_18
** N=3 EP=0 IP=6 FDC=0
.ENDS
***************************************
.SUBCKT ICV_19
** N=3 EP=0 IP=6 FDC=0
.ENDS
***************************************
.SUBCKT ICV_28
** N=3 EP=0 IP=6 FDC=0
.ENDS
***************************************
.SUBCKT ICV_29
** N=3 EP=0 IP=6 FDC=0
.ENDS
***************************************
.SUBCKT ICV_120
** N=102760 EP=0 IP=93 FDC=0
.ENDS
***************************************
.SUBCKT pad_corner
** N=4 EP=0 IP=0 FDC=0
*.CALIBRE ISOLATED NETS: VSS VDD
.ENDS
***************************************
.SUBCKT pad_fill_32
** N=4 EP=0 IP=0 FDC=0
*.CALIBRE ISOLATED NETS: VSS VDD
.ENDS
***************************************
.SUBCKT ICV_118
** N=4 EP=0 IP=8 FDC=0
.ENDS
***************************************
.SUBCKT pad_fill_16
** N=4 EP=0 IP=0 FDC=0
*.CALIBRE ISOLATED NETS: VSS VDD
.ENDS
***************************************
.SUBCKT pad_fill_8
** N=4 EP=0 IP=0 FDC=0
*.CALIBRE ISOLATED NETS: VSS VDD
.ENDS
***************************************
.SUBCKT pad_fill_4
** N=4 EP=0 IP=0 FDC=0
*.CALIBRE ISOLATED NETS: VSS VDD
.ENDS
***************************************
.SUBCKT pad_fill_2
** N=4 EP=0 IP=0 FDC=0
*.CALIBRE ISOLATED NETS: VSS VDD
.ENDS
***************************************
.SUBCKT pad_fill_01
** N=4 EP=0 IP=0 FDC=0
*.CALIBRE ISOLATED NETS: VSS VDD
.ENDS
***************************************
.SUBCKT pad_fill_005
** N=4 EP=0 IP=0 FDC=0
*.CALIBRE ISOLATED NETS: VSS VDD
.ENDS
***************************************
.SUBCKT ICV_119
** N=36582 EP=0 IP=161 FDC=0
.ENDS
***************************************
.SUBCKT FILL32
** N=8 EP=0 IP=0 FDC=0
.ENDS
***************************************
.SUBCKT ICV_37
** N=4 EP=0 IP=8 FDC=0
.ENDS
***************************************
.SUBCKT ICV_38
** N=5 EP=0 IP=8 FDC=0
.ENDS
***************************************
.SUBCKT ICV_41
** N=5 EP=0 IP=8 FDC=0
.ENDS
***************************************
.SUBCKT ICV_42
** N=5 EP=0 IP=10 FDC=0
.ENDS
***************************************
.SUBCKT ICV_43
** N=7 EP=0 IP=10 FDC=0
.ENDS
***************************************
.SUBCKT ICV_44
** N=11 EP=0 IP=14 FDC=0
.ENDS
***************************************
.SUBCKT ICV_45
** N=19 EP=0 IP=22 FDC=0
.ENDS
***************************************
.SUBCKT ICV_116
** N=19 EP=0 IP=38 FDC=0
.ENDS
***************************************
.SUBCKT FILL16
** N=8 EP=0 IP=0 FDC=0
.ENDS
***************************************
.SUBCKT FILL8
** N=8 EP=0 IP=0 FDC=0
.ENDS
***************************************
.SUBCKT ICV_55
** N=4 EP=0 IP=8 FDC=0
.ENDS
***************************************
.SUBCKT FILL4
** N=4 EP=0 IP=0 FDC=0
.ENDS
***************************************
.SUBCKT ICV_53
** N=4 EP=0 IP=8 FDC=0
.ENDS
***************************************
.SUBCKT FILL1
** N=4 EP=0 IP=0 FDC=0
.ENDS
***************************************
.SUBCKT DFFQSRX1 D CLK SETB RESETB VSS VDD Q
** N=34 EP=7 IP=0 FDC=40
M0 VSS D 20 VSS N L=1.8e-07 W=2.2e-07 $X=945 $Y=750 $D=0
M1 10 CLK VSS VSS N L=1.8e-07 W=2.2e-07 $X=1745 $Y=750 $D=0
M2 11 10 20 VSS N L=1.8e-07 W=2.2e-07 $X=3245 $Y=755 $D=0
M3 12 11 VSS VSS N L=1.8e-07 W=2.2e-07 $X=4745 $Y=755 $D=0
M4 13 12 VSS VSS N L=1.8e-07 W=2.2e-07 $X=6250 $Y=760 $D=0
M5 VSS 14 13 VSS N L=1.8e-07 W=2.2e-07 $X=7050 $Y=760 $D=0
M6 15 13 VSS VSS N L=1.8e-07 W=2.2e-07 $X=7850 $Y=1120 $D=0
M7 VSS SETB 14 VSS N L=1.8e-07 W=2.2e-07 $X=9355 $Y=755 $D=0
M8 22 CLK 11 VSS N L=1.8e-07 W=2.2e-07 $X=10860 $Y=750 $D=0
M9 33 15 VSS VSS N L=1.8e-07 W=4.4e-07 $X=12320 $Y=965 $D=0
M10 22 RESETB 33 VSS N L=1.8e-07 W=4.4e-07 $X=13040 $Y=965 $D=0
M11 16 CLK 15 VSS N L=1.8e-07 W=2.2e-07 $X=14500 $Y=755 $D=0
M12 34 16 VSS VSS N L=1.8e-07 W=4.4e-07 $X=15960 $Y=740 $D=0
M13 17 RESETB 34 VSS N L=1.8e-07 W=4.4e-07 $X=16680 $Y=740 $D=0
M14 18 17 VSS VSS N L=1.8e-07 W=2.2e-07 $X=18140 $Y=755 $D=0
M15 19 18 VSS VSS N L=1.8e-07 W=2.2e-07 $X=19640 $Y=755 $D=0
M16 VSS 14 19 VSS N L=1.8e-07 W=2.2e-07 $X=20440 $Y=755 $D=0
M17 24 19 VSS VSS N L=1.8e-07 W=2.2e-07 $X=21240 $Y=755 $D=0
M18 16 10 24 VSS N L=1.8e-07 W=2.2e-07 $X=22740 $Y=755 $D=0
M19 Q 17 VSS VSS N L=1.8e-07 W=2.2e-07 $X=24240 $Y=755 $D=0
M20 VDD D 20 VDD P L=1.8e-07 W=4.4e-07 $X=945 $Y=2705 $D=16
M21 10 CLK VDD VDD P L=1.8e-07 W=4.4e-07 $X=1665 $Y=2705 $D=16
M22 11 CLK 20 VDD P L=1.8e-07 W=4.4e-07 $X=3245 $Y=2725 $D=16
M23 12 11 VDD VDD P L=1.8e-07 W=4.4e-07 $X=4745 $Y=2725 $D=16
M24 21 12 13 VDD P L=1.8e-07 W=8.8e-07 $X=6250 $Y=2300 $D=16
M25 VDD 14 21 VDD P L=1.8e-07 W=8.8e-07 $X=6970 $Y=2300 $D=16
M26 15 13 VDD VDD P L=1.8e-07 W=4.4e-07 $X=7730 $Y=2520 $D=16
M27 VDD SETB 14 VDD P L=1.8e-07 W=4.4e-07 $X=9355 $Y=2535 $D=16
M28 22 10 11 VDD P L=1.8e-07 W=4.4e-07 $X=10815 $Y=2505 $D=16
M29 22 15 VDD VDD P L=1.8e-07 W=4.4e-07 $X=12320 $Y=2505 $D=16
M30 VDD RESETB 22 VDD P L=1.8e-07 W=4.4e-07 $X=13040 $Y=2505 $D=16
M31 16 10 15 VDD P L=1.8e-07 W=4.4e-07 $X=14500 $Y=2505 $D=16
M32 17 16 VDD VDD P L=1.8e-07 W=4.4e-07 $X=15960 $Y=2665 $D=16
M33 VDD RESETB 17 VDD P L=1.8e-07 W=4.4e-07 $X=16680 $Y=2665 $D=16
M34 18 17 VDD VDD P L=1.8e-07 W=4.4e-07 $X=18140 $Y=2725 $D=16
M35 23 18 19 VDD P L=1.8e-07 W=8.8e-07 $X=19640 $Y=2285 $D=16
M36 VDD 14 23 VDD P L=1.8e-07 W=8.8e-07 $X=20360 $Y=2285 $D=16
M37 24 19 VDD VDD P L=1.8e-07 W=4.4e-07 $X=21120 $Y=2505 $D=16
M38 16 CLK 24 VDD P L=1.8e-07 W=4.4e-07 $X=22740 $Y=2505 $D=16
M39 Q 17 VDD VDD P L=1.8e-07 W=4.4e-07 $X=24200 $Y=2505 $D=16
.ENDS
***************************************
.SUBCKT FILL2
** N=4 EP=0 IP=0 FDC=0
.ENDS
***************************************
.SUBCKT ICV_51
** N=4 EP=0 IP=8 FDC=0
.ENDS
***************************************
.SUBCKT MUX2X1 A S B VSS VDD Z
** N=16 EP=6 IP=0 FDC=12
M0 VSS S 9 VSS N L=1.8e-07 W=4.4e-07 $X=940 $Y=960 $D=0
M1 15 A VSS VSS N L=1.8e-07 W=4.4e-07 $X=1660 $Y=960 $D=0
M2 10 9 15 VSS N L=1.8e-07 W=4.4e-07 $X=2380 $Y=960 $D=0
M3 16 S 10 VSS N L=1.8e-07 W=4.4e-07 $X=3100 $Y=960 $D=0
M4 VSS B 16 VSS N L=1.8e-07 W=4.4e-07 $X=3920 $Y=740 $D=0
M5 Z 10 VSS VSS N L=1.8e-07 W=4.4e-07 $X=4640 $Y=740 $D=0
M6 VDD S 9 VDD P L=1.8e-07 W=4.4e-07 $X=940 $Y=2520 $D=16
M7 11 A VDD VDD P L=1.8e-07 W=4.4e-07 $X=1660 $Y=2520 $D=16
M8 10 S 11 VDD P L=1.8e-07 W=4.4e-07 $X=2380 $Y=2520 $D=16
M9 12 9 10 VDD P L=1.8e-07 W=4.4e-07 $X=3100 $Y=2520 $D=16
M10 VDD B 12 VDD P L=1.8e-07 W=4.4e-07 $X=3920 $Y=2735 $D=16
M11 Z 10 VDD VDD P L=1.8e-07 W=4.4e-07 $X=4640 $Y=2735 $D=16
.ENDS
***************************************
.SUBCKT NAND2X1 A B VSS VDD Z
** N=9 EP=5 IP=0 FDC=4
M0 9 A VSS VSS N L=1.8e-07 W=4.4e-07 $X=985 $Y=745 $D=0
M1 Z B 9 VSS N L=1.8e-07 W=4.4e-07 $X=1705 $Y=745 $D=0
M2 Z A VDD VDD P L=1.8e-07 W=4.4e-07 $X=985 $Y=2670 $D=16
M3 VDD B Z VDD P L=1.8e-07 W=4.4e-07 $X=1705 $Y=2670 $D=16
.ENDS
***************************************
.SUBCKT ICV_50
** N=4 EP=0 IP=8 FDC=0
.ENDS
***************************************
.SUBCKT ICV_34
** N=4 EP=0 IP=8 FDC=0
.ENDS
***************************************
.SUBCKT ICV_61
** N=5 EP=0 IP=10 FDC=0
.ENDS
***************************************
.SUBCKT ICV_64
** N=7 EP=0 IP=10 FDC=0
.ENDS
***************************************
.SUBCKT ICV_65
** N=7 EP=0 IP=14 FDC=0
.ENDS
***************************************
.SUBCKT ICV_66
** N=11 EP=0 IP=14 FDC=0
.ENDS
***************************************
.SUBCKT ICV_57
** N=4 EP=0 IP=8 FDC=0
.ENDS
***************************************
.SUBCKT ICV_68 1 2 3 4 5
** N=7 EP=5 IP=11 FDC=4
X1 3 4 1 2 5 NAND2X1 $T=1120 0 0 0 $X=690 $Y=-390
.ENDS
***************************************
.SUBCKT ICV_69 1 2 3 4 5
** N=7 EP=5 IP=11 FDC=4
X0 2 3 1 5 4 NAND2X1 $T=1680 0 0 0 $X=1250 $Y=-390
.ENDS
***************************************
.SUBCKT NOR2X1 A B VSS VDD Z
** N=10 EP=5 IP=0 FDC=4
M0 Z A VSS VSS N L=1.8e-07 W=2.2e-07 $X=925 $Y=760 $D=0
M1 VSS B Z VSS N L=1.8e-07 W=2.2e-07 $X=1725 $Y=760 $D=0
M2 8 A VDD VDD P L=1.8e-07 W=8.8e-07 $X=925 $Y=2300 $D=16
M3 Z B 8 VDD P L=1.8e-07 W=8.8e-07 $X=1645 $Y=2300 $D=16
.ENDS
***************************************
.SUBCKT ICV_81 1 2 3 4 5
** N=7 EP=5 IP=11 FDC=4
X1 3 4 1 2 5 NAND2X1 $T=2240 0 0 0 $X=1810 $Y=-390
.ENDS
***************************************
.SUBCKT ICV_76 1 2 3 4 5
** N=7 EP=5 IP=11 FDC=4
X1 3 4 1 2 5 NAND2X1 $T=560 0 0 0 $X=130 $Y=-390
.ENDS
***************************************
.SUBCKT NAND3X1 A B C VSS VDD Z
** N=10 EP=6 IP=0 FDC=6
M0 9 A VSS VSS N L=1.8e-07 W=6.6e-07 $X=1210 $Y=745 $D=0
M1 10 B 9 VSS N L=1.8e-07 W=6.6e-07 $X=1930 $Y=745 $D=0
M2 Z C 10 VSS N L=1.8e-07 W=6.6e-07 $X=2650 $Y=745 $D=0
M3 Z A VDD VDD P L=1.8e-07 W=4.4e-07 $X=1210 $Y=2670 $D=16
M4 VDD B Z VDD P L=1.8e-07 W=4.4e-07 $X=1930 $Y=2670 $D=16
M5 Z C VDD VDD P L=1.8e-07 W=4.4e-07 $X=2650 $Y=2670 $D=16
.ENDS
***************************************
.SUBCKT ICV_115 1 2 3 4 5 6 7 8
** N=10 EP=8 IP=14 FDC=8
X0 2 3 1 5 4 NAND2X1 $T=0 0 1 180 $X=-3230 $Y=-390
X1 6 7 1 5 8 NAND2X1 $T=0 0 0 0 $X=-430 $Y=-390
.ENDS
***************************************
.SUBCKT OR2X1 A B VSS VDD Z
** N=12 EP=5 IP=0 FDC=6
M0 8 A VSS VSS N L=1.8e-07 W=2.2e-07 $X=835 $Y=760 $D=0
M1 VSS B 8 VSS N L=1.8e-07 W=2.2e-07 $X=1635 $Y=760 $D=0
M2 Z 8 VSS VSS N L=1.8e-07 W=2.2e-07 $X=2435 $Y=760 $D=0
M3 9 A 8 VDD P L=1.8e-07 W=8.8e-07 $X=835 $Y=2300 $D=16
M4 VDD B 9 VDD P L=1.8e-07 W=8.8e-07 $X=1555 $Y=2300 $D=16
M5 Z 8 VDD VDD P L=1.8e-07 W=4.4e-07 $X=2315 $Y=2520 $D=16
.ENDS
***************************************
.SUBCKT ICV_74 1 2 3 4 5
** N=7 EP=5 IP=11 FDC=4
X1 3 4 1 2 5 NAND2X1 $T=3360 0 1 180 $X=130 $Y=-390
.ENDS
***************************************
.SUBCKT ICV_78 1 2 3 4 5
** N=7 EP=5 IP=11 FDC=4
X0 2 3 1 5 4 NAND2X1 $T=4480 0 1 180 $X=1250 $Y=-390
.ENDS
***************************************
.SUBCKT ICV_52
** N=4 EP=0 IP=8 FDC=0
.ENDS
***************************************
.SUBCKT ICV_72 1 2 3 4 5
** N=7 EP=5 IP=11 FDC=4
X1 3 4 1 2 5 NAND2X1 $T=0 0 0 0 $X=-430 $Y=-390
.ENDS
***************************************
.SUBCKT AND2X1 A B VSS VDD Z
** N=10 EP=5 IP=0 FDC=6
M0 10 A 8 VSS N L=1.8e-07 W=4.4e-07 $X=905 $Y=750 $D=0
M1 VSS B 10 VSS N L=1.8e-07 W=4.4e-07 $X=1625 $Y=750 $D=0
M2 Z 8 VSS VSS N L=1.8e-07 W=2.2e-07 $X=2385 $Y=860 $D=0
M3 8 A VDD VDD P L=1.8e-07 W=4.4e-07 $X=905 $Y=2670 $D=16
M4 VDD B 8 VDD P L=1.8e-07 W=4.4e-07 $X=1625 $Y=2670 $D=16
M5 Z 8 VDD VDD P L=1.8e-07 W=4.4e-07 $X=2385 $Y=2670 $D=16
.ENDS
***************************************
.SUBCKT INVX2 A VSS VDD Z
** N=6 EP=4 IP=0 FDC=2
M0 Z A VSS VSS N L=1.8e-07 W=4.4e-07 $X=740 $Y=740 $D=0
M1 Z A VDD VDD P L=1.8e-07 W=8.8e-07 $X=740 $Y=2300 $D=16
.ENDS
***************************************
.SUBCKT ICV_62
** N=4 EP=0 IP=8 FDC=0
.ENDS
***************************************
.SUBCKT ICV_63
** N=4 EP=0 IP=8 FDC=0
.ENDS
***************************************
.SUBCKT ICV_33
** N=4 EP=0 IP=8 FDC=0
.ENDS
***************************************
.SUBCKT ICV_35
** N=4 EP=0 IP=8 FDC=0
.ENDS
***************************************
.SUBCKT BUFX1 A VSS VDD Z
** N=7 EP=4 IP=0 FDC=4
M0 VSS A 7 VSS N L=1.8e-07 W=2.2e-07 $X=925 $Y=760 $D=0
M1 Z 7 VSS VSS N L=1.8e-07 W=2.2e-07 $X=1725 $Y=760 $D=0
M2 VDD A 7 VDD P L=1.8e-07 W=4.4e-07 $X=925 $Y=2715 $D=16
M3 Z 7 VDD VDD P L=1.8e-07 W=4.4e-07 $X=1645 $Y=2715 $D=16
.ENDS
***************************************
.SUBCKT ICV_70
** N=4 EP=0 IP=8 FDC=0
.ENDS
***************************************
.SUBCKT ICV_117 45 85 86 87 88 89 90 91 92 93 94 95 96 97 98 99 100 101 102 103
+ 104 105 106 107 108 109 110 111 112 113 114 115 116 117 118 119 120 121 122 123
+ 124 125 126 127 128 129 130 131 132 133 134 135 136 137 138 139 140 141 142 143
+ 144 145 146 147 148 149 150 151 152 153 154 155 156 157 158 159 160 161 162 163
+ 164 165 166 167 168 169 170 171 172 173 174 175 176 177 178 179 180 181 182 183
+ 184 185 186 187 188 189 190 191 192 193 194 195 196 197 198 199 200 201 202 203
+ 204 205 206 207 208 209 210 211 212 213 214 215 216 217 218 219 220 221 222 223
+ 224 225 226 227 228 229 230 231 232 233 234 235 236 237 238 239 240 241 242 243
+ 244 245 246 247 248 249 250 251 252 253 254 255 256 257 258 259 260 261 262 263
+ 264 265 266 267 268 269 270 271 272 273 274 275 276 277 278 279 280 281 282 283
+ 284 285 286 287 288 289 290 291 292 293 294 295 296 297 298 299 300 301 302 303
+ 304 305 306 307 308 309 310 311 312 313 314 315 316 317 318 319 320 321 322 323
+ 324 325 326 327 328 329 330 331 332 333 334 335 336 337 338 339 340 341 342 343
+ 344 345 346 347 348 349 350 351 424 425 426 427 428 429 430 431 434 435 436 439
+ 440 441
** N=185337 EP=282 IP=9416 FDC=5526
X481 424 426 85 427 45 85 86 DFFQSRX1 $T=753920 475405 0 0 $X=753490 $Y=475015
X482 425 426 85 427 45 85 87 DFFQSRX1 $T=753920 483245 1 0 $X=753490 $Y=478690
X483 27359 426 85 427 45 85 88 DFFQSRX1 $T=763440 475405 1 0 $X=763010 $Y=470850
X484 27811 426 85 427 45 85 93 DFFQSRX1 $T=778560 459725 0 0 $X=778130 $Y=459335
X485 27716 426 85 427 45 85 92 DFFQSRX1 $T=778560 467565 1 0 $X=778130 $Y=463010
X486 428 426 85 427 45 85 96 DFFQSRX1 $T=779120 483245 1 0 $X=778690 $Y=478690
X487 28677 430 85 427 45 85 94 DFFQSRX1 $T=828400 459725 0 180 $X=802770 $Y=455170
X488 28678 430 85 427 45 85 95 DFFQSRX1 $T=828960 475405 0 180 $X=803330 $Y=470850
X489 429 430 85 427 45 85 97 DFFQSRX1 $T=805440 483245 1 0 $X=805010 $Y=478690
X490 29313 430 85 427 45 85 29444 DFFQSRX1 $T=826720 459725 0 0 $X=826290 $Y=459335
X491 29336 430 85 427 45 85 29461 DFFQSRX1 $T=828960 475405 1 0 $X=828530 $Y=470850
X492 29935 430 85 427 45 85 30027 DFFQSRX1 $T=834000 451885 1 0 $X=833570 $Y=447330
X493 29602 430 85 427 45 85 100 DFFQSRX1 $T=834000 451885 0 0 $X=833570 $Y=451495
X494 29673 430 85 427 45 85 101 DFFQSRX1 $T=834000 467565 0 0 $X=833570 $Y=467175
X495 34291 35893 85 427 45 85 33340 DFFQSRX1 $T=1009840 397005 0 180 $X=984210 $Y=392450
X496 34897 35893 85 427 45 85 34256 DFFQSRX1 $T=1028320 397005 1 180 $X=1002690 $Y=396615
X497 37511 35893 85 427 45 85 134 DFFQSRX1 $T=1089920 412685 1 0 $X=1089490 $Y=408130
X498 37719 35893 85 427 45 85 111 DFFQSRX1 $T=1125760 444045 0 180 $X=1100130 $Y=439490
X499 37874 35893 85 427 45 85 37458 DFFQSRX1 $T=1129120 420525 1 180 $X=1103490 $Y=420135
X500 435 434 85 427 45 85 38225 DFFQSRX1 $T=1151520 459725 1 180 $X=1125890 $Y=459335
X501 38812 434 85 427 45 85 37253 DFFQSRX1 $T=1153760 467565 1 180 $X=1128130 $Y=467175
X502 38813 436 85 427 45 85 32314 DFFQSRX1 $T=1153760 483245 0 180 $X=1128130 $Y=478690
X503 39133 434 85 427 45 85 37385 DFFQSRX1 $T=1164960 459725 0 180 $X=1139330 $Y=455170
X504 39321 434 85 427 45 85 191 DFFQSRX1 $T=1165520 420525 0 180 $X=1139890 $Y=415970
X505 39049 434 85 427 45 85 38563 DFFQSRX1 $T=1165520 428365 0 180 $X=1139890 $Y=423810
X506 38980 434 85 427 45 85 39430 DFFQSRX1 $T=1140320 451885 0 0 $X=1139890 $Y=451495
X507 39272 434 85 427 45 85 39558 DFFQSRX1 $T=1157680 444045 0 0 $X=1157250 $Y=443655
X508 39769 434 85 427 45 85 335 DFFQSRX1 $T=1185120 467565 1 180 $X=1159490 $Y=467175
X509 39787 434 85 427 45 85 342 DFFQSRX1 $T=1185120 483245 0 180 $X=1159490 $Y=478690
X510 431 434 85 427 45 85 40300 DFFQSRX1 $T=1167200 420525 1 0 $X=1166770 $Y=415970
X511 40262 439 85 427 45 85 39360 DFFQSRX1 $T=1192400 428365 0 180 $X=1166770 $Y=423810
X512 40282 439 85 427 45 85 39752 DFFQSRX1 $T=1203600 459725 1 180 $X=1177970 $Y=459335
X513 40362 439 85 427 45 85 39734 DFFQSRX1 $T=1205840 467565 0 180 $X=1180210 $Y=463010
X514 40587 439 85 427 45 85 40639 DFFQSRX1 $T=1194640 451885 1 0 $X=1194210 $Y=447330
X515 40300 439 85 427 45 85 350 DFFQSRX1 $T=1198560 428365 1 0 $X=1198130 $Y=423810
X516 40586 439 85 427 45 85 39487 DFFQSRX1 $T=1198560 436205 1 0 $X=1198130 $Y=431650
X517 40635 439 85 427 45 85 347 DFFQSRX1 $T=1198560 467565 0 0 $X=1198130 $Y=467175
X518 440 439 85 427 45 85 344 DFFQSRX1 $T=1198560 483245 0 0 $X=1198130 $Y=482855
X519 41297 441 85 427 45 85 40301 DFFQSRX1 $T=1234400 428365 1 180 $X=1208770 $Y=427975
X520 41171 441 85 427 45 85 40766 DFFQSRX1 $T=1234400 444045 1 180 $X=1208770 $Y=443655
X521 41318 441 85 427 45 85 40961 DFFQSRX1 $T=1237760 483245 0 180 $X=1212130 $Y=478690
X522 41510 441 85 427 45 85 41027 DFFQSRX1 $T=1240000 451885 1 180 $X=1214370 $Y=451495
X621 88 89 86 45 85 27359 MUX2X1 $T=784720 475405 1 180 $X=778690 $Y=475015
X622 94 89 92 45 85 28677 MUX2X1 $T=812720 467565 1 0 $X=812290 $Y=463010
X623 95 89 93 45 85 28678 MUX2X1 $T=812720 475405 0 0 $X=812290 $Y=475015
X624 29444 98 95 45 85 29313 MUX2X1 $T=841840 467565 0 180 $X=835810 $Y=463010
X625 29461 98 97 45 85 29336 MUX2X1 $T=842400 483245 0 180 $X=836370 $Y=478690
X626 100 98 88 45 85 29602 MUX2X1 $T=850800 467565 0 180 $X=844770 $Y=463010
X627 101 98 99 45 85 29673 MUX2X1 $T=853040 483245 0 180 $X=847010 $Y=478690
X628 30027 98 94 45 85 29935 MUX2X1 $T=861440 459725 1 180 $X=855410 $Y=459335
X629 31476 134 123 45 85 30952 MUX2X1 $T=904560 459725 1 180 $X=898530 $Y=459335
X630 124 134 131 45 85 30953 MUX2X1 $T=906800 451885 1 180 $X=900770 $Y=451495
X631 31581 139 129 45 85 31114 MUX2X1 $T=907920 436205 1 180 $X=901890 $Y=435815
X632 142 139 136 45 85 31473 MUX2X1 $T=908480 428365 0 180 $X=902450 $Y=423810
X633 31476 139 31508 45 85 31266 MUX2X1 $T=904000 459725 1 0 $X=903570 $Y=455170
X634 141 139 146 45 85 31487 MUX2X1 $T=904560 420525 1 0 $X=904130 $Y=415970
X635 31662 139 138 45 85 31725 MUX2X1 $T=907920 436205 0 0 $X=907490 $Y=435815
X636 31662 134 31619 45 85 31647 MUX2X1 $T=908480 451885 1 0 $X=908050 $Y=447330
X637 154 134 146 45 85 31767 MUX2X1 $T=918560 404845 1 180 $X=912530 $Y=404455
X638 31894 134 154 45 85 31440 MUX2X1 $T=919120 412685 0 180 $X=913090 $Y=408130
X639 171 134 164 45 85 31931 MUX2X1 $T=924160 420525 1 180 $X=918130 $Y=420135
X640 31619 134 31894 45 85 32092 MUX2X1 $T=919120 412685 1 0 $X=918690 $Y=408130
X641 150 134 32223 45 85 32309 MUX2X1 $T=929200 412685 1 0 $X=928770 $Y=408130
X642 32223 134 176 45 85 32394 MUX2X1 $T=931440 420525 1 0 $X=931010 $Y=415970
X643 180 134 173 45 85 32439 MUX2X1 $T=942080 436205 0 180 $X=936050 $Y=431650
X644 141 134 150 45 85 32583 MUX2X1 $T=937040 420525 1 0 $X=936610 $Y=415970
X645 180 139 193 45 85 32692 MUX2X1 $T=940400 428365 1 0 $X=939970 $Y=423810
X646 205 134 32642 45 85 32372 MUX2X1 $T=948240 436205 1 180 $X=942210 $Y=435815
X647 32642 134 193 45 85 32776 MUX2X1 $T=943200 436205 1 0 $X=942770 $Y=431650
X648 245 134 256 45 85 35119 MUX2X1 $T=1019360 420525 0 0 $X=1018930 $Y=420135
X649 276 134 271 45 85 35310 MUX2X1 $T=1036720 483245 0 180 $X=1030690 $Y=478690
X650 257 134 275 45 85 34934 MUX2X1 $T=1037840 451885 1 180 $X=1031810 $Y=451495
X651 255 139 260 45 85 35387 MUX2X1 $T=1039520 459725 0 180 $X=1033490 $Y=455170
X652 34611 134 35481 45 85 35418 MUX2X1 $T=1035040 420525 1 0 $X=1034610 $Y=415970
X653 248 139 280 45 85 35419 MUX2X1 $T=1046240 420525 0 180 $X=1040210 $Y=415970
X654 262 139 272 45 85 35559 MUX2X1 $T=1046800 412685 1 180 $X=1040770 $Y=412295
X655 34611 139 277 45 85 35993 MUX2X1 $T=1051840 420525 1 0 $X=1051410 $Y=415970
X656 294 134 36036 45 85 34999 MUX2X1 $T=1061360 451885 0 180 $X=1055330 $Y=447330
X657 35481 134 280 45 85 36257 MUX2X1 $T=1070320 412685 1 180 $X=1064290 $Y=412295
X658 281 139 36457 45 85 36420 MUX2X1 $T=1075920 420525 1 180 $X=1069890 $Y=420135
X659 315 139 264 45 85 36458 MUX2X1 $T=1078720 451885 1 180 $X=1072690 $Y=451495
X660 36509 139 36111 45 85 36538 MUX2X1 $T=1079840 428365 1 180 $X=1073810 $Y=427975
X661 36111 139 303 45 85 36692 MUX2X1 $T=1074800 459725 1 0 $X=1074370 $Y=455170
X662 36457 139 36509 45 85 36568 MUX2X1 $T=1075360 428365 1 0 $X=1074930 $Y=423810
X663 305 134 303 45 85 36658 MUX2X1 $T=1075360 451885 1 0 $X=1074930 $Y=447330
X664 240 134 37305 45 85 37511 MUX2X1 $T=1100560 420525 1 0 $X=1100130 $Y=415970
X665 334 98 335 45 85 336 MUX2X1 $T=1134160 483245 0 0 $X=1133730 $Y=482855
X666 37253 98 337 45 85 38812 MUX2X1 $T=1139760 475405 1 0 $X=1139330 $Y=470850
X667 32314 98 338 45 85 38813 MUX2X1 $T=1139760 483245 0 0 $X=1139330 $Y=482855
X668 37385 98 341 45 85 39133 MUX2X1 $T=1150400 475405 1 0 $X=1149970 $Y=470850
X669 335 89 39734 45 85 39769 MUX2X1 $T=1170560 475405 1 0 $X=1170130 $Y=470850
X670 342 89 39752 45 85 39787 MUX2X1 $T=1171120 475405 0 0 $X=1170690 $Y=475015
X671 341 89 344 45 85 345 MUX2X1 $T=1173360 483245 0 0 $X=1172930 $Y=482855
X672 40301 41171 351 45 85 41297 MUX2X1 $T=1219280 436205 0 0 $X=1218850 $Y=435815
X673 90 86 45 85 27583 NAND2X1 $T=787520 475405 1 180 $X=784290 $Y=475015
X674 90 87 45 85 27677 NAND2X1 $T=790320 475405 1 180 $X=787090 $Y=475015
X675 27583 27734 45 85 27716 NAND2X1 $T=788640 475405 1 0 $X=788210 $Y=470850
X676 27677 27834 45 85 27811 NAND2X1 $T=791440 475405 1 0 $X=791010 $Y=470850
X677 91 92 45 85 27734 NAND2X1 $T=794240 475405 1 0 $X=793810 $Y=470850
X678 91 93 45 85 27834 NAND2X1 $T=799280 475405 0 0 $X=798850 $Y=475015
X679 106 29444 45 85 107 NAND2X1 $T=887760 483245 0 0 $X=887330 $Y=482855
X680 31116 31100 45 85 31115 NAND2X1 $T=891680 451885 1 180 $X=888450 $Y=451495
X681 30952 110 45 85 31132 NAND2X1 $T=889440 459725 0 0 $X=889010 $Y=459335
X682 113 112 45 85 31003 NAND2X1 $T=893920 444045 1 180 $X=890690 $Y=443655
X683 31229 31268 45 85 31250 NAND2X1 $T=893360 475405 0 0 $X=892930 $Y=475015
X684 121 123 45 85 31333 NAND2X1 $T=896160 459725 0 0 $X=895730 $Y=459335
X685 31114 110 45 85 31380 NAND2X1 $T=897840 444045 1 0 $X=897410 $Y=439490
X686 113 127 45 85 31293 NAND2X1 $T=897840 451885 1 0 $X=897410 $Y=447330
X687 126 123 45 85 31229 NAND2X1 $T=900640 483245 0 180 $X=897410 $Y=478690
X688 122 133 45 85 31459 NAND2X1 $T=900640 451885 1 0 $X=900210 $Y=447330
X689 31487 130 45 85 31472 NAND2X1 $T=904000 404845 1 180 $X=900770 $Y=404455
X690 126 31508 45 85 31088 NAND2X1 $T=901760 467565 1 0 $X=901330 $Y=463010
X691 122 135 45 85 31492 NAND2X1 $T=901760 475405 0 0 $X=901330 $Y=475015
X692 140 138 45 85 31377 NAND2X1 $T=906800 412685 1 180 $X=903570 $Y=412295
X693 143 31619 45 85 31417 NAND2X1 $T=905680 436205 1 0 $X=905250 $Y=431650
X694 143 141 45 85 31582 NAND2X1 $T=908480 467565 0 180 $X=905250 $Y=463010
X695 137 133 45 85 31528 NAND2X1 $T=909600 451885 1 180 $X=906370 $Y=451495
X696 31473 130 45 85 31679 NAND2X1 $T=908480 436205 1 0 $X=908050 $Y=431650
X697 143 131 45 85 31677 NAND2X1 $T=911280 467565 0 180 $X=908050 $Y=463010
X698 137 147 45 85 148 NAND2X1 $T=911280 483245 1 180 $X=908050 $Y=482855
X699 31266 132 45 85 31707 NAND2X1 $T=912400 451885 1 180 $X=909170 $Y=451495
X700 143 146 45 85 31416 NAND2X1 $T=912960 420525 0 180 $X=909730 $Y=415970
X701 31725 130 45 85 31755 NAND2X1 $T=914080 436205 0 180 $X=910850 $Y=431650
X702 140 31662 45 85 31756 NAND2X1 $T=914080 467565 0 180 $X=910850 $Y=463010
X703 143 138 45 85 31768 NAND2X1 $T=914640 412685 1 180 $X=911410 $Y=412295
X704 140 129 45 85 31791 NAND2X1 $T=915200 428365 1 180 $X=911970 $Y=427975
X705 149 127 45 85 31788 NAND2X1 $T=915200 444045 1 180 $X=911970 $Y=443655
X706 140 164 45 85 31895 NAND2X1 $T=917440 428365 1 0 $X=917010 $Y=423810
X707 31931 132 45 85 31912 NAND2X1 $T=919120 420525 1 0 $X=918690 $Y=415970
X708 169 124 45 85 31950 NAND2X1 $T=922480 459725 1 180 $X=919250 $Y=459335
X709 137 163 45 85 167 NAND2X1 $T=922480 467565 0 180 $X=919250 $Y=463010
X710 31931 130 45 85 31966 NAND2X1 $T=920240 428365 1 0 $X=919810 $Y=423810
X711 140 176 45 85 31833 NAND2X1 $T=921920 420525 1 0 $X=921490 $Y=415970
X712 143 171 45 85 32003 NAND2X1 $T=925280 459725 1 180 $X=922050 $Y=459335
X713 179 31978 45 85 31894 NAND2X1 $T=925840 475405 0 180 $X=922610 $Y=470850
X714 140 31894 45 85 32107 NAND2X1 $T=923600 451885 0 0 $X=923170 $Y=451495
X715 143 136 45 85 32122 NAND2X1 $T=924160 420525 0 0 $X=923730 $Y=420135
X716 179 31135 45 85 175 NAND2X1 $T=924160 475405 0 0 $X=923730 $Y=475015
X717 143 176 45 85 32137 NAND2X1 $T=924720 420525 1 0 $X=924290 $Y=415970
X718 137 32172 45 85 160 NAND2X1 $T=925840 467565 0 0 $X=925410 $Y=467175
X719 179 170 45 85 32172 NAND2X1 $T=928640 475405 0 180 $X=925410 $Y=470850
X720 107 186 45 85 32223 NAND2X1 $T=927520 483245 0 0 $X=927090 $Y=482855
X721 149 184 45 85 32061 NAND2X1 $T=930880 428365 1 180 $X=927650 $Y=427975
X722 149 188 45 85 31458 NAND2X1 $T=928080 436205 0 0 $X=927650 $Y=435815
X723 143 32223 45 85 32178 NAND2X1 $T=928080 459725 1 0 $X=927650 $Y=455170
X724 185 31135 45 85 31619 NAND2X1 $T=931440 467565 1 180 $X=928210 $Y=467175
X725 32304 32219 45 85 190 NAND2X1 $T=933120 444045 0 180 $X=929890 $Y=439490
X726 111 32314 45 85 31978 NAND2X1 $T=930320 483245 0 0 $X=929890 $Y=482855
X727 32372 104 45 85 32157 NAND2X1 $T=935360 436205 0 180 $X=932130 $Y=431650
X728 113 192 45 85 32271 NAND2X1 $T=935360 467565 0 180 $X=932130 $Y=463010
X729 32394 132 45 85 32263 NAND2X1 $T=935920 412685 1 180 $X=932690 $Y=412295
X730 32439 110 45 85 32410 NAND2X1 $T=938160 428365 1 180 $X=934930 $Y=427975
X731 126 193 45 85 32562 NAND2X1 $T=939840 436205 0 0 $X=939410 $Y=435815
X732 201 119 45 85 32642 NAND2X1 $T=946000 475405 1 180 $X=942770 $Y=475015
X733 113 172 45 85 204 NAND2X1 $T=943200 483245 0 0 $X=942770 $Y=482855
X734 32692 104 45 85 32549 NAND2X1 $T=947680 420525 1 180 $X=944450 $Y=420135
X735 122 32172 45 85 32742 NAND2X1 $T=946560 451885 1 0 $X=946130 $Y=447330
X736 208 32172 45 85 209 NAND2X1 $T=951600 467565 1 180 $X=948370 $Y=467175
X737 213 31894 45 85 32875 NAND2X1 $T=953280 436205 0 180 $X=950050 $Y=431650
X738 208 206 45 85 32895 NAND2X1 $T=953840 467565 0 180 $X=950610 $Y=463010
X739 32776 130 45 85 32967 NAND2X1 $T=953280 412685 0 0 $X=952850 $Y=412295
X740 217 136 45 85 32921 NAND2X1 $T=956080 436205 0 180 $X=952850 $Y=431650
X741 121 32533 45 85 32964 NAND2X1 $T=953280 475405 0 0 $X=952850 $Y=475015
X742 122 211 45 85 32927 NAND2X1 $T=957200 451885 0 180 $X=953970 $Y=447330
X743 33035 32964 45 85 33051 NAND2X1 $T=958880 475405 1 180 $X=955650 $Y=475015
X744 141 220 45 85 33106 NAND2X1 $T=957760 428365 1 0 $X=957330 $Y=423810
X745 221 142 45 85 32947 NAND2X1 $T=961120 483245 1 180 $X=957890 $Y=482855
X746 31581 228 45 85 33237 NAND2X1 $T=962240 436205 0 0 $X=961810 $Y=435815
X747 33285 33252 45 85 33016 NAND2X1 $T=966160 444045 1 180 $X=962930 $Y=443655
X748 112 228 45 85 33322 NAND2X1 $T=967840 436205 1 180 $X=964610 $Y=435815
X749 33404 33377 45 85 31948 NAND2X1 $T=968400 444045 1 0 $X=967970 $Y=439490
X750 33352 33442 45 85 230 NAND2X1 $T=968960 483245 0 0 $X=968530 $Y=482855
X751 33435 33442 45 85 33321 NAND2X1 $T=969520 467565 1 0 $X=969090 $Y=463010
X752 110 223 45 85 33537 NAND2X1 $T=975680 436205 0 180 $X=972450 $Y=431650
X753 33374 234 45 85 33135 NAND2X1 $T=973440 428365 1 0 $X=973010 $Y=423810
X754 110 32533 45 85 33556 NAND2X1 $T=976240 451885 0 180 $X=973010 $Y=447330
X755 34024 33236 45 85 229 NAND2X1 $T=994160 475405 1 0 $X=993730 $Y=470850
X756 34372 228 45 85 34495 NAND2X1 $T=1002000 451885 0 0 $X=1001570 $Y=451495
X757 34256 33340 45 85 241 NAND2X1 $T=1005360 420525 0 180 $X=1002130 $Y=415970
X758 246 33236 45 85 34693 NAND2X1 $T=1012080 420525 1 180 $X=1008850 $Y=420135
X759 247 33236 45 85 34694 NAND2X1 $T=1012080 483245 1 180 $X=1008850 $Y=482855
X760 248 225 45 85 34749 NAND2X1 $T=1013760 420525 0 180 $X=1010530 $Y=415970
X761 246 225 45 85 34796 NAND2X1 $T=1015440 436205 0 180 $X=1012210 $Y=431650
X762 158 34924 45 85 34809 NAND2X1 $T=1022160 475405 1 180 $X=1018930 $Y=475015
X763 34999 198 45 85 35032 NAND2X1 $T=1025520 444045 0 180 $X=1022290 $Y=439490
X764 126 260 45 85 34990 NAND2X1 $T=1023840 459725 0 0 $X=1023410 $Y=459335
X765 122 261 45 85 35033 NAND2X1 $T=1025520 467565 0 0 $X=1025090 $Y=467175
X766 143 262 45 85 35181 NAND2X1 $T=1025520 475405 0 0 $X=1025090 $Y=475015
X767 35261 35200 45 85 266 NAND2X1 $T=1030560 436205 1 180 $X=1027330 $Y=435815
X768 35262 35232 45 85 267 NAND2X1 $T=1030560 444045 0 180 $X=1027330 $Y=439490
X769 272 169 45 85 35306 NAND2X1 $T=1033920 467565 1 180 $X=1030690 $Y=467175
X770 35418 189 45 85 35361 NAND2X1 $T=1036160 404845 1 180 $X=1032930 $Y=404455
X771 35419 189 45 85 35362 NAND2X1 $T=1036160 412685 1 180 $X=1032930 $Y=412295
X772 34934 132 45 85 35403 NAND2X1 $T=1036160 436205 1 180 $X=1032930 $Y=435815
X773 35379 104 45 85 35404 NAND2X1 $T=1033360 444045 1 0 $X=1032930 $Y=439490
X774 35419 198 45 85 35321 NAND2X1 $T=1036720 412685 0 180 $X=1033490 $Y=408130
X775 277 217 45 85 35305 NAND2X1 $T=1037280 428365 0 180 $X=1034050 $Y=423810
X776 169 264 45 85 34851 NAND2X1 $T=1036720 483245 1 0 $X=1036290 $Y=478690
X777 35559 130 45 85 35543 NAND2X1 $T=1041200 412685 1 180 $X=1037970 $Y=412295
X778 35576 191 45 85 35512 NAND2X1 $T=1041760 436205 1 180 $X=1038530 $Y=435815
X779 261 214 45 85 35562 NAND2X1 $T=1041760 451885 1 180 $X=1038530 $Y=451495
X780 122 279 45 85 35595 NAND2X1 $T=1043440 475405 0 180 $X=1040210 $Y=470850
X781 35559 189 45 85 35639 NAND2X1 $T=1041760 404845 1 0 $X=1041330 $Y=400290
X782 113 274 45 85 35726 NAND2X1 $T=1047360 467565 1 180 $X=1044130 $Y=467175
X783 149 285 45 85 35805 NAND2X1 $T=1050160 444045 1 180 $X=1046930 $Y=443655
X784 34547 35573 45 85 35697 NAND2X1 $T=1050720 451885 0 180 $X=1047490 $Y=447330
X785 262 235 45 85 35766 NAND2X1 $T=1049600 428365 0 0 $X=1049170 $Y=427975
X786 149 292 45 85 35885 NAND2X1 $T=1050720 436205 0 0 $X=1050290 $Y=435815
X787 35929 35961 45 85 35904 NAND2X1 $T=1052400 428365 0 0 $X=1051970 $Y=427975
X788 35993 198 45 85 35974 NAND2X1 $T=1056320 404845 0 180 $X=1053090 $Y=400290
X789 143 277 45 85 35961 NAND2X1 $T=1056320 420525 1 180 $X=1053090 $Y=420135
X790 137 35883 45 85 35929 NAND2X1 $T=1053520 436205 0 0 $X=1053090 $Y=435815
X791 294 140 45 85 35882 NAND2X1 $T=1053520 444045 0 0 $X=1053090 $Y=443655
X792 35975 36010 45 85 36007 NAND2X1 $T=1054080 412685 1 0 $X=1053650 $Y=408130
X793 203 35883 45 85 298 NAND2X1 $T=1058000 483245 0 180 $X=1054770 $Y=478690
X794 137 292 45 85 36057 NAND2X1 $T=1059120 444045 0 180 $X=1055890 $Y=439490
X795 280 140 45 85 36114 NAND2X1 $T=1061360 420525 1 180 $X=1058130 $Y=420135
X796 143 294 45 85 36149 NAND2X1 $T=1062480 428365 1 180 $X=1059250 $Y=427975
X797 36257 189 45 85 36239 NAND2X1 $T=1066400 412685 0 180 $X=1063170 $Y=408130
X798 36257 198 45 85 36292 NAND2X1 $T=1067520 404845 0 180 $X=1064290 $Y=400290
X799 140 271 45 85 36319 NAND2X1 $T=1069760 451885 1 180 $X=1066530 $Y=451495
X800 106 309 45 85 36351 NAND2X1 $T=1066960 483245 0 0 $X=1066530 $Y=482855
X801 111 309 45 85 36275 NAND2X1 $T=1070320 483245 0 180 $X=1067090 $Y=478690
X802 140 275 45 85 36391 NAND2X1 $T=1070880 459725 0 180 $X=1067650 $Y=455170
X803 149 299 45 85 36362 NAND2X1 $T=1072560 467565 0 180 $X=1069330 $Y=463010
X804 36458 130 45 85 36404 NAND2X1 $T=1070880 451885 1 0 $X=1070450 $Y=447330
X805 235 315 45 85 36490 NAND2X1 $T=1071440 428365 0 0 $X=1071010 $Y=427975
X806 36458 110 45 85 36422 NAND2X1 $T=1074800 444045 0 180 $X=1071570 $Y=439490
X807 36568 110 45 85 36492 NAND2X1 $T=1076480 412685 1 180 $X=1073250 $Y=412295
X808 36459 191 45 85 36437 NAND2X1 $T=1077600 444045 0 180 $X=1074370 $Y=439490
X809 36601 316 45 85 36457 NAND2X1 $T=1077600 467565 0 180 $X=1074370 $Y=463010
X810 143 36509 45 85 36602 NAND2X1 $T=1078160 436205 0 180 $X=1074930 $Y=431650
X811 36601 36275 45 85 318 NAND2X1 $T=1078160 475405 0 180 $X=1074930 $Y=470850
X812 36630 36275 45 85 36509 NAND2X1 $T=1078720 467565 1 180 $X=1075490 $Y=467175
X813 36538 110 45 85 36592 NAND2X1 $T=1079280 412685 1 180 $X=1076050 $Y=412295
X814 36658 104 45 85 36382 NAND2X1 $T=1079840 444045 1 180 $X=1076610 $Y=443655
X815 319 36225 45 85 36111 NAND2X1 $T=1077040 483245 1 0 $X=1076610 $Y=478690
X816 169 318 45 85 36660 NAND2X1 $T=1080400 483245 1 180 $X=1077170 $Y=482855
X817 143 36457 45 85 36693 NAND2X1 $T=1081520 444045 0 180 $X=1078290 $Y=439490
X818 140 264 45 85 36753 NAND2X1 $T=1083760 451885 1 180 $X=1080530 $Y=451495
X819 137 320 45 85 36755 NAND2X1 $T=1083760 467565 1 180 $X=1080530 $Y=467175
X820 143 281 45 85 36766 NAND2X1 $T=1084320 420525 1 180 $X=1081090 $Y=420135
X821 137 285 45 85 36771 NAND2X1 $T=1084320 444045 0 180 $X=1081090 $Y=439490
X822 36840 130 45 85 34916 NAND2X1 $T=1086000 412685 0 180 $X=1082770 $Y=408130
X823 140 36036 45 85 36824 NAND2X1 $T=1086000 451885 0 180 $X=1082770 $Y=447330
X824 36692 132 45 85 36908 NAND2X1 $T=1086000 459725 1 0 $X=1085570 $Y=455170
X825 36692 130 45 85 36911 NAND2X1 $T=1086000 459725 0 0 $X=1085570 $Y=459335
X826 36658 132 45 85 36925 NAND2X1 $T=1091600 444045 0 180 $X=1088370 $Y=439490
X827 137 37039 45 85 325 NAND2X1 $T=1093840 467565 1 180 $X=1090610 $Y=467175
X828 149 310 45 85 330 NAND2X1 $T=1093840 483245 1 180 $X=1090610 $Y=482855
X829 149 332 45 85 37096 NAND2X1 $T=1092160 483245 1 0 $X=1091730 $Y=478690
X830 37096 37079 45 85 37154 NAND2X1 $T=1097200 459725 0 180 $X=1093970 $Y=455170
X831 37756 37895 45 85 37874 NAND2X1 $T=1115120 436205 1 0 $X=1114690 $Y=431650
X832 38794 38631 45 85 37895 NAND2X1 $T=1145360 436205 0 180 $X=1142130 $Y=431650
X833 38959 38997 45 85 38980 NAND2X1 $T=1149280 444045 0 0 $X=1148850 $Y=443655
X834 38941 339 45 85 39049 NAND2X1 $T=1151520 436205 0 0 $X=1151090 $Y=435815
X835 39291 39252 45 85 39272 NAND2X1 $T=1161600 451885 0 180 $X=1158370 $Y=447330
X836 38631 39360 45 85 39097 NAND2X1 $T=1161040 436205 0 0 $X=1160610 $Y=435815
X837 39372 39430 45 85 38959 NAND2X1 $T=1167200 436205 0 0 $X=1166770 $Y=435815
X838 39372 39558 45 85 39291 NAND2X1 $T=1167200 444045 1 0 $X=1166770 $Y=439490
X839 346 40340 45 85 40362 NAND2X1 $T=1195200 475405 1 180 $X=1191970 $Y=475015
X840 91 39734 45 85 40340 NAND2X1 $T=1192960 475405 1 0 $X=1192530 $Y=470850
X841 91 347 45 85 40619 NAND2X1 $T=1203600 475405 1 180 $X=1200370 $Y=475015
X842 40507 40619 45 85 40635 NAND2X1 $T=1204160 475405 0 180 $X=1200930 $Y=470850
X843 41076 348 45 85 41188 NAND2X1 $T=1219280 467565 1 0 $X=1218850 $Y=463010
X844 41364 348 45 85 40930 NAND2X1 $T=1227680 459725 1 180 $X=1224450 $Y=459335
X845 41508 40930 45 85 41510 NAND2X1 $T=1232720 459725 1 180 $X=1229490 $Y=459335
X846 41188 41027 45 85 41508 NAND2X1 $T=1229920 467565 1 0 $X=1229490 $Y=463010
X847 41454 41027 45 85 41385 NAND2X1 $T=1229920 475405 1 0 $X=1229490 $Y=470850
X1003 45 85 30757 30802 102 ICV_68 $T=877680 467565 1 0 $X=877250 $Y=463010
X1004 45 85 113 118 31035 ICV_68 $T=892240 459725 0 0 $X=891810 $Y=459335
X1005 45 85 121 124 31045 ICV_68 $T=896160 451885 0 0 $X=895730 $Y=451495
X1006 45 85 31769 191 32280 ICV_68 $T=928640 475405 1 0 $X=928210 $Y=470850
X1007 45 85 32439 104 32550 ICV_68 $T=938160 428365 0 0 $X=937730 $Y=427975
X1008 45 85 211 214 32849 ICV_68 $T=949360 451885 1 0 $X=948930 $Y=447330
X1009 45 85 171 33236 33218 ICV_68 $T=960560 428365 1 0 $X=960130 $Y=423810
X1010 45 85 33270 33304 32643 ICV_68 $T=962800 451885 0 0 $X=962370 $Y=451495
X1011 45 85 176 225 33397 ICV_68 $T=967840 420525 1 0 $X=967410 $Y=415970
X1012 45 85 35119 189 35183 ICV_68 $T=1024400 428365 1 0 $X=1023970 $Y=423810
X1013 45 85 35418 130 35511 ICV_68 $T=1036160 404845 0 0 $X=1035730 $Y=404455
X1014 45 85 33166 282 35633 ICV_68 $T=1040640 483245 0 0 $X=1040210 $Y=482855
X1015 45 85 277 238 35662 ICV_68 $T=1041200 428365 1 0 $X=1040770 $Y=423810
X1016 45 85 286 34547 35822 ICV_68 $T=1046800 451885 0 0 $X=1046370 $Y=451495
X1017 45 85 297 35964 274 ICV_68 $T=1058000 483245 1 0 $X=1057570 $Y=478690
X1018 45 85 36420 104 36556 ICV_68 $T=1072560 420525 1 0 $X=1072130 $Y=415970
X1019 45 85 158 247 36791 ICV_68 $T=1080400 483245 0 0 $X=1079970 $Y=482855
X1020 45 30894 30874 103 85 ICV_69 $T=881040 436205 0 0 $X=880610 $Y=435815
X1021 45 30953 110 31116 85 ICV_69 $T=887200 459725 1 0 $X=886770 $Y=455170
X1022 45 31440 132 31351 85 ICV_69 $T=898960 420525 0 0 $X=898530 $Y=420135
X1023 45 31473 132 31379 85 ICV_69 $T=900080 428365 0 0 $X=899650 $Y=427975
X1024 45 137 145 31616 85 ICV_69 $T=904560 475405 0 0 $X=904130 $Y=475015
X1025 45 31487 132 31834 85 ICV_69 $T=912960 428365 1 0 $X=912530 $Y=423810
X1026 45 31135 183 182 85 ICV_69 $T=924160 483245 1 0 $X=923730 $Y=478690
X1027 45 185 31197 187 85 ICV_69 $T=926960 475405 0 0 $X=926530 $Y=475015
X1028 45 106 32314 196 85 ICV_69 $T=933120 483245 0 0 $X=932690 $Y=482855
X1029 45 113 195 32450 85 ICV_69 $T=934800 451885 1 0 $X=934370 $Y=447330
X1030 45 31767 189 32691 85 ICV_69 $T=942640 404845 0 0 $X=942210 $Y=404455
X1031 45 32309 189 32807 85 ICV_69 $T=947120 412685 1 0 $X=946690 $Y=408130
X1032 45 33085 108 33105 85 ICV_69 $T=956080 420525 1 0 $X=955650 $Y=415970
X1033 45 126 223 32973 85 ICV_69 $T=957200 444045 1 0 $X=956770 $Y=439490
X1034 45 104 223 33435 85 ICV_69 $T=967280 459725 0 0 $X=966850 $Y=459335
X1035 45 104 32533 33434 85 ICV_69 $T=967840 451885 1 0 $X=967410 $Y=447330
X1036 45 33434 33442 33270 85 ICV_69 $T=967840 459725 1 0 $X=967410 $Y=455170
X1037 45 33537 232 33404 85 ICV_69 $T=971200 444045 1 0 $X=970770 $Y=439490
X1038 45 34372 220 34547 85 ICV_69 $T=1002560 444045 0 0 $X=1002130 $Y=443655
X1039 45 34664 34796 34816 85 ICV_69 $T=1010960 428365 0 0 $X=1010530 $Y=427975
X1040 45 158 253 34953 85 ICV_69 $T=1015440 459725 0 0 $X=1015010 $Y=459335
X1041 45 143 264 35069 85 ICV_69 $T=1024400 475405 1 0 $X=1023970 $Y=470850
X1042 45 35119 130 35229 85 ICV_69 $T=1024960 420525 1 0 $X=1024530 $Y=415970
X1043 45 214 270 35283 85 ICV_69 $T=1026640 451885 0 0 $X=1026210 $Y=451495
X1044 45 208 274 35281 85 ICV_69 $T=1029440 467565 1 0 $X=1029010 $Y=463010
X1045 45 246 238 35402 85 ICV_69 $T=1031680 420525 0 0 $X=1031250 $Y=420135
X1046 45 217 35481 35322 85 ICV_69 $T=1033920 436205 1 0 $X=1033490 $Y=431650
X1047 45 290 291 35883 85 ICV_69 $T=1048480 475405 0 0 $X=1048050 $Y=475015
X1048 45 34547 35962 35946 85 ICV_69 $T=1050720 451885 0 0 $X=1050290 $Y=451495
X1049 45 113 35820 35839 85 ICV_69 $T=1050720 483245 0 0 $X=1050290 $Y=482855
X1050 45 304 36275 296 85 ICV_69 $T=1061920 475405 0 0 $X=1061490 $Y=475015
X1051 45 313 36351 310 85 ICV_69 $T=1069760 483245 0 0 $X=1069330 $Y=482855
X1052 45 36824 329 35930 85 ICV_69 $T=1086560 444045 0 0 $X=1086130 $Y=443655
X1053 45 149 37039 329 85 ICV_69 $T=1088240 467565 1 0 $X=1087810 $Y=463010
X1054 45 37154 191 36600 85 ICV_69 $T=1092720 428365 0 0 $X=1092290 $Y=427975
X1055 45 111 37253 312 85 ICV_69 $T=1094400 475405 0 0 $X=1093970 $Y=475015
X1056 45 106 37385 36601 85 ICV_69 $T=1100000 475405 1 0 $X=1099570 $Y=470850
X1057 30854 30895 45 85 30874 NOR2X1 $T=881600 444045 0 0 $X=881170 $Y=443655
X1058 30875 30917 45 85 30802 NOR2X1 $T=882160 467565 1 0 $X=881730 $Y=463010
X1059 31250 31115 45 85 31228 NOR2X1 $T=895600 475405 0 180 $X=892370 $Y=470850
X1060 31247 31281 45 85 31253 NOR2X1 $T=893920 444045 0 0 $X=893490 $Y=443655
X1061 31299 31331 45 85 31237 NOR2X1 $T=895600 412685 1 0 $X=895170 $Y=408130
X1062 31300 31332 45 85 31087 NOR2X1 $T=895600 436205 0 0 $X=895170 $Y=435815
X1063 31352 31378 45 85 31217 NOR2X1 $T=897280 428365 0 0 $X=896850 $Y=427975
X1064 31424 31457 45 85 31206 NOR2X1 $T=900080 428365 1 0 $X=899650 $Y=423810
X1065 31848 31877 45 85 31313 NOR2X1 $T=915200 428365 0 0 $X=914770 $Y=427975
X1066 31990 32156 45 85 32140 NOR2X1 $T=924720 436205 1 0 $X=924290 $Y=431650
X1067 32155 31896 45 85 32218 NOR2X1 $T=926960 420525 0 0 $X=926530 $Y=420135
X1068 32220 31441 45 85 32219 NOR2X1 $T=930320 444045 1 180 $X=927090 $Y=443655
X1069 108 32218 45 85 32279 NOR2X1 $T=932560 428365 0 180 $X=929330 $Y=423810
X1070 31932 32357 45 85 32423 NOR2X1 $T=934800 459725 1 0 $X=934370 $Y=455170
X1071 32295 32374 45 85 32396 NOR2X1 $T=935360 467565 1 0 $X=934930 $Y=463010
X1072 32440 32474 45 85 31252 NOR2X1 $T=935920 444045 1 0 $X=935490 $Y=439490
X1073 32491 32279 45 85 199 NOR2X1 $T=939280 428365 0 180 $X=936050 $Y=423810
X1074 32492 32458 45 85 200 NOR2X1 $T=937600 459725 1 0 $X=937170 $Y=455170
X1075 191 32423 45 85 32584 NOR2X1 $T=943200 459725 0 180 $X=939970 $Y=455170
X1076 32578 32660 45 85 32708 NOR2X1 $T=944320 459725 0 0 $X=943890 $Y=459335
X1077 32733 32584 45 85 212 NOR2X1 $T=949360 459725 0 0 $X=948930 $Y=459335
X1078 33051 32829 45 85 33119 NOR2X1 $T=957760 475405 1 0 $X=957330 $Y=470850
X1079 33233 33271 45 85 32475 NOR2X1 $T=962800 475405 1 0 $X=962370 $Y=470850
X1080 191 34003 45 85 104 NOR2X1 $T=985200 444045 0 0 $X=984770 $Y=443655
X1081 108 34003 45 85 198 NOR2X1 $T=994720 451885 0 180 $X=991490 $Y=447330
X1082 34256 134 45 85 228 NOR2X1 $T=996400 420525 1 180 $X=993170 $Y=420135
X1083 34256 34167 45 85 110 NOR2X1 $T=996400 436205 0 180 $X=993170 $Y=431650
X1084 34257 191 45 85 34024 NOR2X1 $T=996400 436205 1 180 $X=993170 $Y=435815
X1085 134 34003 45 85 158 NOR2X1 $T=993600 459725 1 0 $X=993170 $Y=455170
X1086 108 33340 45 85 234 NOR2X1 $T=995280 428365 1 0 $X=994850 $Y=423810
X1087 108 34257 45 85 237 NOR2X1 $T=998080 444045 1 180 $X=994850 $Y=443655
X1088 34257 34256 45 85 132 NOR2X1 $T=996400 420525 0 0 $X=995970 $Y=420135
X1089 34433 134 45 85 225 NOR2X1 $T=1002560 420525 0 180 $X=999330 $Y=415970
X1090 34433 33340 45 85 130 NOR2X1 $T=1003120 412685 0 180 $X=999890 $Y=408130
X1091 139 34433 45 85 33236 NOR2X1 $T=1000320 420525 0 0 $X=999890 $Y=420135
X1092 139 34256 45 85 220 NOR2X1 $T=1003120 428365 1 180 $X=999890 $Y=427975
X1093 34256 33340 45 85 236 NOR2X1 $T=1000320 436205 1 0 $X=999890 $Y=431650
X1094 191 33340 45 85 34372 NOR2X1 $T=1000320 444045 1 0 $X=999890 $Y=439490
X1095 139 34003 45 85 169 NOR2X1 $T=1003120 459725 1 180 $X=999890 $Y=459335
X1096 139 241 45 85 137 NOR2X1 $T=1009280 436205 0 180 $X=1006050 $Y=431650
X1097 34970 35000 45 85 34923 NOR2X1 $T=1018800 451885 0 0 $X=1018370 $Y=451495
X1098 35132 35213 45 85 35200 NOR2X1 $T=1026080 428365 0 0 $X=1025650 $Y=427975
X1099 35245 35280 45 85 268 NOR2X1 $T=1028320 412685 0 0 $X=1027890 $Y=412295
X1100 35103 35282 45 85 35232 NOR2X1 $T=1030560 444045 1 0 $X=1030130 $Y=439490
X1101 35513 35544 45 85 278 NOR2X1 $T=1037840 483245 0 0 $X=1037410 $Y=482855
X1102 35823 35853 45 85 287 NOR2X1 $T=1048480 467565 0 0 $X=1048050 $Y=467175
X1103 35738 35725 45 85 35857 NOR2X1 $T=1049040 404845 0 0 $X=1048610 $Y=404455
X1104 35915 35857 45 85 35853 NOR2X1 $T=1053520 412685 1 180 $X=1050290 $Y=412295
X1105 35930 35904 45 85 35660 NOR2X1 $T=1054080 436205 0 180 $X=1050850 $Y=431650
X1106 191 36113 45 85 35280 NOR2X1 $T=1058000 420525 1 0 $X=1057570 $Y=415970
X1107 36175 36211 45 85 35812 NOR2X1 $T=1061360 444045 1 0 $X=1060930 $Y=439490
X1108 36147 35560 45 85 36221 NOR2X1 $T=1062480 428365 1 0 $X=1062050 $Y=423810
X1109 36293 36258 45 85 306 NOR2X1 $T=1066960 444045 0 180 $X=1063730 $Y=439490
X1110 108 36221 45 85 36258 NOR2X1 $T=1068640 428365 0 180 $X=1065410 $Y=423810
X1111 36174 36367 45 85 308 NOR2X1 $T=1066960 404845 0 0 $X=1066530 $Y=404455
X1112 36259 36421 45 85 311 NOR2X1 $T=1069760 467565 0 0 $X=1069330 $Y=467175
X1113 36723 36856 45 85 35811 NOR2X1 $T=1083760 436205 0 0 $X=1083330 $Y=435815
X1114 36618 36273 45 85 36874 NOR2X1 $T=1084320 420525 0 0 $X=1083890 $Y=420135
X1115 36790 36841 45 85 36113 NOR2X1 $T=1086000 412685 0 0 $X=1085570 $Y=412295
X1116 36909 36926 45 85 326 NOR2X1 $T=1087120 475405 0 0 $X=1086690 $Y=475015
X1117 37274 37305 45 85 34609 NOR2X1 $T=1097760 420525 1 0 $X=1097330 $Y=415970
X1118 134 37421 45 85 37274 NOR2X1 $T=1101120 420525 0 0 $X=1100690 $Y=420135
X1119 37458 37421 45 85 240 NOR2X1 $T=1121840 436205 0 180 $X=1118610 $Y=431650
X1120 38599 38563 45 85 36840 NOR2X1 $T=1138640 420525 1 180 $X=1135410 $Y=420135
X1121 37458 37749 45 85 38631 NOR2X1 $T=1137520 436205 0 0 $X=1137090 $Y=435815
X1122 108 38631 45 85 39153 NOR2X1 $T=1154880 436205 1 0 $X=1154450 $Y=431650
X1123 39487 39167 45 85 39285 NOR2X1 $T=1167760 436205 0 180 $X=1164530 $Y=431650
X1124 39487 39360 45 85 38906 NOR2X1 $T=1184560 436205 1 180 $X=1181330 $Y=435815
X1125 40281 40239 45 85 40262 NOR2X1 $T=1192400 436205 0 180 $X=1189170 $Y=431650
X1126 39360 40301 45 85 40239 NOR2X1 $T=1190160 444045 1 0 $X=1189730 $Y=439490
X1127 39487 40449 45 85 40433 NOR2X1 $T=1194640 436205 0 0 $X=1194210 $Y=435815
X1128 40281 40433 45 85 40586 NOR2X1 $T=1202480 436205 1 180 $X=1199250 $Y=435815
X1129 41235 40930 45 85 41171 NOR2X1 $T=1223200 459725 0 180 $X=1219970 $Y=455170
X1130 45 85 30953 104 30993 ICV_81 $T=882160 459725 1 0 $X=881730 $Y=455170
X1131 45 85 121 31476 31460 ICV_81 $T=898400 467565 0 0 $X=897970 $Y=467175
X1132 45 85 121 193 32236 ICV_81 $T=929760 451885 1 0 $X=929330 $Y=447330
X1133 45 85 31767 198 32393 ICV_81 $T=935920 404845 1 0 $X=935490 $Y=400290
X1134 45 85 32681 32810 32829 ICV_81 $T=946560 475405 1 0 $X=946130 $Y=470850
X1135 45 85 164 213 32874 ICV_81 $T=947680 420525 0 0 $X=947250 $Y=420135
X1136 45 85 205 220 33118 ICV_81 $T=956080 436205 1 0 $X=955650 $Y=431650
X1137 45 85 184 33236 33251 ICV_81 $T=960000 428365 0 0 $X=959570 $Y=427975
X1138 45 85 33556 232 33285 ICV_81 $T=971200 444045 0 0 $X=970770 $Y=443655
X1139 45 85 34610 139 35035 ICV_81 $T=1018240 412685 0 0 $X=1017810 $Y=412295
X1140 45 85 214 259 35110 ICV_81 $T=1021600 451885 0 0 $X=1021170 $Y=451495
X1141 45 85 290 35964 34611 ICV_81 $T=1050160 483245 1 0 $X=1049730 $Y=478690
X1142 45 85 35387 104 36308 ICV_81 $T=1062480 428365 0 0 $X=1062050 $Y=427975
X1143 45 85 36420 110 36403 ICV_81 $T=1067520 420525 1 0 $X=1067090 $Y=415970
X1144 45 85 149 320 36724 ICV_81 $T=1077600 467565 1 0 $X=1077170 $Y=463010
X1145 45 85 106 37253 36630 ICV_81 $T=1093840 467565 0 0 $X=1093410 $Y=467175
X1146 45 85 111 333 36225 ICV_81 $T=1093840 483245 0 0 $X=1093410 $Y=482855
X1147 45 85 37512 37737 37719 ICV_81 $T=1108400 451885 0 0 $X=1107970 $Y=451495
X1148 45 85 38906 40607 40587 ICV_81 $T=1197440 444045 1 0 $X=1197010 $Y=439490
X1149 45 85 40731 40766 40281 ICV_81 $T=1202480 436205 0 0 $X=1202050 $Y=435815
X1150 45 85 30952 104 30951 ICV_76 $T=883840 451885 1 0 $X=883410 $Y=447330
X1151 45 85 31205 31252 114 ICV_76 $T=892240 436205 0 0 $X=891810 $Y=435815
X1152 45 85 122 128 31268 ICV_76 $T=897280 483245 0 0 $X=896850 $Y=482855
X1153 45 85 121 129 31077 ICV_76 $T=898400 467565 1 0 $X=897970 $Y=463010
X1154 45 85 31440 130 31456 ICV_76 $T=900640 412685 1 0 $X=900210 $Y=408130
X1155 45 85 143 150 31611 ICV_76 $T=909600 412685 1 0 $X=909170 $Y=408130
X1156 45 85 165 170 31581 ICV_76 $T=919680 475405 1 0 $X=919250 $Y=470850
X1157 45 85 152 119 172 ICV_76 $T=920800 483245 1 0 $X=920370 $Y=478690
X1158 45 85 126 180 32139 ICV_76 $T=924160 444045 0 0 $X=923730 $Y=443655
X1159 45 85 32092 130 32138 ICV_76 $T=924720 412685 1 0 $X=924290 $Y=408130
X1160 45 85 32092 189 32249 ICV_76 $T=928080 404845 1 0 $X=927650 $Y=400290
X1161 45 85 32394 198 32438 ICV_76 $T=934800 412685 1 0 $X=934370 $Y=408130
X1162 45 85 31913 191 32395 ICV_76 $T=934800 451885 0 0 $X=934370 $Y=451495
X1163 45 85 32372 110 32517 ICV_76 $T=941520 420525 0 0 $X=941090 $Y=420135
X1164 45 85 121 173 32678 ICV_76 $T=943200 451885 0 0 $X=942770 $Y=451495
X1165 45 85 214 216 32884 ICV_76 $T=951600 459725 1 0 $X=951170 $Y=455170
X1166 45 85 180 225 33204 ICV_76 $T=960560 420525 1 0 $X=960130 $Y=415970
X1167 45 85 33166 31508 33238 ICV_76 $T=961680 467565 1 0 $X=961250 $Y=463010
X1168 45 85 33302 33340 33170 ICV_76 $T=964480 412685 1 0 $X=964050 $Y=408130
X1169 45 85 229 33378 33007 ICV_76 $T=967840 475405 1 0 $X=967410 $Y=470850
X1170 45 85 220 34024 232 ICV_76 $T=985200 459725 0 0 $X=984770 $Y=459335
X1171 45 85 34255 34304 34291 ICV_76 $T=994720 404845 1 0 $X=994290 $Y=400290
X1172 45 85 240 238 34834 ICV_76 $T=1014880 412685 0 0 $X=1014450 $Y=412295
X1173 45 85 34835 234 34917 ICV_76 $T=1016000 420525 0 0 $X=1015570 $Y=420135
X1174 45 85 34836 234 35001 ICV_76 $T=1018240 483245 0 0 $X=1017810 $Y=482855
X1175 45 85 34999 189 34969 ICV_76 $T=1019360 444045 1 0 $X=1018930 $Y=439490
X1176 45 85 213 256 35084 ICV_76 $T=1021040 428365 1 0 $X=1020610 $Y=423810
X1177 45 85 137 258 35037 ICV_76 $T=1022160 475405 0 0 $X=1021730 $Y=475015
X1178 45 85 121 253 35561 ICV_76 $T=1037840 444045 0 0 $X=1037410 $Y=443655
X1179 45 85 149 279 35534 ICV_76 $T=1038400 436205 1 0 $X=1037970 $Y=431650
X1180 45 85 34464 283 35675 ICV_76 $T=1043440 475405 1 0 $X=1043010 $Y=470850
X1181 45 85 137 296 35976 ICV_76 $T=1052960 444045 1 0 $X=1052530 $Y=439490
X1182 45 85 35993 189 36129 ICV_76 $T=1058560 404845 1 0 $X=1058130 $Y=400290
X1183 45 85 126 36509 36228 ICV_76 $T=1070880 475405 1 0 $X=1070450 $Y=470850
X1184 45 85 36601 331 37039 ICV_76 $T=1089920 475405 1 0 $X=1089490 $Y=470850
X1185 45 85 111 37385 35964 ICV_76 $T=1099440 467565 1 0 $X=1099010 $Y=463010
X1186 45 85 90 347 40303 ICV_76 $T=1195760 475405 1 0 $X=1195330 $Y=470850
X1187 45 85 40480 40639 40607 ICV_76 $T=1200240 451885 0 0 $X=1199810 $Y=451495
X1188 45 85 40639 40961 41076 ICV_76 $T=1214800 459725 0 0 $X=1214370 $Y=459335
X1189 30951 31003 31045 45 85 30895 NAND3X1 $T=884400 444045 0 0 $X=883970 $Y=443655
X1190 30993 31035 31077 45 85 30875 NAND3X1 $T=885520 459725 0 0 $X=885090 $Y=459335
X1191 31132 31088 31046 45 85 30917 NAND3X1 $T=891680 467565 1 180 $X=887330 $Y=467175
X1192 31248 31293 31333 45 85 31247 NAND3X1 $T=893920 451885 1 0 $X=893490 $Y=447330
X1193 31334 31228 31249 45 85 117 NAND3X1 $T=898400 467565 1 180 $X=894050 $Y=467175
X1194 31351 120 116 45 85 31299 NAND3X1 $T=898960 420525 0 180 $X=894610 $Y=415970
X1195 31379 31417 31458 45 85 31300 NAND3X1 $T=898400 436205 0 0 $X=897970 $Y=435815
X1196 31380 31418 31459 45 85 31441 NAND3X1 $T=898400 444045 0 0 $X=897970 $Y=443655
X1197 31456 31416 31377 45 85 31378 NAND3X1 $T=902880 412685 1 180 $X=898530 $Y=412295
X1198 31570 31528 31488 45 85 31352 NAND3X1 $T=906800 444045 1 180 $X=902450 $Y=443655
X1199 31472 31611 31569 45 85 31331 NAND3X1 $T=909600 412685 0 180 $X=905250 $Y=408130
X1200 31710 31718 31584 45 85 31424 NAND3X1 $T=913520 420525 1 180 $X=909170 $Y=420135
X1201 31645 151 31756 45 85 31769 NAND3X1 $T=910160 475405 1 0 $X=909730 $Y=470850
X1202 31755 160 31895 45 85 31332 NAND3X1 $T=914080 436205 1 0 $X=913650 $Y=431650
X1203 31834 155 31901 45 85 31896 NAND3X1 $T=914640 436205 0 0 $X=914210 $Y=435815
X1204 31912 31768 31833 45 85 31877 NAND3X1 $T=919120 420525 0 180 $X=914770 $Y=415970
X1205 31784 161 31950 45 85 31932 NAND3X1 $T=915760 459725 0 0 $X=915330 $Y=459335
X1206 31948 31906 31859 45 85 31281 NAND3X1 $T=920240 444045 0 180 $X=915890 $Y=439490
X1207 31949 156 31805 45 85 31913 NAND3X1 $T=920240 451885 1 180 $X=915890 $Y=451495
X1208 31679 31991 32029 45 85 31848 NAND3X1 $T=918560 436205 0 0 $X=918130 $Y=435815
X1209 31966 32009 31788 45 85 31990 NAND3X1 $T=919120 428365 0 0 $X=918690 $Y=427975
X1210 32109 177 174 45 85 32062 NAND3X1 $T=926400 467565 0 180 $X=922050 $Y=463010
X1211 32138 32103 32061 45 85 31457 NAND3X1 $T=926960 428365 1 180 $X=922610 $Y=427975
X1212 32192 32137 32016 45 85 32155 NAND3X1 $T=928640 404845 1 180 $X=924290 $Y=404455
X1213 32157 31835 32236 45 85 32220 NAND3X1 $T=925840 451885 1 0 $X=925410 $Y=447330
X1214 32263 32122 32193 45 85 32156 NAND3X1 $T=931440 420525 0 180 $X=927090 $Y=415970
X1215 31546 32271 32139 45 85 32295 NAND3X1 $T=928640 467565 1 0 $X=928210 $Y=463010
X1216 31707 167 32373 45 85 32357 NAND3X1 $T=930880 459725 1 0 $X=930450 $Y=455170
X1217 32395 32432 32471 45 85 32458 NAND3X1 $T=934240 420525 0 0 $X=933810 $Y=420135
X1218 32396 32280 32475 45 85 197 NAND3X1 $T=934240 475405 1 0 $X=933810 $Y=470850
X1219 32410 32450 32294 45 85 32474 NAND3X1 $T=934800 444045 0 0 $X=934370 $Y=443655
X1220 203 32594 32547 45 85 31249 NAND3X1 $T=944320 467565 1 180 $X=939970 $Y=467175
X1221 32643 32562 32563 45 85 32440 NAND3X1 $T=944880 444045 0 180 $X=940530 $Y=439490
X1222 32691 32689 32566 45 85 32660 NAND3X1 $T=947680 412685 1 180 $X=943330 $Y=412295
X1223 32777 32734 32678 45 85 32492 NAND3X1 $T=949360 459725 0 180 $X=945010 $Y=455170
X1224 32822 32550 32741 45 85 32491 NAND3X1 $T=951040 428365 0 180 $X=946690 $Y=423810
X1225 32826 32743 32742 45 85 32800 NAND3X1 $T=951040 444045 0 180 $X=946690 $Y=439490
X1226 32807 32849 32874 45 85 32873 NAND3X1 $T=948800 420525 1 0 $X=948370 $Y=415970
X1227 32677 32884 32895 45 85 32761 NAND3X1 $T=949920 451885 0 0 $X=949490 $Y=451495
X1228 32885 32921 32875 45 85 32808 NAND3X1 $T=955520 436205 1 180 $X=951170 $Y=435815
X1229 33016 32973 32927 45 85 30854 NAND3X1 $T=957200 444045 0 180 $X=952850 $Y=439490
X1230 203 33007 33031 45 85 32826 NAND3X1 $T=953840 467565 0 0 $X=953410 $Y=467175
X1231 33139 33094 33050 45 85 32777 NAND3X1 $T=961120 459725 0 180 $X=956770 $Y=455170
X1232 32708 33119 33171 45 85 222 NAND3X1 $T=957760 467565 0 0 $X=957330 $Y=467175
X1233 33170 32967 32390 45 85 33085 NAND3X1 $T=962240 412685 0 180 $X=957890 $Y=408130
X1234 33105 33135 32992 45 85 219 NAND3X1 $T=962240 420525 1 180 $X=957890 $Y=420135
X1235 224 33238 33303 45 85 33271 NAND3X1 $T=962240 475405 0 0 $X=961810 $Y=475015
X1236 33204 33298 33251 45 85 33302 NAND3X1 $T=967840 420525 0 180 $X=963490 $Y=415970
X1237 33342 33397 33218 45 85 33374 NAND3X1 $T=971200 420525 1 180 $X=966850 $Y=420135
X1238 240 134 34257 45 85 34255 NAND3X1 $T=993600 412685 0 0 $X=993170 $Y=412295
X1239 34645 34612 34433 45 85 34582 NAND3X1 $T=1009840 428365 0 180 $X=1005490 $Y=423810
X1240 203 34756 34781 45 85 34797 NAND3X1 $T=1010960 467565 0 0 $X=1010530 $Y=467175
X1241 34582 34693 34749 45 85 34835 NAND3X1 $T=1012080 420525 0 0 $X=1011650 $Y=420135
X1242 249 34694 251 45 85 34836 NAND3X1 $T=1012080 483245 0 0 $X=1011650 $Y=482855
X1243 34851 34809 108 45 85 250 NAND3X1 $T=1016560 475405 1 180 $X=1012210 $Y=475015
X1244 34834 34711 34916 45 85 34897 NAND3X1 $T=1014320 404845 0 0 $X=1013890 $Y=404455
X1245 34882 34898 34969 45 85 252 NAND3X1 $T=1016000 444045 0 0 $X=1015570 $Y=443655
X1246 34797 34990 35033 45 85 254 NAND3X1 $T=1018240 467565 0 0 $X=1017810 $Y=467175
X1247 35068 35025 34953 45 85 34970 NAND3X1 $T=1023840 459725 1 180 $X=1019490 $Y=459335
X1248 35032 35036 35085 45 85 35103 NAND3X1 $T=1021040 436205 0 0 $X=1020610 $Y=435815
X1249 34933 35110 35084 45 85 35132 NAND3X1 $T=1022160 428365 0 0 $X=1021730 $Y=427975
X1250 35263 265 35180 45 85 35000 NAND3X1 $T=1030560 459725 0 180 $X=1026210 $Y=455170
X1251 35183 35233 35283 45 85 35282 NAND3X1 $T=1027200 451885 1 0 $X=1026770 $Y=447330
X1252 35269 35321 35361 45 85 35245 NAND3X1 $T=1029440 404845 0 0 $X=1029010 $Y=404455
X1253 35345 35305 35260 45 85 35291 NAND3X1 $T=1033360 428365 1 180 $X=1029010 $Y=427975
X1254 35346 35306 35181 45 85 269 NAND3X1 $T=1033360 475405 1 180 $X=1029010 $Y=475015
X1255 239 35259 273 45 85 35345 NAND3X1 $T=1029440 483245 0 0 $X=1029010 $Y=482855
X1256 35362 35322 35281 45 85 35213 NAND3X1 $T=1033920 436205 0 180 $X=1029570 $Y=431650
X1257 203 35440 35478 45 85 35464 NAND3X1 $T=1033920 467565 0 0 $X=1033490 $Y=467175
X1258 35229 35534 35402 45 85 35560 NAND3X1 $T=1037280 428365 1 0 $X=1036850 $Y=423810
X1259 35512 35404 35561 45 85 35577 NAND3X1 $T=1037840 444045 1 0 $X=1037410 $Y=439490
X1260 35543 35403 35660 45 85 35576 NAND3X1 $T=1040080 428365 0 0 $X=1039650 $Y=427975
X1261 35494 35632 104 45 85 35661 NAND3X1 $T=1040640 459725 0 0 $X=1040210 $Y=459335
X1262 35595 35633 35675 45 85 35513 NAND3X1 $T=1040640 475405 0 0 $X=1040210 $Y=475015
X1263 35659 35511 35737 45 85 35725 NAND3X1 $T=1042880 412685 1 0 $X=1042450 $Y=408130
X1264 33139 35697 35739 45 85 35714 NAND3X1 $T=1042880 451885 0 0 $X=1042450 $Y=451495
X1265 35674 35714 35726 45 85 35702 NAND3X1 $T=1043440 444045 0 0 $X=1043010 $Y=443655
X1266 35804 35766 35662 45 85 35738 NAND3X1 $T=1049600 428365 0 180 $X=1045250 $Y=423810
X1267 35001 35796 35839 45 85 35544 NAND3X1 $T=1046240 483245 1 0 $X=1045810 $Y=478690
X1268 35838 35742 34610 45 85 35659 NAND3X1 $T=1050720 412685 1 180 $X=1046370 $Y=412295
X1269 35464 35813 35661 45 85 35823 NAND3X1 $T=1046800 459725 0 0 $X=1046370 $Y=459335
X1270 33139 35909 35946 45 85 35813 NAND3X1 $T=1050160 459725 1 0 $X=1049730 $Y=455170
X1271 33139 35510 35784 45 85 289 NAND3X1 $T=1054080 475405 0 180 $X=1049730 $Y=470850
X1272 35947 295 35963 45 85 35844 NAND3X1 $T=1052960 459725 0 0 $X=1052530 $Y=459335
X1273 33139 36003 35822 45 85 35947 NAND3X1 $T=1058000 459725 0 180 $X=1053650 $Y=455170
X1274 36025 36114 36149 45 85 36147 NAND3X1 $T=1058000 428365 1 0 $X=1057570 $Y=423810
X1275 203 36121 36097 45 85 36148 NAND3X1 $T=1058000 467565 0 0 $X=1057570 $Y=467175
X1276 35866 36129 36112 45 85 36174 NAND3X1 $T=1059120 404845 0 0 $X=1058690 $Y=404455
X1277 36162 36057 36240 45 85 36175 NAND3X1 $T=1060800 436205 0 0 $X=1060370 $Y=435815
X1278 36241 36207 132 45 85 36162 NAND3X1 $T=1065280 444045 1 180 $X=1060930 $Y=443655
X1279 301 36228 36176 45 85 36259 NAND3X1 $T=1061920 467565 0 0 $X=1061490 $Y=467175
X1280 36239 35562 35344 45 85 36273 NAND3X1 $T=1067520 420525 0 180 $X=1063170 $Y=415970
X1281 33139 36270 36190 45 85 36242 NAND3X1 $T=1067520 467565 0 180 $X=1063170 $Y=463010
X1282 36335 36382 36422 45 85 36293 NAND3X1 $T=1066960 444045 1 0 $X=1066530 $Y=439490
X1283 36404 36362 36319 45 85 36211 NAND3X1 $T=1070880 451885 0 180 $X=1066530 $Y=447330
X1284 36033 36381 36437 45 85 36421 NAND3X1 $T=1067520 428365 0 0 $X=1067090 $Y=427975
X1285 36522 314 36391 45 85 36459 NAND3X1 $T=1074800 459725 0 180 $X=1070450 $Y=455170
X1286 36628 36592 36556 45 85 36367 NAND3X1 $T=1078720 412685 0 180 $X=1074370 $Y=408130
X1287 36579 36602 36323 45 85 36723 NAND3X1 $T=1078160 436205 1 0 $X=1077730 $Y=431650
X1288 36691 36766 36775 45 85 36790 NAND3X1 $T=1080400 420525 1 0 $X=1079970 $Y=415970
X1289 36908 323 321 45 85 36841 NAND3X1 $T=1088240 467565 0 180 $X=1083890 $Y=463010
X1290 36925 36771 36693 45 85 36881 NAND3X1 $T=1088800 444045 0 180 $X=1084450 $Y=439490
X1291 36362 36755 36875 45 85 36926 NAND3X1 $T=1084880 467565 0 0 $X=1084450 $Y=467175
X1292 36911 325 36753 45 85 36856 NAND3X1 $T=1090480 451885 1 180 $X=1086130 $Y=451495
X1293 36961 36874 34917 45 85 327 NAND3X1 $T=1091040 420525 1 180 $X=1086690 $Y=420135
X1294 36903 36807 324 45 85 36942 NAND3X1 $T=1091600 436205 0 180 $X=1087250 $Y=431650
X1295 240 137 106 45 85 37512 NAND3X1 $T=1108960 459725 0 180 $X=1104610 $Y=455170
X1296 240 137 111 45 85 37756 NAND3X1 $T=1110080 444045 0 0 $X=1109650 $Y=443655
X1297 37564 37749 111 45 85 37737 NAND3X1 $T=1110640 451885 1 0 $X=1110210 $Y=447330
X1298 38558 38599 38563 45 85 38811 NAND3X1 $T=1142000 444045 0 0 $X=1141570 $Y=443655
X1299 41235 41027 348 45 85 349 NAND3X1 $T=1223200 475405 0 180 $X=1218850 $Y=470850
X1300 45 106 30027 109 85 106 29461 105 ICV_115 $T=889440 483245 0 180 $X=886210 $Y=478690
X1301 45 111 29444 119 85 111 29461 31197 ICV_115 $T=894480 483245 1 180 $X=891250 $Y=482855
X1302 45 105 144 31476 85 137 128 120 ICV_115 $T=905680 483245 1 180 $X=902450 $Y=482855
X1303 45 149 147 31488 85 31647 132 31570 ICV_115 $T=909600 444045 1 180 $X=906370 $Y=443655
X1304 45 137 159 156 85 149 145 153 ICV_115 $T=914080 483245 1 180 $X=910850 $Y=482855
X1305 45 122 162 31859 85 113 147 31835 ICV_115 $T=916880 451885 0 180 $X=913650 $Y=447330
X1306 45 149 163 31914 85 158 123 31753 ICV_115 $T=916880 467565 0 180 $X=913650 $Y=463010
X1307 45 149 118 31901 85 137 125 155 ICV_115 $T=916880 475405 0 180 $X=913650 $Y=470850
X1308 45 166 31978 168 85 149 159 161 ICV_115 $T=919680 483245 1 180 $X=916450 $Y=482855
X1309 45 140 175 31860 85 31978 165 118 ICV_115 $T=921360 475405 1 180 $X=918130 $Y=475015
X1310 45 137 181 32103 85 137 162 32009 ICV_115 $T=925280 436205 1 180 $X=922050 $Y=435815
X1311 45 149 195 32029 85 149 181 32313 ICV_115 $T=933680 436205 1 180 $X=930450 $Y=435815
X1312 45 31647 198 32677 85 122 172 32563 ICV_115 $T=943760 451885 0 180 $X=940530 $Y=447330
X1313 45 143 248 36010 85 262 140 35975 ICV_115 $T=1056320 412685 1 180 $X=1053090 $Y=412295
X1314 45 143 305 36240 85 235 248 36056 ICV_115 $T=1062480 436205 0 180 $X=1059250 $Y=431650
X1315 45 36351 35964 300 85 36351 312 35481 ICV_115 $T=1073680 475405 1 180 $X=1070450 $Y=475015
X1316 45 36630 36225 322 85 36630 307 244 ICV_115 $T=1082640 475405 1 180 $X=1079410 $Y=475015
X1317 108 31087 45 85 30757 OR2X1 $T=891120 436205 0 180 $X=887330 $Y=431650
X1318 108 31206 45 85 30894 OR2X1 $T=895040 428365 0 180 $X=891250 $Y=423810
X1319 108 31217 45 85 31187 OR2X1 $T=895600 428365 1 180 $X=891810 $Y=427975
X1320 108 31237 45 85 31205 OR2X1 $T=896160 412685 1 180 $X=892370 $Y=412295
X1321 108 31313 45 85 31334 OR2X1 $T=895040 428365 1 0 $X=894610 $Y=423810
X1322 108 32140 45 85 32304 OR2X1 $T=929200 436205 1 0 $X=928770 $Y=431650
X1323 178 121 45 85 32547 OR2X1 $T=938720 475405 1 0 $X=938290 $Y=470850
X1324 205 113 45 85 32594 OR2X1 $T=945440 467565 0 180 $X=941650 $Y=463010
X1325 32808 32761 45 85 32733 OR2X1 $T=949920 451885 1 180 $X=946130 $Y=451495
X1326 188 121 45 85 33031 OR2X1 $T=953840 467565 1 0 $X=953410 $Y=463010
X1327 31581 122 45 85 33050 OR2X1 $T=961120 451885 0 180 $X=957330 $Y=447330
X1328 173 33166 45 85 33202 OR2X1 $T=959440 459725 0 0 $X=959010 $Y=459335
X1329 168 33166 45 85 226 OR2X1 $T=960560 483245 1 0 $X=960130 $Y=478690
X1330 216 126 45 85 33094 OR2X1 $T=964480 459725 0 180 $X=960690 $Y=455170
X1331 31508 227 45 85 33252 OR2X1 $T=962240 451885 1 0 $X=961810 $Y=447330
X1332 33166 223 45 85 33304 OR2X1 $T=964480 459725 1 0 $X=964050 $Y=455170
X1333 32533 227 45 85 33377 OR2X1 $T=971200 444045 1 180 $X=967410 $Y=443655
X1334 33358 33442 45 85 33303 OR2X1 $T=972320 475405 1 180 $X=968530 $Y=475015
X1335 208 214 45 85 239 OR2X1 $T=989120 483245 0 0 $X=988690 $Y=482855
X1336 228 34611 45 85 34612 OR2X1 $T=1005920 420525 0 0 $X=1005490 $Y=420135
X1337 220 242 45 85 34645 OR2X1 $T=1005920 444045 1 0 $X=1005490 $Y=439490
X1338 34433 34609 45 85 34711 OR2X1 $T=1008160 412685 1 0 $X=1007730 $Y=408130
X1339 242 121 45 85 34756 OR2X1 $T=1015440 459725 1 180 $X=1011650 $Y=459335
X1340 191 34923 45 85 34882 OR2X1 $T=1019920 451885 0 180 $X=1016130 $Y=447330
X1341 258 214 45 85 35259 OR2X1 $T=1026640 483245 1 0 $X=1026210 $Y=478690
X1342 121 35310 45 85 35379 OR2X1 $T=1036720 451885 0 180 $X=1032930 $Y=447330
X1343 34464 260 45 85 35494 OR2X1 $T=1035040 459725 0 0 $X=1034610 $Y=459335
X1344 258 126 45 85 35510 OR2X1 $T=1035600 475405 0 0 $X=1035170 $Y=475015
X1345 255 113 45 85 35440 OR2X1 $T=1041200 467565 1 180 $X=1037410 $Y=467175
X1346 263 121 45 85 35478 OR2X1 $T=1044560 467565 1 180 $X=1040770 $Y=467175
X1347 33166 281 45 85 35632 OR2X1 $T=1041760 459725 1 0 $X=1041330 $Y=455170
X1348 35577 35702 45 85 284 OR2X1 $T=1044000 444045 1 0 $X=1043570 $Y=439490
X1349 281 122 45 85 35739 OR2X1 $T=1045120 459725 1 0 $X=1044690 $Y=455170
X1350 283 122 45 85 35784 OR2X1 $T=1045120 475405 0 0 $X=1044690 $Y=475015
X1351 137 280 45 85 35742 OR2X1 $T=1049600 428365 1 180 $X=1045810 $Y=427975
X1352 191 35811 45 85 35261 OR2X1 $T=1050720 436205 0 180 $X=1046930 $Y=431650
X1353 191 35812 45 85 35262 OR2X1 $T=1050720 444045 0 180 $X=1046930 $Y=439490
X1354 214 35820 45 85 288 OR2X1 $T=1047360 483245 0 0 $X=1046930 $Y=482855
X1355 299 143 45 85 35838 OR2X1 $T=1058560 428365 1 180 $X=1054770 $Y=427975
X1356 244 121 45 85 36097 OR2X1 $T=1056320 475405 1 0 $X=1055890 $Y=470850
X1357 36111 122 45 85 35909 OR2X1 $T=1061360 459725 0 180 $X=1057570 $Y=455170
X1358 113 36111 45 85 36121 OR2X1 $T=1058000 467565 1 0 $X=1057570 $Y=463010
X1359 34924 122 45 85 36190 OR2X1 $T=1059680 459725 0 0 $X=1059250 $Y=459335
X1360 34924 235 45 85 36207 OR2X1 $T=1061360 451885 1 0 $X=1060930 $Y=447330
X1361 122 303 45 85 36003 OR2X1 $T=1061360 459725 1 0 $X=1060930 $Y=455170
X1362 253 238 45 85 36241 OR2X1 $T=1063600 451885 0 0 $X=1063170 $Y=451495
X1363 310 126 45 85 36270 OR2X1 $T=1069760 467565 1 180 $X=1065970 $Y=467175
X1364 328 37037 45 85 37079 OR2X1 $T=1089920 459725 1 0 $X=1089490 $Y=455170
X1365 37037 37305 45 85 37564 OR2X1 $T=1104480 444045 0 0 $X=1104050 $Y=443655
X1366 38563 37458 45 85 38475 OR2X1 $T=1138640 428365 1 180 $X=1134850 $Y=427975
X1367 38563 38225 45 85 37749 OR2X1 $T=1139760 451885 0 180 $X=1135970 $Y=447330
X1368 38558 37421 45 85 339 OR2X1 $T=1141440 444045 1 0 $X=1141010 $Y=439490
X1369 38558 37749 45 85 340 OR2X1 $T=1142000 451885 1 0 $X=1141570 $Y=447330
X1370 38811 38906 45 85 38941 OR2X1 $T=1146480 444045 1 0 $X=1146050 $Y=439490
X1371 191 38811 45 85 38997 OR2X1 $T=1152080 444045 0 0 $X=1151650 $Y=443655
X1372 108 38811 45 85 39252 OR2X1 $T=1156560 444045 1 0 $X=1156130 $Y=439490
X1373 39153 39285 45 85 39321 OR2X1 $T=1158800 428365 0 0 $X=1158370 $Y=427975
X1374 39430 39558 45 85 343 OR2X1 $T=1169440 451885 0 0 $X=1169010 $Y=451495
X1375 40961 40930 45 85 39778 OR2X1 $T=1213680 459725 0 180 $X=1209890 $Y=455170
X1376 45 85 31114 104 31100 ICV_74 $T=887760 444045 1 0 $X=887330 $Y=439490
X1377 45 85 31725 132 31710 ICV_74 $T=909040 428365 0 0 $X=908610 $Y=427975
X1378 45 85 140 146 31805 ICV_74 $T=912400 451885 0 0 $X=911970 $Y=451495
X1379 45 85 126 205 32743 ICV_74 $T=945440 444045 0 0 $X=945010 $Y=443655
X1380 45 85 122 218 33035 ICV_74 $T=954960 483245 0 0 $X=954530 $Y=482855
X1381 45 85 104 175 33352 ICV_74 $T=965600 483245 0 0 $X=965170 $Y=482855
X1382 45 85 34372 225 33442 ICV_74 $T=996960 467565 1 0 $X=996530 $Y=463010
X1383 45 85 244 33236 243 ICV_74 $T=1005920 483245 0 0 $X=1005490 $Y=482855
X1384 45 85 245 33236 34664 ICV_74 $T=1007600 428365 0 0 $X=1007170 $Y=427975
X1385 45 85 34934 198 34898 ICV_74 $T=1016000 444045 1 0 $X=1015570 $Y=439490
X1386 45 85 217 246 35036 ICV_74 $T=1019920 436205 1 0 $X=1019490 $Y=431650
X1387 45 85 208 263 35233 ICV_74 $T=1026640 459725 0 0 $X=1026210 $Y=459335
X1388 45 85 35310 132 35263 ICV_74 $T=1030560 459725 1 0 $X=1030130 $Y=455170
X1389 45 85 149 35883 36323 ICV_74 $T=1065280 436205 1 0 $X=1064850 $Y=431650
X1390 45 85 305 238 36441 ICV_74 $T=1069200 436205 0 0 $X=1068770 $Y=435815
X1391 45 85 137 317 314 ICV_74 $T=1074240 483245 0 0 $X=1073810 $Y=482855
X1392 45 85 36568 130 36691 ICV_74 $T=1078720 412685 1 0 $X=1078290 $Y=408130
X1393 45 85 140 315 36807 ICV_74 $T=1082080 436205 1 0 $X=1081650 $Y=431650
X1394 45 85 40303 40187 40282 ICV_74 $T=1189600 475405 1 0 $X=1189170 $Y=470850
X1395 45 85 41334 349 41318 ICV_74 $T=1223200 475405 1 0 $X=1222770 $Y=470850
X1396 45 111 30027 31135 85 ICV_78 $T=887760 475405 1 0 $X=887330 $Y=470850
X1397 45 31266 104 31248 85 ICV_78 $T=891680 451885 0 0 $X=891250 $Y=451495
X1398 45 140 142 31584 85 ICV_78 $T=903440 420525 0 0 $X=903010 $Y=420135
X1399 45 152 31197 31662 85 ICV_78 $T=909040 475405 0 0 $X=908610 $Y=475015
X1400 45 140 154 32016 85 ICV_78 $T=918560 404845 0 0 $X=918130 $Y=404455
X1401 45 126 173 31906 85 ICV_78 $T=920240 444045 1 0 $X=919810 $Y=439490
X1402 45 32309 130 32192 85 ICV_78 $T=928640 404845 0 0 $X=928210 $Y=404455
X1403 45 32393 32249 32374 85 ICV_78 $T=931440 404845 1 0 $X=931010 $Y=400290
X1404 45 109 194 31508 85 ICV_78 $T=931440 475405 0 0 $X=931010 $Y=475015
X1405 45 201 31197 178 85 ICV_78 $T=935920 475405 0 0 $X=935490 $Y=475015
X1406 45 196 202 32533 85 ICV_78 $T=937600 483245 1 0 $X=937170 $Y=478690
X1407 45 32583 189 32412 85 ICV_78 $T=938160 404845 0 0 $X=937730 $Y=404455
X1408 45 32583 198 32566 85 ICV_78 $T=938160 412685 1 0 $X=937730 $Y=408130
X1409 45 126 32642 32681 85 ICV_78 $T=942080 475405 1 0 $X=941650 $Y=470850
X1410 45 32692 110 32689 85 ICV_78 $T=942640 420525 1 0 $X=942210 $Y=415970
X1411 45 113 206 32734 85 ICV_78 $T=944320 467565 0 0 $X=943890 $Y=467175
X1412 45 208 172 207 85 ICV_78 $T=946000 483245 0 0 $X=945570 $Y=482855
X1413 45 33321 33202 33171 85 ICV_78 $T=962800 459725 0 0 $X=962370 $Y=459335
X1414 45 34452 33340 34304 85 ICV_78 $T=998640 404845 0 0 $X=998210 $Y=404455
X1415 45 34547 34495 33139 85 ICV_78 $T=1006480 451885 1 0 $X=1006050 $Y=447330
X1416 45 255 140 35025 85 ICV_78 $T=1018800 459725 1 0 $X=1018370 $Y=455170
X1417 45 245 213 35344 85 ICV_78 $T=1029440 420525 1 0 $X=1029010 $Y=415970
X1418 45 35387 110 35674 85 ICV_78 $T=1041760 436205 0 0 $X=1041330 $Y=435815
X1419 45 140 272 35825 85 ICV_78 $T=1046240 420525 1 0 $X=1045810 $Y=415970
X1420 45 121 260 35963 85 ICV_78 $T=1051280 467565 0 0 $X=1050850 $Y=467175
X1421 45 297 291 34924 85 ICV_78 $T=1052960 475405 0 0 $X=1052530 $Y=475015
X1422 45 143 35481 36694 85 ICV_78 $T=1077040 459725 0 0 $X=1076610 $Y=459335
X1423 45 140 305 36775 85 ICV_78 $T=1079840 428365 0 0 $X=1079410 $Y=427975
X1424 45 36660 36791 36909 85 ICV_78 $T=1084320 483245 1 0 $X=1083890 $Y=478690
X1425 45 91 39752 40187 85 ICV_78 $T=1185680 475405 0 0 $X=1185250 $Y=475015
X1426 45 90 39734 40507 85 ICV_78 $T=1195200 475405 0 0 $X=1194770 $Y=475015
X1427 45 41385 40961 41334 85 ICV_78 $T=1223760 467565 0 0 $X=1223330 $Y=467175
X1456 45 85 31187 31253 115 ICV_72 $T=892800 444045 1 0 $X=892370 $Y=439490
X1457 45 85 122 125 31046 ICV_72 $T=897280 475405 1 0 $X=896850 $Y=470850
X1458 45 85 126 131 31418 ICV_72 $T=903440 451885 1 0 $X=903010 $Y=447330
X1459 45 85 140 31619 31569 ICV_72 $T=906800 412685 0 0 $X=906370 $Y=412295
X1460 45 85 143 154 31718 ICV_72 $T=913520 420525 0 0 $X=913090 $Y=420135
X1461 45 85 137 172 31991 ICV_72 $T=920800 451885 1 0 $X=920370 $Y=447330
X1462 45 85 149 178 116 ICV_72 $T=922480 483245 0 0 $X=922050 $Y=482855
X1463 45 85 140 150 32193 ICV_72 $T=928080 412685 0 0 $X=927650 $Y=412295
X1464 45 85 121 31508 32294 ICV_72 $T=929760 451885 0 0 $X=929330 $Y=451495
X1465 45 85 140 32533 32373 ICV_72 $T=938160 451885 0 0 $X=937730 $Y=451495
X1466 45 85 113 210 32810 ICV_72 $T=948240 475405 0 0 $X=947810 $Y=475015
X1467 45 85 32776 110 32741 ICV_72 $T=952720 428365 1 0 $X=952290 $Y=423810
X1468 45 85 229 34800 34781 ICV_72 $T=1012080 475405 1 0 $X=1011650 $Y=470850
X1469 45 85 34816 234 34933 ICV_72 $T=1017120 428365 0 0 $X=1016690 $Y=427975
X1470 45 85 213 257 35085 ICV_72 $T=1022160 451885 1 0 $X=1021730 $Y=447330
X1471 45 85 246 213 35260 ICV_72 $T=1029440 428365 1 0 $X=1029010 $Y=423810
X1472 45 85 169 34924 35180 ICV_72 $T=1030000 459725 0 0 $X=1029570 $Y=459335
X1473 45 85 126 300 35796 ICV_72 $T=1056880 483245 0 0 $X=1056450 $Y=482855
X1474 45 85 36007 191 36112 ICV_72 $T=1058560 412685 1 0 $X=1058130 $Y=408130
X1475 45 85 122 35820 36176 ICV_72 $T=1060800 475405 1 0 $X=1060370 $Y=470850
X1476 45 85 302 36225 35820 ICV_72 $T=1061920 483245 0 0 $X=1061490 $Y=482855
X1477 45 85 304 307 36036 ICV_72 $T=1065840 475405 1 0 $X=1065410 $Y=470850
X1478 45 85 143 322 36875 ICV_72 $T=1084880 475405 1 0 $X=1084450 $Y=470850
X1479 45 85 36942 108 36961 ICV_72 $T=1087680 428365 0 0 $X=1087250 $Y=427975
X1480 31460 31492 45 85 31546 AND2X1 $T=902320 475405 1 0 $X=901890 $Y=470850
X1481 31582 31616 45 85 31645 AND2X1 $T=905680 475405 1 0 $X=905250 $Y=470850
X1482 31677 31753 45 85 31784 AND2X1 $T=910720 459725 0 0 $X=910290 $Y=459335
X1483 31901 31860 45 85 157 AND2X1 $T=918560 475405 1 180 $X=914770 $Y=475015
X1484 32003 31914 45 85 31949 AND2X1 $T=920240 451885 0 0 $X=919810 $Y=451495
X1485 32178 32107 45 85 32109 AND2X1 $T=928080 459725 0 180 $X=924290 $Y=455170
X1486 32313 31791 45 85 32390 AND2X1 $T=932000 428365 0 0 $X=931570 $Y=427975
X1487 32412 32438 45 85 32471 AND2X1 $T=934800 404845 0 0 $X=934370 $Y=404455
X1488 32549 32517 45 85 32432 AND2X1 $T=941520 420525 1 180 $X=937730 $Y=420135
X1489 32062 191 45 85 32578 AND2X1 $T=938720 467565 1 0 $X=938290 $Y=463010
X1490 32947 215 45 85 32885 AND2X1 $T=954960 483245 0 180 $X=951170 $Y=478690
X1491 33237 33118 45 85 33298 AND2X1 $T=962800 436205 1 0 $X=962370 $Y=431650
X1492 33202 227 45 85 33233 AND2X1 $T=967280 467565 1 180 $X=963490 $Y=467175
X1493 33106 33322 45 85 33342 AND2X1 $T=970080 428365 1 180 $X=966290 $Y=427975
X1494 231 33236 45 85 233 AND2X1 $T=972320 483245 0 0 $X=971890 $Y=482855
X1495 220 234 45 85 217 AND2X1 $T=980160 428365 1 180 $X=976370 $Y=427975
X1496 228 33340 45 85 235 AND2X1 $T=982960 428365 0 0 $X=982530 $Y=427975
X1497 236 134 45 85 140 AND2X1 $T=985200 451885 0 0 $X=984770 $Y=451495
X1498 220 33340 45 85 238 AND2X1 $T=989120 428365 0 0 $X=988690 $Y=427975
X1499 225 237 45 85 213 AND2X1 $T=992480 444045 0 180 $X=988690 $Y=439490
X1500 33236 237 45 85 214 AND2X1 $T=989120 483245 1 0 $X=988690 $Y=478690
X1501 34024 225 45 85 121 AND2X1 $T=994720 459725 1 180 $X=990930 $Y=459335
X1502 228 34024 45 85 227 AND2X1 $T=994720 467565 1 180 $X=990930 $Y=467175
X1503 228 237 45 85 221 AND2X1 $T=993600 483245 0 0 $X=993170 $Y=482855
X1504 236 139 45 85 149 AND2X1 $T=997520 436205 0 0 $X=997090 $Y=435815
X1505 34372 33236 45 85 33166 AND2X1 $T=1003120 459725 0 180 $X=999330 $Y=455170
X1506 35037 35069 45 85 35068 AND2X1 $T=1021040 475405 1 0 $X=1020610 $Y=470850
X1507 35885 35825 45 85 35804 AND2X1 $T=1052400 420525 1 180 $X=1048610 $Y=420135
X1508 35805 35882 45 85 35346 AND2X1 $T=1053520 444045 1 180 $X=1049730 $Y=443655
X1509 35639 35974 45 85 36033 AND2X1 $T=1054080 397005 0 0 $X=1053650 $Y=396615
X1510 35976 36056 45 85 36025 AND2X1 $T=1059680 436205 0 180 $X=1055890 $Y=431650
X1511 36242 36148 45 85 36335 AND2X1 $T=1064720 459725 0 0 $X=1064290 $Y=459335
X1512 36308 36403 45 85 36381 AND2X1 $T=1072000 428365 0 180 $X=1068210 $Y=423810
X1513 36492 108 45 85 35915 AND2X1 $T=1073680 412685 1 180 $X=1069890 $Y=412295
X1514 36441 36490 45 85 36579 AND2X1 $T=1073120 436205 0 0 $X=1072690 $Y=435815
X1515 36292 36600 45 85 36628 AND2X1 $T=1074800 404845 1 0 $X=1074370 $Y=400290
X1516 36538 104 45 85 36618 AND2X1 $T=1080400 420525 0 180 $X=1076610 $Y=415970
X1517 36694 36724 45 85 36522 AND2X1 $T=1082640 459725 1 0 $X=1082210 $Y=455170
X1518 38475 37749 45 85 37305 AND2X1 $T=1134720 436205 0 180 $X=1130930 $Y=431650
X1519 39097 108 45 85 39167 AND2X1 $T=1153760 428365 0 0 $X=1153330 $Y=427975
X1520 32800 45 85 32822 INVX2 $T=948800 436205 1 0 $X=948370 $Y=431650
X1521 32873 45 85 32992 INVX2 $T=954400 420525 1 0 $X=953970 $Y=415970
X1522 32533 45 85 33358 INVX2 $T=968960 475405 1 180 $X=966850 $Y=475015
X1523 134 45 85 139 INVX2 $T=969520 436205 0 180 $X=967410 $Y=431650
X1524 223 45 85 33378 INVX2 $T=969520 467565 1 180 $X=967410 $Y=467175
X1525 229 45 85 113 INVX2 $T=990800 475405 0 180 $X=988690 $Y=470850
X1526 34024 45 85 34167 INVX2 $T=993600 436205 1 180 $X=991490 $Y=435815
X1527 33340 45 85 34257 INVX2 $T=995840 412685 1 0 $X=995410 $Y=408130
X1528 130 45 85 34003 INVX2 $T=999760 451885 0 180 $X=997650 $Y=447330
X1529 33442 45 85 34464 INVX2 $T=1001440 475405 1 0 $X=1001010 $Y=470850
X1530 34256 45 85 34433 INVX2 $T=1003680 404845 0 0 $X=1003250 $Y=404455
X1531 34609 45 85 34452 INVX2 $T=1008160 404845 1 180 $X=1006050 $Y=404455
X1532 241 45 85 34610 INVX2 $T=1006480 412685 0 0 $X=1006050 $Y=412295
X1533 34495 45 85 122 INVX2 $T=1008160 459725 1 0 $X=1007730 $Y=455170
X1534 34547 45 85 126 INVX2 $T=1009840 459725 1 180 $X=1007730 $Y=459335
X1535 34924 45 85 34800 INVX2 $T=1018800 475405 0 180 $X=1016690 $Y=470850
X1536 35035 45 85 143 INVX2 $T=1024960 412685 0 0 $X=1024530 $Y=412295
X1537 35291 45 85 35269 INVX2 $T=1031120 412685 0 180 $X=1029010 $Y=408130
X1538 259 45 85 35573 INVX2 $T=1039520 459725 1 0 $X=1039090 $Y=455170
X1539 110 45 85 35737 INVX2 $T=1046800 412685 1 0 $X=1046370 $Y=408130
X1540 35844 45 85 35866 INVX2 $T=1049600 412685 1 0 $X=1049170 $Y=408130
X1541 270 45 85 35962 INVX2 $T=1058560 451885 1 180 $X=1056450 $Y=451495
X1542 36881 45 85 36903 INVX2 $T=1086000 436205 1 0 $X=1085570 $Y=431650
X1543 191 45 85 108 INVX2 $T=1095520 436205 0 0 $X=1095090 $Y=435815
X1544 137 45 85 37037 INVX2 $T=1105040 451885 0 180 $X=1102930 $Y=447330
X1545 36840 45 85 37421 INVX2 $T=1130800 420525 1 0 $X=1130370 $Y=415970
X1546 37458 45 85 38558 INVX2 $T=1135280 444045 1 0 $X=1134850 $Y=439490
X1547 38225 45 85 38599 INVX2 $T=1136960 444045 1 0 $X=1136530 $Y=439490
X1548 38906 45 85 38794 INVX2 $T=1149840 436205 0 180 $X=1147730 $Y=431650
X1549 38631 45 85 39372 INVX2 $T=1162160 444045 1 0 $X=1161730 $Y=439490
X1550 39778 45 85 98 INVX2 $T=1176720 459725 1 180 $X=1174610 $Y=459335
X1551 40301 45 85 40449 INVX2 $T=1195760 444045 1 0 $X=1195330 $Y=439490
X1552 343 45 85 40480 INVX2 $T=1196320 451885 0 0 $X=1195890 $Y=451495
X1553 40639 45 85 40731 INVX2 $T=1205840 444045 1 0 $X=1205410 $Y=439490
X1554 40961 45 85 41235 INVX2 $T=1222080 467565 1 0 $X=1221650 $Y=463010
X1555 41027 45 85 41364 INVX2 $T=1225440 467565 1 0 $X=1225010 $Y=463010
X1556 41188 45 85 41454 INVX2 $T=1228240 467565 1 0 $X=1227810 $Y=463010
X1600 293 45 85 35893 BUFX1 $T=1054080 412685 0 180 $X=1050850 $Y=408130
.ENDS
***************************************
.SUBCKT padbox
** N=1 EP=0 IP=0 FDC=0
.ENDS
***************************************
.SUBCKT pad_in VSS VDD DataIn
** N=24 EP=3 IP=1 FDC=96
M0 VSS VSS 6 VSS N L=3.5e-07 W=9e-06 $X=5700 $Y=147100 $D=0
M1 7 6 VSS VSS N L=3.5e-07 W=9e-06 $X=8100 $Y=147100 $D=0
M2 VSS VSS 9 VSS N L=3.5e-07 W=9e-06 $X=13200 $Y=147100 $D=0
M3 9 VSS VSS VSS N L=3.5e-07 W=9e-06 $X=15600 $Y=147100 $D=0
M4 pad 9 VSS VSS N L=3.5e-07 W=2e-05 $X=15770 $Y=191300 $D=0
M5 VSS 9 pad VSS N L=3.5e-07 W=2e-05 $X=15770 $Y=196210 $D=0
M6 pad 9 VSS VSS N L=3.5e-07 W=2e-05 $X=15770 $Y=197780 $D=0
M7 VSS 9 pad VSS N L=3.5e-07 W=2e-05 $X=15770 $Y=202690 $D=0
M8 pad 9 VSS VSS N L=3.5e-07 W=2e-05 $X=15770 $Y=204260 $D=0
M9 VSS 9 pad VSS N L=3.5e-07 W=2e-05 $X=15770 $Y=209170 $D=0
M10 pad 9 VSS VSS N L=3.5e-07 W=2e-05 $X=15770 $Y=210740 $D=0
M11 VSS 9 pad VSS N L=3.5e-07 W=2e-05 $X=15770 $Y=215650 $D=0
M12 pad 9 VSS VSS N L=3.5e-07 W=2e-05 $X=15770 $Y=217220 $D=0
M13 VSS 9 pad VSS N L=3.5e-07 W=2e-05 $X=15770 $Y=222130 $D=0
M14 VSS VSS 9 VSS N L=3.5e-07 W=9e-06 $X=18000 $Y=147100 $D=0
M15 9 VSS VSS VSS N L=3.5e-07 W=9e-06 $X=20400 $Y=147100 $D=0
M16 VSS VSS 9 VSS N L=3.5e-07 W=9e-06 $X=22800 $Y=147100 $D=0
M17 9 6 VSS VSS N L=3.5e-07 W=9e-06 $X=25200 $Y=147100 $D=0
M18 VSS 6 9 VSS N L=3.5e-07 W=9e-06 $X=27600 $Y=147100 $D=0
M19 9 6 VSS VSS N L=3.5e-07 W=9e-06 $X=30000 $Y=147100 $D=0
M20 VSS 6 9 VSS N L=3.5e-07 W=9e-06 $X=32400 $Y=147100 $D=0
M21 9 6 VSS VSS N L=3.5e-07 W=9e-06 $X=34800 $Y=147100 $D=0
M22 8 7 9 VSS N L=3.5e-07 W=9e-06 $X=37200 $Y=147100 $D=0
M23 9 7 8 VSS N L=3.5e-07 W=9e-06 $X=39600 $Y=147100 $D=0
M24 8 7 9 VSS N L=3.5e-07 W=9e-06 $X=42000 $Y=147100 $D=0
M25 9 7 8 VSS N L=3.5e-07 W=9e-06 $X=44400 $Y=147100 $D=0
M26 pad 9 VSS VSS N L=3.5e-07 W=2e-05 $X=54230 $Y=191300 $D=0
M27 VSS 9 pad VSS N L=3.5e-07 W=2e-05 $X=54230 $Y=196210 $D=0
M28 pad 9 VSS VSS N L=3.5e-07 W=2e-05 $X=54230 $Y=197780 $D=0
M29 VSS 9 pad VSS N L=3.5e-07 W=2e-05 $X=54230 $Y=202690 $D=0
M30 pad 9 VSS VSS N L=3.5e-07 W=2e-05 $X=54230 $Y=204260 $D=0
M31 VSS 9 pad VSS N L=3.5e-07 W=2e-05 $X=54230 $Y=209170 $D=0
M32 pad 9 VSS VSS N L=3.5e-07 W=2e-05 $X=54230 $Y=210740 $D=0
M33 VSS 9 pad VSS N L=3.5e-07 W=2e-05 $X=54230 $Y=215650 $D=0
M34 pad 9 VSS VSS N L=3.5e-07 W=2e-05 $X=54230 $Y=217220 $D=0
M35 VSS 9 pad VSS N L=3.5e-07 W=2e-05 $X=54230 $Y=222130 $D=0
M36 11 pad VSS VSS N L=3.5e-07 W=9e-06 $X=59400 $Y=146950 $D=0
M37 VSS pad 11 VSS N L=3.5e-07 W=9e-06 $X=61800 $Y=146950 $D=0
M38 11 pad VSS VSS N L=3.5e-07 W=9e-06 $X=64200 $Y=146950 $D=0
M39 VSS pad 11 VSS N L=3.5e-07 W=9e-06 $X=66600 $Y=146950 $D=0
M40 11 pad VSS VSS N L=3.5e-07 W=9e-06 $X=69000 $Y=146950 $D=0
M41 VSS pad 11 VSS N L=3.5e-07 W=9e-06 $X=71400 $Y=146950 $D=0
M42 DataIn 11 VSS VSS N L=3.5e-07 W=9e-06 $X=73800 $Y=146950 $D=0
M43 VSS 11 DataIn VSS N L=3.5e-07 W=9e-06 $X=76200 $Y=146950 $D=0
M44 DataIn 11 VSS VSS N L=3.5e-07 W=9e-06 $X=78600 $Y=146950 $D=0
M45 VSS 11 DataIn VSS N L=3.5e-07 W=9e-06 $X=81000 $Y=146950 $D=0
M46 DataIn 11 VSS VSS N L=3.5e-07 W=9e-06 $X=83400 $Y=146950 $D=0
M47 VSS 11 DataIn VSS N L=3.5e-07 W=9e-06 $X=85800 $Y=146950 $D=0
M48 VDD VSS 6 VDD P L=3.5e-07 W=1.56e-05 $X=5700 $Y=165550 $D=16
M49 7 6 VDD VDD P L=3.5e-07 W=1.56e-05 $X=8100 $Y=165550 $D=16
M50 VDD VSS 8 VDD P L=3.5e-07 W=1.56e-05 $X=13200 $Y=165550 $D=16
M51 8 VSS VDD VDD P L=3.5e-07 W=1.56e-05 $X=15600 $Y=165550 $D=16
M52 pad 8 VDD VDD P L=3.5e-07 W=2e-05 $X=15795 $Y=97085 $D=16
M53 VDD 8 pad VDD P L=3.5e-07 W=2e-05 $X=15795 $Y=101995 $D=16
M54 pad 8 VDD VDD P L=3.5e-07 W=2e-05 $X=15795 $Y=103565 $D=16
M55 VDD 8 pad VDD P L=3.5e-07 W=2e-05 $X=15795 $Y=108475 $D=16
M56 pad 8 VDD VDD P L=3.5e-07 W=2e-05 $X=15795 $Y=110045 $D=16
M57 VDD 8 pad VDD P L=3.5e-07 W=2e-05 $X=15795 $Y=114955 $D=16
M58 pad 8 VDD VDD P L=3.5e-07 W=2e-05 $X=15795 $Y=116525 $D=16
M59 VDD 8 pad VDD P L=3.5e-07 W=2e-05 $X=15795 $Y=121435 $D=16
M60 pad 8 VDD VDD P L=3.5e-07 W=2e-05 $X=15795 $Y=123005 $D=16
M61 VDD 8 pad VDD P L=3.5e-07 W=2e-05 $X=15795 $Y=127915 $D=16
M62 VDD VSS 8 VDD P L=3.5e-07 W=1.56e-05 $X=18000 $Y=165550 $D=16
M63 8 VSS VDD VDD P L=3.5e-07 W=1.56e-05 $X=20400 $Y=165550 $D=16
M64 VDD VSS 8 VDD P L=3.5e-07 W=1.56e-05 $X=22800 $Y=165550 $D=16
M65 8 7 VDD VDD P L=3.5e-07 W=1.56e-05 $X=25200 $Y=165550 $D=16
M66 VDD 7 8 VDD P L=3.5e-07 W=1.56e-05 $X=27600 $Y=165550 $D=16
M67 8 7 VDD VDD P L=3.5e-07 W=1.56e-05 $X=30000 $Y=165550 $D=16
M68 VDD 7 8 VDD P L=3.5e-07 W=1.56e-05 $X=32400 $Y=165550 $D=16
M69 8 7 VDD VDD P L=3.5e-07 W=1.56e-05 $X=34800 $Y=165550 $D=16
M70 9 6 8 VDD P L=3.5e-07 W=1.56e-05 $X=37200 $Y=165550 $D=16
M71 8 6 9 VDD P L=3.5e-07 W=1.56e-05 $X=39600 $Y=165550 $D=16
M72 9 6 8 VDD P L=3.5e-07 W=1.56e-05 $X=42000 $Y=165550 $D=16
M73 8 6 9 VDD P L=3.5e-07 W=1.56e-05 $X=44400 $Y=165550 $D=16
M74 pad 8 VDD VDD P L=3.5e-07 W=2e-05 $X=53330 $Y=97085 $D=16
M75 VDD 8 pad VDD P L=3.5e-07 W=2e-05 $X=53330 $Y=101995 $D=16
M76 pad 8 VDD VDD P L=3.5e-07 W=2e-05 $X=53330 $Y=103565 $D=16
M77 VDD 8 pad VDD P L=3.5e-07 W=2e-05 $X=53330 $Y=108475 $D=16
M78 pad 8 VDD VDD P L=3.5e-07 W=2e-05 $X=53330 $Y=110045 $D=16
M79 VDD 8 pad VDD P L=3.5e-07 W=2e-05 $X=53330 $Y=114955 $D=16
M80 pad 8 VDD VDD P L=3.5e-07 W=2e-05 $X=53330 $Y=116525 $D=16
M81 VDD 8 pad VDD P L=3.5e-07 W=2e-05 $X=53330 $Y=121435 $D=16
M82 pad 8 VDD VDD P L=3.5e-07 W=2e-05 $X=53330 $Y=123005 $D=16
M83 VDD 8 pad VDD P L=3.5e-07 W=2e-05 $X=53330 $Y=127915 $D=16
M84 11 pad VDD VDD P L=3.5e-07 W=1.56e-05 $X=59400 $Y=165550 $D=16
M85 VDD pad 11 VDD P L=3.5e-07 W=1.56e-05 $X=61800 $Y=165550 $D=16
M86 11 pad VDD VDD P L=3.5e-07 W=1.56e-05 $X=64200 $Y=165550 $D=16
M87 VDD pad 11 VDD P L=3.5e-07 W=1.56e-05 $X=66600 $Y=165550 $D=16
M88 11 pad VDD VDD P L=3.5e-07 W=1.56e-05 $X=69000 $Y=165550 $D=16
M89 VDD pad 11 VDD P L=3.5e-07 W=1.56e-05 $X=71400 $Y=165550 $D=16
M90 DataIn 11 VDD VDD P L=3.5e-07 W=1.56e-05 $X=73800 $Y=165550 $D=16
M91 VDD 11 DataIn VDD P L=3.5e-07 W=1.56e-05 $X=76200 $Y=165550 $D=16
M92 DataIn 11 VDD VDD P L=3.5e-07 W=1.56e-05 $X=78600 $Y=165550 $D=16
M93 VDD 11 DataIn VDD P L=3.5e-07 W=1.56e-05 $X=81000 $Y=165550 $D=16
M94 DataIn 11 VDD VDD P L=3.5e-07 W=1.56e-05 $X=83400 $Y=165550 $D=16
M95 VDD 11 DataIn VDD P L=3.5e-07 W=1.56e-05 $X=85800 $Y=165550 $D=16
.ENDS
***************************************
.SUBCKT ICV_39
** N=7 EP=0 IP=10 FDC=0
.ENDS
***************************************
.SUBCKT ICV_90
** N=4 EP=0 IP=8 FDC=0
.ENDS
***************************************
.SUBCKT ICV_92
** N=4 EP=0 IP=8 FDC=0
.ENDS
***************************************
.SUBCKT ICV_106
** N=4 EP=0 IP=8 FDC=0
.ENDS
***************************************
.SUBCKT ICV_77 1 2 3 4 5
** N=7 EP=5 IP=11 FDC=4
X1 1 2 3 4 5 ICV_76 $T=2240 0 0 0 $X=1810 $Y=-390
.ENDS
***************************************
.SUBCKT ICV_88
** N=4 EP=0 IP=8 FDC=0
.ENDS
***************************************
.SUBCKT ICV_75
** N=4 EP=0 IP=8 FDC=0
.ENDS
***************************************
.SUBCKT ICV_91
** N=4 EP=0 IP=8 FDC=0
.ENDS
***************************************
.SUBCKT ICV_112 1 2 3 4 5 6 7 8
** N=10 EP=8 IP=14 FDC=8
X0 2 3 1 5 4 NAND2X1 $T=0 0 0 0 $X=-430 $Y=-390
X1 6 7 1 5 8 NAND2X1 $T=5600 0 1 180 $X=2370 $Y=-390
.ENDS
***************************************
.SUBCKT XOR2X1 B A VDD VSS Z
** N=11 EP=5 IP=0 FDC=10
M0 VSS B 10 VSS N L=1.8e-07 W=4.4e-07 $X=630 $Y=985 $D=0
M1 8 A VSS VSS N L=1.8e-07 W=4.4e-07 $X=1350 $Y=985 $D=0
M2 9 8 10 VSS N L=1.8e-07 W=4.4e-07 $X=3205 $Y=1000 $D=0
M3 B A 9 VSS N L=1.8e-07 W=4.4e-07 $X=3925 $Y=1000 $D=0
M4 Z 9 VSS VSS N L=1.8e-07 W=4.4e-07 $X=5345 $Y=1000 $D=0
M5 VDD B 10 VDD P L=1.8e-07 W=4.4e-07 $X=630 $Y=2435 $D=16
M6 8 A VDD VDD P L=1.8e-07 W=4.4e-07 $X=1350 $Y=2435 $D=16
M7 9 A 10 VDD P L=1.8e-07 W=4.4e-07 $X=3205 $Y=2435 $D=16
M8 B 8 9 VDD P L=1.8e-07 W=4.4e-07 $X=3925 $Y=2435 $D=16
M9 Z 9 VDD VDD P L=1.8e-07 W=4.4e-07 $X=5345 $Y=2435 $D=16
.ENDS
***************************************
.SUBCKT ICV_96 1 2 3 4 5
** N=7 EP=5 IP=11 FDC=4
X1 3 4 1 2 5 NAND2X1 $T=0 0 0 0 $X=-430 $Y=-390
.ENDS
***************************************
.SUBCKT ICV_94 1 2 3 4 5
** N=7 EP=5 IP=11 FDC=4
X1 1 2 3 4 5 ICV_72 $T=1680 0 0 0 $X=1250 $Y=-390
.ENDS
***************************************
.SUBCKT ICV_101 1 2 3 4 5
** N=7 EP=5 IP=11 FDC=4
X1 3 4 1 2 5 NAND2X1 $T=5040 0 1 180 $X=1810 $Y=-390
.ENDS
***************************************
.SUBCKT ICV_58
** N=4 EP=0 IP=8 FDC=0
.ENDS
***************************************
.SUBCKT ICV_79 1 2 3 4 5
** N=7 EP=5 IP=11 FDC=4
X1 3 4 1 2 5 NAND2X1 $T=0 0 0 0 $X=-430 $Y=-390
.ENDS
***************************************
.SUBCKT ICV_109 1 2 3 4 5
** N=7 EP=5 IP=11 FDC=4
X1 3 4 1 2 5 NAND2X1 $T=0 0 0 0 $X=-430 $Y=-390
.ENDS
***************************************
.SUBCKT ICV_105 1 2 3 4 5
** N=7 EP=5 IP=11 FDC=4
X1 3 4 1 2 5 NAND2X1 $T=6160 0 1 180 $X=2930 $Y=-390
.ENDS
***************************************
.SUBCKT ICV_95
** N=4 EP=0 IP=8 FDC=0
.ENDS
***************************************
.SUBCKT ICV_111 1 2 3 4 5 6
** N=8 EP=6 IP=13 FDC=40
X1 4 6 2 5 1 2 3 DFFQSRX1 $T=0 0 0 0 $X=-430 $Y=-390
.ENDS
***************************************
.SUBCKT ICV_113 1 2 3 4 5 6
** N=8 EP=6 IP=13 FDC=40
X1 4 6 2 5 1 2 3 DFFQSRX1 $T=0 0 0 0 $X=-430 $Y=-390
.ENDS
***************************************
.SUBCKT ICV_54
** N=4 EP=0 IP=8 FDC=0
.ENDS
***************************************
.SUBCKT ICV_56
** N=4 EP=0 IP=8 FDC=0
.ENDS
***************************************
.SUBCKT ICV_89
** N=4 EP=0 IP=8 FDC=0
.ENDS
***************************************
.SUBCKT ICV_104
** N=4 EP=0 IP=8 FDC=0
.ENDS
***************************************
.SUBCKT ICV_97 1 2 3 4 5 6
** N=8 EP=6 IP=12 FDC=6
X1 3 4 6 1 2 5 NAND3X1 $T=560 0 0 0 $X=130 $Y=-390
.ENDS
***************************************
.SUBCKT ICV_99 1 2 3 4 5
** N=7 EP=5 IP=11 FDC=4
X1 3 4 1 2 5 NAND2X1 $T=3360 0 0 0 $X=2930 $Y=-390
.ENDS
***************************************
.SUBCKT ICV_100 1 2 3 4 5 6
** N=8 EP=6 IP=12 FDC=6
X1 3 4 6 1 2 5 NAND3X1 $T=2240 0 0 0 $X=1810 $Y=-390
.ENDS
***************************************
.SUBCKT ICV_107 1 2 3 4 5 6
** N=8 EP=6 IP=12 FDC=12
X0 4 3 5 1 2 6 MUX2X1 $T=7280 0 1 180 $X=1250 $Y=-390
.ENDS
***************************************
.SUBCKT ICV_86
** N=4 EP=0 IP=8 FDC=0
.ENDS
***************************************
.SUBCKT ICV_60
** N=4 EP=0 IP=8 FDC=0
.ENDS
***************************************
.SUBCKT ICV_87
** N=4 EP=0 IP=8 FDC=0
.ENDS
***************************************
.SUBCKT ICV_80 1 2 3 4 5 6
** N=8 EP=6 IP=13 FDC=40
X1 4 6 2 5 1 2 3 DFFQSRX1 $T=560 0 0 0 $X=130 $Y=-390
.ENDS
***************************************
.SUBCKT ICV_103 1 2 3 4 5
** N=7 EP=5 IP=11 FDC=4
X1 3 4 1 2 5 NAND2X1 $T=0 0 0 0 $X=-430 $Y=-390
.ENDS
***************************************
.SUBCKT ICV_71 1 2 3 4 5
** N=7 EP=5 IP=11 FDC=4
X1 3 4 1 2 5 NAND2X1 $T=3920 0 1 180 $X=690 $Y=-390
.ENDS
***************************************
.SUBCKT ICV_73 1 2 3 4 5 6
** N=8 EP=6 IP=13 FDC=40
X0 4 6 2 5 1 2 3 DFFQSRX1 $T=1680 0 0 0 $X=1250 $Y=-390
.ENDS
***************************************
.SUBCKT ICV_108 1 2 3 4 5 6 7 8
** N=10 EP=8 IP=14 FDC=8
X0 2 3 1 5 4 NAND2X1 $T=0 0 0 0 $X=-430 $Y=-390
X1 6 7 1 5 8 NAND2X1 $T=2800 0 0 0 $X=2370 $Y=-390
.ENDS
***************************************
.SUBCKT ICV_93 1 2 3 4 5
** N=7 EP=5 IP=11 FDC=4
X1 3 4 1 2 5 NOR2X1 $T=1680 0 0 0 $X=1250 $Y=-390
.ENDS
***************************************
.SUBCKT ICV_102 1 2 3 4 5 6 7 8
** N=10 EP=8 IP=14 FDC=8
X0 2 3 1 5 4 NAND2X1 $T=-2800 0 0 0 $X=-3230 $Y=-390
X1 6 7 1 5 8 NAND2X1 $T=0 0 0 0 $X=-430 $Y=-390
.ENDS
***************************************
.SUBCKT ICV_98 1 2 3 4 5 6
** N=8 EP=6 IP=12 FDC=6
X1 3 4 6 1 2 5 NAND3X1 $T=5600 0 1 180 $X=1250 $Y=-390
.ENDS
***************************************
.SUBCKT ICV_82 1 2 3 4 5
** N=7 EP=5 IP=11 FDC=4
X1 3 4 1 2 5 NAND2X1 $T=0 0 0 0 $X=-430 $Y=-390
.ENDS
***************************************
.SUBCKT ICV_110 1 2 3 4 5 6
** N=8 EP=6 IP=12 FDC=12
X0 4 3 5 1 2 6 MUX2X1 $T=1680 0 0 0 $X=1250 $Y=-390
.ENDS
***************************************
.SUBCKT ANTENNA VSS A
** N=5 EP=2 IP=0 FDC=1
*.CALIBRE ISOLATED NETS: VDD
D0 VSS A DN AREA=3.9e-13 PJ=2.54e-06 $X=300 $Y=655 $D=26
.ENDS
***************************************
.SUBCKT INVX4 A VSS VDD Z
** N=6 EP=4 IP=0 FDC=4
M0 Z A VSS VSS N L=1.8e-07 W=4.4e-07 $X=670 $Y=760 $D=0
M1 VSS A Z VSS N L=1.8e-07 W=4.4e-07 $X=1390 $Y=760 $D=0
M2 Z A VDD VDD P L=1.8e-07 W=8.8e-07 $X=670 $Y=2300 $D=16
M3 VDD A Z VDD P L=1.8e-07 W=8.8e-07 $X=1390 $Y=2300 $D=16
.ENDS
***************************************
.SUBCKT ICV_67
** N=4 EP=0 IP=8 FDC=0
.ENDS
***************************************
.SUBCKT ICV_114 44 74 75 76 77 78 79 80 81 82 83 84 85 86 87 88 89 90 91 92
+ 93 94 95 96 97 98 99 100 101 102 103 104 105 106 107 108 109 110 111 112
+ 113 114 115 116 117 118 119 120 121 122 123 124 125 126 127 128 129 130 131 132
+ 133 134 135 136 137 138 139 140 141 142 143 144 145 146 147 148 149 150 151 152
+ 153 154 155 156 157 158 159 160 161 162 163 164 165 166 167 168 169 170 171 172
+ 173 174 175 176 177 178 179 180 181 182 183 184 185 186 187 188 189 190 191 192
+ 193 194 195 196 197 198 199 200 201 202 203 204 205 206 207 208 209 210 211 212
+ 213 214 215 216 217 218 219 220 221 222 223 224 225 226 227 228 229 230 231 232
+ 233 234 235 236 237 238 239 240 241 242 243 244 245 246 247 248 249 250 251 252
+ 253 254 255 256 257 258 259 260 261 262 263 264 265 266 267 268 269 270 271 272
+ 273 274 275 276 277 278 279 280 281 282 283 284 285 286 287 288 289 290 291 292
+ 293 294 295 296 297 298 299 300 301 302 303 304 305 306 307 308 309 310 311 312
+ 313 314 315 316 317 318 319 320 321 322 323 324 325 326 327 328 329 330 331 332
+ 333 334 335 336 337 338 339 340 341 342 343 344 345 346 347 348 349 350 351 352
+ 353 354 355 356 357 358 359 360 361 362 363 364 365 366 367 368 369 370 371 372
+ 373 374 375 376 377 378 379 380 381 382 383 384 385 386 387 388 389 390 391 392
+ 393 394 395 396 397 398 399 400 401 402 403 404 405 406 407 408 409 410 411 412
+ 413 414 415 416 417 418 419 420 421 422 423 424 425 426 427 428 429 430 431 432
+ 433 434 435 436 437 438 439 440 441 442 443 444 445 446 447 448 449 450 451 452
+ 453 454 455 456 457 458 459 460 461 462 463 464 465 466 467 468 469 470 471 472
+ 473 474 475 476 477 478 479 480 481 482 483 484 485 486 487 488 489 490 491 492
+ 493 494 495 496 497 498 499 500 501 502 503 504 505 506 578 579 580 581 585 586
+ 588 589 590
** N=196156 EP=443 IP=26704 FDC=24292
X759 25846 26480 74 579 44 74 25825 DFFQSRX1 $T=723120 538125 1 0 $X=722690 $Y=533570
X760 53802 26480 579 74 44 74 25827 DFFQSRX1 $T=723120 545965 0 0 $X=722690 $Y=545575
X761 25868 578 74 579 44 74 25828 DFFQSRX1 $T=723120 694925 1 0 $X=722690 $Y=690370
X762 25847 578 74 579 44 74 75 DFFQSRX1 $T=748320 710605 1 180 $X=722690 $Y=710215
X763 25996 578 74 579 44 74 76 DFFQSRX1 $T=748320 718445 1 180 $X=722690 $Y=718055
X764 25827 26480 579 74 44 74 25419 DFFQSRX1 $T=760640 561645 1 180 $X=735010 $Y=561255
X765 25901 26480 74 579 44 74 25477 DFFQSRX1 $T=762320 569485 0 180 $X=736690 $Y=564930
X766 26257 27182 74 579 44 74 25478 DFFQSRX1 $T=762320 671405 0 180 $X=736690 $Y=666850
X767 26123 27182 74 579 44 74 25548 DFFQSRX1 $T=764560 663565 1 180 $X=738930 $Y=663175
X768 26283 26480 74 579 44 74 26349 DFFQSRX1 $T=753920 545965 1 0 $X=753490 $Y=541410
X769 26284 26480 74 579 44 74 26338 DFFQSRX1 $T=753920 561645 1 0 $X=753490 $Y=557090
X770 26270 26480 74 579 44 74 26294 DFFQSRX1 $T=753920 593005 1 0 $X=753490 $Y=588450
X771 26216 26480 74 579 44 74 26218 DFFQSRX1 $T=753920 600845 0 0 $X=753490 $Y=600455
X772 26306 103 74 579 44 74 26390 DFFQSRX1 $T=756160 514605 1 0 $X=755730 $Y=510050
X773 26350 27325 74 579 44 74 26468 DFFQSRX1 $T=757280 655725 0 0 $X=756850 $Y=655335
X774 26445 27325 74 579 44 74 26486 DFFQSRX1 $T=758960 624365 1 0 $X=758530 $Y=619810
X775 26465 27325 74 579 44 74 26207 DFFQSRX1 $T=758960 632205 0 0 $X=758530 $Y=631815
X776 26412 27182 74 579 44 74 26340 DFFQSRX1 $T=759520 710605 1 0 $X=759090 $Y=706050
X777 26443 103 74 579 44 74 26231 DFFQSRX1 $T=786400 506765 0 180 $X=760770 $Y=502210
X778 26339 27182 74 579 44 74 98 DFFQSRX1 $T=762320 671405 1 0 $X=761890 $Y=666850
X779 26761 580 74 579 44 74 95 DFFQSRX1 $T=792000 726285 1 180 $X=766370 $Y=725895
X780 26563 26480 74 579 44 74 26582 DFFQSRX1 $T=767360 553805 0 0 $X=766930 $Y=553415
X781 26605 27182 74 579 44 74 26363 DFFQSRX1 $T=792560 679245 1 180 $X=766930 $Y=678855
X782 26617 26480 74 579 44 74 26619 DFFQSRX1 $T=770720 569485 1 0 $X=770290 $Y=564930
X783 26618 27617 74 579 44 74 26641 DFFQSRX1 $T=771280 585165 0 0 $X=770850 $Y=584775
X784 26673 27617 74 579 44 74 26650 DFFQSRX1 $T=771840 593005 0 0 $X=771410 $Y=592615
X785 26726 27647 74 579 44 74 26454 DFFQSRX1 $T=800960 538125 1 180 $X=775330 $Y=537735
X786 26860 27182 74 579 44 74 101 DFFQSRX1 $T=803200 702765 0 180 $X=777570 $Y=698210
X787 26883 27182 74 579 44 74 102 DFFQSRX1 $T=803760 710605 1 180 $X=778130 $Y=710215
X788 26626 27182 74 579 44 74 26328 DFFQSRX1 $T=803760 718445 1 180 $X=778130 $Y=718055
X789 26903 103 74 579 44 74 26808 DFFQSRX1 $T=779120 491085 0 0 $X=778690 $Y=490695
X790 26763 103 74 579 44 74 26772 DFFQSRX1 $T=779120 506765 0 0 $X=778690 $Y=506375
X791 26760 27325 74 579 44 74 26792 DFFQSRX1 $T=780240 663565 1 0 $X=779810 $Y=659010
X792 26716 27325 74 579 44 74 26555 DFFQSRX1 $T=780800 647885 1 0 $X=780370 $Y=643330
X793 26927 27182 74 579 44 74 26609 DFFQSRX1 $T=806560 671405 1 180 $X=780930 $Y=671015
X794 26926 27325 74 579 44 74 26840 DFFQSRX1 $T=781920 632205 1 0 $X=781490 $Y=627650
X795 26938 27325 74 579 44 74 108 DFFQSRX1 $T=784160 624365 1 0 $X=783730 $Y=619810
X796 26832 27617 74 579 44 74 27000 DFFQSRX1 $T=784720 577325 1 0 $X=784290 $Y=572770
X797 26861 27617 74 579 44 74 26976 DFFQSRX1 $T=784720 593005 1 0 $X=784290 $Y=588450
X798 26948 27617 74 579 44 74 26974 DFFQSRX1 $T=786960 600845 0 0 $X=786530 $Y=600455
X799 27069 27647 74 579 44 74 27055 DFFQSRX1 $T=787520 530285 0 0 $X=787090 $Y=529895
X800 26973 27647 74 579 44 74 26949 DFFQSRX1 $T=788080 545965 0 0 $X=787650 $Y=545575
X801 27283 27647 74 579 44 74 26991 DFFQSRX1 $T=794800 506765 1 0 $X=794370 $Y=502210
X802 27083 27647 74 579 44 74 26868 DFFQSRX1 $T=794800 514605 0 0 $X=794370 $Y=514215
X803 27172 27617 74 579 44 74 27042 DFFQSRX1 $T=796480 569485 0 0 $X=796050 $Y=569095
X804 27409 27617 74 579 44 74 27508 DFFQSRX1 $T=804880 585165 0 0 $X=804450 $Y=584775
X805 27421 27647 74 579 44 74 116 DFFQSRX1 $T=805440 498925 0 0 $X=805010 $Y=498535
X806 27509 27182 74 579 44 74 119 DFFQSRX1 $T=806000 679245 0 0 $X=805570 $Y=678855
X807 27545 27325 74 579 44 74 126 DFFQSRX1 $T=808240 663565 0 0 $X=807810 $Y=663175
X808 27523 27325 74 579 44 74 27425 DFFQSRX1 $T=809360 624365 1 0 $X=808930 $Y=619810
X809 27529 27617 74 579 44 74 27659 DFFQSRX1 $T=813280 577325 1 0 $X=812850 $Y=572770
X810 27672 29141 74 579 44 74 27044 DFFQSRX1 $T=839040 647885 0 180 $X=813410 $Y=643330
X811 27669 27647 74 579 44 74 27762 DFFQSRX1 $T=815520 514605 1 0 $X=815090 $Y=510050
X812 27466 27647 74 579 44 74 27554 DFFQSRX1 $T=815520 530285 1 0 $X=815090 $Y=525730
X813 27917 27647 74 579 44 74 27987 DFFQSRX1 $T=824480 538125 0 0 $X=824050 $Y=537735
X814 27956 27647 74 579 44 74 28033 DFFQSRX1 $T=826160 553805 1 0 $X=825730 $Y=549250
X815 27480 27647 74 579 44 74 27608 DFFQSRX1 $T=827280 545965 1 0 $X=826850 $Y=541410
X816 28035 27617 74 579 44 74 28125 DFFQSRX1 $T=831200 561645 1 0 $X=830770 $Y=557090
X817 28128 28698 74 579 44 74 26904 DFFQSRX1 $T=856960 585165 0 180 $X=831330 $Y=580610
X818 28214 130 74 579 44 74 145 DFFQSRX1 $T=834000 491085 1 0 $X=833570 $Y=486530
X819 28032 130 74 579 44 74 28123 DFFQSRX1 $T=834000 491085 0 0 $X=833570 $Y=490695
X820 28231 130 74 579 44 74 28318 DFFQSRX1 $T=834000 506765 1 0 $X=833570 $Y=502210
X821 28268 130 74 579 44 74 28354 DFFQSRX1 $T=834000 522445 0 0 $X=833570 $Y=522055
X822 28105 29141 74 579 44 74 28201 DFFQSRX1 $T=834000 593005 0 0 $X=833570 $Y=592615
X823 28106 29141 74 579 44 74 27764 DFFQSRX1 $T=834000 600845 0 0 $X=833570 $Y=600455
X824 28422 29141 74 579 44 74 27714 DFFQSRX1 $T=859200 608685 1 180 $X=833570 $Y=608295
X825 28244 29141 74 579 44 74 28331 DFFQSRX1 $T=834000 616525 0 0 $X=833570 $Y=616135
X826 28379 29141 74 579 44 74 27902 DFFQSRX1 $T=859200 624365 1 180 $X=833570 $Y=623975
X827 28340 29115 74 579 44 74 27903 DFFQSRX1 $T=859200 640045 1 180 $X=833570 $Y=639655
X828 28107 29141 74 579 44 74 28137 DFFQSRX1 $T=834000 671405 1 0 $X=833570 $Y=666850
X829 28626 28698 74 579 44 74 28768 DFFQSRX1 $T=861440 553805 1 0 $X=861010 $Y=549250
X830 28679 28698 74 579 44 74 28827 DFFQSRX1 $T=864800 577325 1 0 $X=864370 $Y=572770
X831 28803 29115 74 579 44 74 28769 DFFQSRX1 $T=864800 640045 0 0 $X=864370 $Y=639655
X832 29186 28698 74 579 44 74 29294 DFFQSRX1 $T=870960 585165 1 0 $X=870530 $Y=580610
X833 28727 28698 74 579 44 74 28726 DFFQSRX1 $T=872080 585165 0 0 $X=871650 $Y=584775
X834 29250 28698 74 579 44 74 29348 DFFQSRX1 $T=872080 608685 1 0 $X=871650 $Y=604130
X835 29295 29115 74 579 44 74 29320 DFFQSRX1 $T=874880 671405 0 0 $X=874450 $Y=671015
X836 29373 29115 74 579 44 74 29467 DFFQSRX1 $T=877680 647885 1 0 $X=877250 $Y=643330
X837 29479 29115 74 579 44 74 29456 DFFQSRX1 $T=877680 655725 1 0 $X=877250 $Y=651170
X838 29374 29115 74 579 44 74 29003 DFFQSRX1 $T=904000 687085 0 180 $X=878370 $Y=682530
X839 29437 29115 74 579 44 74 158 DFFQSRX1 $T=879360 702765 1 0 $X=878930 $Y=698210
X840 29573 29115 74 579 44 74 29603 DFFQSRX1 $T=881040 687085 0 0 $X=880610 $Y=686695
X841 29562 29115 74 579 44 74 29590 DFFQSRX1 $T=884400 663565 1 0 $X=883970 $Y=659010
X842 29646 29115 74 579 44 74 29791 DFFQSRX1 $T=886080 640045 1 0 $X=885650 $Y=635490
X843 29844 30452 74 579 44 74 28573 DFFQSRX1 $T=919120 616525 0 180 $X=893490 $Y=611970
X844 29776 28698 74 579 44 74 29859 DFFQSRX1 $T=894480 608685 0 0 $X=894050 $Y=608295
X845 29861 581 74 579 44 74 29880 DFFQSRX1 $T=898400 710605 1 0 $X=897970 $Y=706050
X846 30144 30452 74 579 44 74 29659 DFFQSRX1 $T=929760 632205 0 180 $X=904130 $Y=627650
X847 30145 30452 74 579 44 74 29679 DFFQSRX1 $T=930320 647885 0 180 $X=904690 $Y=643330
X848 30083 29115 74 579 44 74 30099 DFFQSRX1 $T=905120 655725 0 0 $X=904690 $Y=655335
X849 30166 30452 74 579 44 74 29822 DFFQSRX1 $T=931440 679245 0 180 $X=905810 $Y=674690
X850 30050 581 74 579 44 74 30061 DFFQSRX1 $T=906240 694925 1 0 $X=905810 $Y=690370
X851 30268 30452 74 579 44 74 29845 DFFQSRX1 $T=932560 687085 1 180 $X=906930 $Y=686695
X852 30210 581 74 579 44 74 30191 DFFQSRX1 $T=912960 702765 0 0 $X=912530 $Y=702375
X853 30096 30452 74 579 44 74 30182 DFFQSRX1 $T=915760 600845 1 0 $X=915330 $Y=596290
X854 30143 30452 74 579 44 74 29825 DFFQSRX1 $T=915760 624365 1 0 $X=915330 $Y=619810
X855 30366 30452 74 579 44 74 30127 DFFQSRX1 $T=944880 608685 1 180 $X=919250 $Y=608295
X856 30568 30452 74 579 44 74 30129 DFFQSRX1 $T=950480 640045 1 180 $X=924850 $Y=639655
X857 30432 30452 74 579 44 74 30315 DFFQSRX1 $T=925840 647885 0 0 $X=925410 $Y=647495
X858 30500 30452 74 579 44 74 30582 DFFQSRX1 $T=927520 608685 1 0 $X=927090 $Y=604130
X859 30659 30452 74 579 44 74 30190 DFFQSRX1 $T=934800 663565 1 0 $X=934370 $Y=659010
X860 30609 30452 74 579 44 74 30554 DFFQSRX1 $T=934800 687085 1 0 $X=934370 $Y=682530
X861 30780 308 74 579 44 74 30290 DFFQSRX1 $T=960000 694925 0 180 $X=934370 $Y=690370
X862 30820 308 74 579 44 74 30235 DFFQSRX1 $T=960560 671405 1 180 $X=934930 $Y=671015
X863 31438 33622 74 579 44 74 31557 DFFQSRX1 $T=976240 593005 0 0 $X=975810 $Y=592615
X864 32371 308 74 579 44 74 31031 DFFQSRX1 $T=976240 679245 0 0 $X=975810 $Y=678855
X865 32155 308 74 579 44 74 32285 DFFQSRX1 $T=986880 694925 1 0 $X=986450 $Y=690370
X866 32386 33622 74 579 44 74 32500 DFFQSRX1 $T=994720 608685 1 0 $X=994290 $Y=604130
X867 32681 33622 74 579 44 74 32795 DFFQSRX1 $T=1001440 616525 1 0 $X=1001010 $Y=611970
X868 32662 308 74 579 44 74 32713 DFFQSRX1 $T=1003680 702765 0 0 $X=1003250 $Y=702375
X869 32830 359 74 579 44 74 349 DFFQSRX1 $T=1028880 726285 1 180 $X=1003250 $Y=725895
X870 32698 308 74 579 44 74 367 DFFQSRX1 $T=1004240 718445 0 0 $X=1003810 $Y=718055
X871 33293 359 74 579 44 74 32631 DFFQSRX1 $T=1045120 702765 0 180 $X=1019490 $Y=698210
X872 33403 33622 74 579 44 74 33062 DFFQSRX1 $T=1051840 616525 0 180 $X=1026210 $Y=611970
X873 33303 359 74 579 44 74 379 DFFQSRX1 $T=1051840 718445 0 180 $X=1026210 $Y=713890
X874 33402 33622 74 579 44 74 33076 DFFQSRX1 $T=1052400 600845 1 180 $X=1026770 $Y=600455
X875 33291 359 74 579 44 74 397 DFFQSRX1 $T=1027200 726285 1 0 $X=1026770 $Y=721730
X876 33548 359 74 579 44 74 388 DFFQSRX1 $T=1059120 702765 1 180 $X=1033490 $Y=702375
X877 33601 33622 74 579 44 74 33273 DFFQSRX1 $T=1060800 600845 0 180 $X=1035170 $Y=596290
X878 33557 33622 74 579 44 74 33274 DFFQSRX1 $T=1060800 608685 1 180 $X=1035170 $Y=608295
X879 33685 359 74 579 44 74 421 DFFQSRX1 $T=1047360 710605 1 0 $X=1046930 $Y=706050
X880 33662 359 74 579 44 74 404 DFFQSRX1 $T=1072560 718445 1 180 $X=1046930 $Y=718055
X881 585 359 74 579 44 74 271 DFFQSRX1 $T=1072560 726285 1 180 $X=1046930 $Y=725895
X882 33977 35822 74 579 44 74 33537 DFFQSRX1 $T=1081520 600845 1 180 $X=1055890 $Y=600455
X883 34334 35822 74 579 44 74 30415 DFFQSRX1 $T=1081520 608685 0 180 $X=1055890 $Y=604130
X884 34001 449 74 579 44 74 33377 DFFQSRX1 $T=1081520 687085 1 180 $X=1055890 $Y=686695
X885 33957 449 74 579 44 74 33466 DFFQSRX1 $T=1081520 702765 0 180 $X=1055890 $Y=698210
X886 34132 449 74 579 44 74 415 DFFQSRX1 $T=1081520 710605 1 180 $X=1055890 $Y=710215
X887 34269 449 74 579 44 74 416 DFFQSRX1 $T=1081520 718445 0 180 $X=1055890 $Y=713890
X888 34383 449 74 579 44 74 33956 DFFQSRX1 $T=1097760 663565 1 180 $X=1072130 $Y=663175
X889 34428 449 74 579 44 74 33578 DFFQSRX1 $T=1097760 671405 0 180 $X=1072130 $Y=666850
X890 34686 35822 74 579 44 74 33915 DFFQSRX1 $T=1087120 616525 0 0 $X=1086690 $Y=616135
X891 34747 449 74 579 44 74 34232 DFFQSRX1 $T=1087120 710605 1 0 $X=1086690 $Y=706050
X892 35420 35822 74 579 44 74 35419 DFFQSRX1 $T=1106160 632205 1 0 $X=1105730 $Y=627650
X893 35343 35822 74 579 44 74 34808 DFFQSRX1 $T=1131920 624365 1 180 $X=1106290 $Y=623975
X894 35360 35562 74 579 44 74 34948 DFFQSRX1 $T=1131920 671405 1 180 $X=1106290 $Y=671015
X895 35330 35822 74 579 44 74 34461 DFFQSRX1 $T=1133040 608685 1 180 $X=1107410 $Y=608295
X896 586 449 74 579 44 74 458 DFFQSRX1 $T=1109520 718445 0 0 $X=1109090 $Y=718055
X897 35462 36395 74 579 44 74 29789 DFFQSRX1 $T=1135280 585165 1 180 $X=1109650 $Y=584775
X898 35461 36395 74 579 44 74 33119 DFFQSRX1 $T=1135840 569485 1 180 $X=1110210 $Y=569095
X899 35359 35562 74 579 44 74 35389 DFFQSRX1 $T=1111200 655725 0 0 $X=1110770 $Y=655335
X900 35632 36395 74 579 44 74 33316 DFFQSRX1 $T=1141440 577325 1 180 $X=1115810 $Y=576935
X901 35788 467 74 579 44 74 33243 DFFQSRX1 $T=1148720 553805 1 180 $X=1123090 $Y=553415
X902 35812 467 74 579 44 74 34685 DFFQSRX1 $T=1150400 545965 0 180 $X=1124770 $Y=541410
X903 35828 467 74 579 44 74 33416 DFFQSRX1 $T=1150960 538125 0 180 $X=1125330 $Y=533570
X904 35838 467 74 579 44 74 30608 DFFQSRX1 $T=1151520 530285 0 180 $X=1125890 $Y=525730
X905 35849 467 74 579 44 74 34640 DFFQSRX1 $T=1152080 514605 0 180 $X=1126450 $Y=510050
X906 35850 467 74 579 44 74 30416 DFFQSRX1 $T=1152080 514605 1 180 $X=1126450 $Y=514215
X907 35965 36395 74 579 44 74 35432 DFFQSRX1 $T=1152080 593005 0 180 $X=1126450 $Y=588450
X908 36270 467 74 579 44 74 263 DFFQSRX1 $T=1152640 491085 1 180 $X=1127010 $Y=490695
X909 35862 467 74 579 44 74 251 DFFQSRX1 $T=1152640 498925 1 180 $X=1127010 $Y=498535
X910 35749 469 74 579 44 74 342 DFFQSRX1 $T=1152640 710605 0 180 $X=1127010 $Y=706050
X911 588 467 74 579 44 74 176 DFFQSRX1 $T=1153760 491085 0 180 $X=1128130 $Y=486530
X912 35954 36395 74 579 44 74 35614 DFFQSRX1 $T=1157680 616525 1 180 $X=1132050 $Y=616135
X913 35662 35822 74 579 44 74 35752 DFFQSRX1 $T=1133040 608685 0 0 $X=1132610 $Y=608295
X914 36003 35562 74 579 44 74 35671 DFFQSRX1 $T=1159920 632205 0 180 $X=1134290 $Y=627650
X915 35914 469 74 579 44 74 470 DFFQSRX1 $T=1134720 718445 0 0 $X=1134290 $Y=718055
X916 35937 35562 74 579 44 74 35966 DFFQSRX1 $T=1138080 663565 0 0 $X=1137650 $Y=663175
X917 36175 36395 74 579 44 74 36205 DFFQSRX1 $T=1142000 577325 1 0 $X=1141570 $Y=572770
X918 36221 36395 74 579 44 74 35435 DFFQSRX1 $T=1167200 585165 1 180 $X=1141570 $Y=584775
X919 36235 35562 74 579 44 74 31803 DFFQSRX1 $T=1169440 655725 1 180 $X=1143810 $Y=655335
X920 36417 35562 74 579 44 74 30843 DFFQSRX1 $T=1171120 640045 0 180 $X=1145490 $Y=635490
X921 36261 469 74 579 44 74 465 DFFQSRX1 $T=1171120 679245 1 180 $X=1145490 $Y=678855
X922 36247 467 74 579 44 74 36271 DFFQSRX1 $T=1149840 569485 0 0 $X=1149410 $Y=569095
X923 36426 36395 74 579 44 74 35602 DFFQSRX1 $T=1175040 593005 1 180 $X=1149410 $Y=592615
X924 36461 469 74 579 44 74 36059 DFFQSRX1 $T=1177280 671405 0 180 $X=1151650 $Y=666850
X925 36308 469 74 579 44 74 474 DFFQSRX1 $T=1153200 726285 0 0 $X=1152770 $Y=725895
X926 36487 36707 74 579 44 74 36174 DFFQSRX1 $T=1181200 538125 1 180 $X=1155570 $Y=537735
X927 36466 36707 74 579 44 74 35773 DFFQSRX1 $T=1181200 545965 1 180 $X=1155570 $Y=545575
X928 36408 467 74 579 44 74 36342 DFFQSRX1 $T=1156000 561645 0 0 $X=1155570 $Y=561255
X929 36377 469 74 579 44 74 35985 DFFQSRX1 $T=1181200 687085 0 180 $X=1155570 $Y=682530
X930 36446 36707 74 579 44 74 36449 DFFQSRX1 $T=1159920 506765 1 0 $X=1159490 $Y=502210
X931 36624 36707 74 579 44 74 36599 DFFQSRX1 $T=1159920 514605 0 0 $X=1159490 $Y=514215
X932 36576 36707 74 579 44 74 36550 DFFQSRX1 $T=1160480 506765 0 0 $X=1160050 $Y=506375
X933 589 479 74 579 44 74 473 DFFQSRX1 $T=1186240 491085 0 180 $X=1160610 $Y=486530
X934 36625 36707 74 579 44 74 35827 DFFQSRX1 $T=1187920 522445 1 180 $X=1162290 $Y=522055
X935 36498 36395 74 579 44 74 36517 DFFQSRX1 $T=1162720 624365 1 0 $X=1162290 $Y=619810
X936 36952 36707 74 579 44 74 36416 DFFQSRX1 $T=1192400 530285 1 180 $X=1166770 $Y=529895
X937 36882 36707 74 579 44 74 35800 DFFQSRX1 $T=1192400 553805 0 180 $X=1166770 $Y=549250
X938 36781 36395 74 579 44 74 36840 DFFQSRX1 $T=1167200 577325 1 0 $X=1166770 $Y=572770
X939 36854 37292 74 579 44 74 35787 DFFQSRX1 $T=1192400 593005 0 180 $X=1166770 $Y=588450
X940 36883 35562 74 579 44 74 36541 DFFQSRX1 $T=1167200 632205 1 0 $X=1166770 $Y=627650
X941 36998 469 74 579 44 74 36960 DFFQSRX1 $T=1167200 687085 0 0 $X=1166770 $Y=686695
X942 36676 469 74 579 44 74 478 DFFQSRX1 $T=1167200 702765 0 0 $X=1166770 $Y=702375
X943 36539 37414 74 579 44 74 36579 DFFQSRX1 $T=1202480 671405 0 180 $X=1176850 $Y=666850
X944 37256 486 74 579 44 74 484 DFFQSRX1 $T=1198560 498925 0 0 $X=1198130 $Y=498535
X945 37376 486 74 579 44 74 35826 DFFQSRX1 $T=1198560 514605 1 0 $X=1198130 $Y=510050
X946 36832 37292 74 579 44 74 36831 DFFQSRX1 $T=1198560 600845 1 0 $X=1198130 $Y=596290
X947 37226 37414 74 579 44 74 37260 DFFQSRX1 $T=1198560 694925 1 0 $X=1198130 $Y=690370
X948 37211 37414 74 579 44 74 37244 DFFQSRX1 $T=1198560 710605 0 0 $X=1198130 $Y=710215
X949 37511 37292 74 579 44 74 29940 DFFQSRX1 $T=1199120 624365 1 0 $X=1198690 $Y=619810
X950 37703 37414 74 579 44 74 33913 DFFQSRX1 $T=1199680 640045 1 0 $X=1199250 $Y=635490
X951 37210 37414 74 579 44 74 37243 DFFQSRX1 $T=1202480 671405 1 0 $X=1202050 $Y=666850
X952 37765 37745 74 579 44 74 36275 DFFQSRX1 $T=1232720 593005 0 180 $X=1207090 $Y=588450
X953 37747 590 74 579 44 74 37466 DFFQSRX1 $T=1233280 687085 1 180 $X=1207650 $Y=686695
X954 37802 492 74 579 44 74 36334 DFFQSRX1 $T=1235520 530285 0 180 $X=1209890 $Y=525730
X955 37923 37745 74 579 44 74 490 DFFQSRX1 $T=1237200 577325 0 180 $X=1211570 $Y=572770
X956 37767 37414 74 579 44 74 37884 DFFQSRX1 $T=1212000 663565 1 0 $X=1211570 $Y=659010
X957 37832 492 74 579 44 74 35837 DFFQSRX1 $T=1237760 498925 0 180 $X=1212130 $Y=494370
X958 37856 37292 74 579 44 74 37821 DFFQSRX1 $T=1212560 600845 0 0 $X=1212130 $Y=600455
X959 37881 492 74 579 44 74 491 DFFQSRX1 $T=1238320 491085 0 180 $X=1212690 $Y=486530
X960 37798 486 74 579 44 74 37855 DFFQSRX1 $T=1214240 506765 0 0 $X=1213810 $Y=506375
X961 38171 37745 74 579 44 74 494 DFFQSRX1 $T=1244480 569485 1 180 $X=1218850 $Y=569095
X962 37937 492 74 579 44 74 38069 DFFQSRX1 $T=1223760 538125 0 0 $X=1223330 $Y=537735
X963 37909 590 74 579 44 74 37936 DFFQSRX1 $T=1223760 679245 0 0 $X=1223330 $Y=678855
X964 37910 590 74 579 44 74 498 DFFQSRX1 $T=1223760 694925 1 0 $X=1223330 $Y=690370
X965 38170 492 74 579 44 74 37797 DFFQSRX1 $T=1252880 506765 0 180 $X=1227250 $Y=502210
X966 37785 590 74 579 44 74 499 DFFQSRX1 $T=1228240 710605 1 0 $X=1227810 $Y=706050
X967 38245 590 74 579 44 74 502 DFFQSRX1 $T=1228240 718445 1 0 $X=1227810 $Y=713890
X968 38172 590 74 579 44 74 505 DFFQSRX1 $T=1228240 726285 1 0 $X=1227810 $Y=721730
X969 25419 37745 579 74 44 74 38153 DFFQSRX1 $T=1228800 600845 1 0 $X=1228370 $Y=596290
X970 38291 37745 74 579 44 74 38007 DFFQSRX1 $T=1259040 514605 1 180 $X=1233410 $Y=514215
X971 38665 37745 74 579 44 74 38310 DFFQSRX1 $T=1269120 514605 0 180 $X=1243490 $Y=510050
X972 38655 37745 74 579 44 74 37883 DFFQSRX1 $T=1243920 593005 1 0 $X=1243490 $Y=588450
X973 38836 37745 74 579 44 74 38327 DFFQSRX1 $T=1269680 522445 1 180 $X=1244050 $Y=522055
X974 504 37745 74 579 44 74 38518 DFFQSRX1 $T=1245040 577325 1 0 $X=1244610 $Y=572770
X975 38721 37745 74 579 44 74 38361 DFFQSRX1 $T=1270800 577325 1 180 $X=1245170 $Y=576935
X976 38975 37745 74 579 44 74 38517 DFFQSRX1 $T=1278080 569485 0 180 $X=1252450 $Y=564930
X977 39031 37745 74 579 44 74 38564 DFFQSRX1 $T=1278640 553805 1 180 $X=1253010 $Y=553415
X1170 24548 24419 24417 44 74 24692 MUX2X1 $T=709120 640045 1 0 $X=708690 $Y=635490
X1171 24862 24265 25032 44 74 24863 MUX2X1 $T=729280 608685 1 180 $X=723250 $Y=608295
X1172 25478 80 25829 44 74 25783 MUX2X1 $T=752240 694925 1 180 $X=746210 $Y=694535
X1173 25548 80 25828 44 74 25868 MUX2X1 $T=754480 679245 1 180 $X=748450 $Y=678855
X1174 26066 86 25992 44 74 25952 MUX2X1 $T=756720 522445 1 180 $X=750690 $Y=522055
X1175 26067 86 25477 44 74 25953 MUX2X1 $T=756720 585165 1 180 $X=750690 $Y=584775
X1176 26207 80 26174 44 74 26147 MUX2X1 $T=763440 679245 1 180 $X=757410 $Y=678855
X1177 26067 94 26218 44 74 26216 MUX2X1 $T=766240 593005 1 180 $X=760210 $Y=592615
X1178 26338 94 26285 44 74 26256 MUX2X1 $T=767920 569485 0 180 $X=761890 $Y=564930
X1179 26349 94 26294 44 74 26270 MUX2X1 $T=768480 585165 1 180 $X=762450 $Y=584775
X1180 26349 86 25825 44 74 26283 MUX2X1 $T=769040 538125 1 180 $X=763010 $Y=537735
X1181 26338 86 26085 44 74 26284 MUX2X1 $T=769040 553805 0 180 $X=763010 $Y=549250
X1182 26390 86 25915 44 74 26306 MUX2X1 $T=770160 522445 1 180 $X=764130 $Y=522055
X1183 26444 94 26217 44 74 26362 MUX2X1 $T=772960 569485 1 180 $X=766930 $Y=569095
X1184 26486 80 26340 44 74 26412 MUX2X1 $T=775200 702765 0 180 $X=769170 $Y=698210
X1185 26363 80 26327 44 74 26516 MUX2X1 $T=770160 687085 0 0 $X=769730 $Y=686695
X1186 99 94 26231 44 74 26443 MUX2X1 $T=776880 522445 0 180 $X=770850 $Y=517890
X1187 100 94 26484 44 74 26464 MUX2X1 $T=778000 491085 0 180 $X=771970 $Y=486530
X1188 26555 80 26328 44 74 26626 MUX2X1 $T=776320 718445 1 0 $X=775890 $Y=713890
X1189 104 94 26582 44 74 26563 MUX2X1 $T=783600 545965 1 180 $X=777570 $Y=545575
X1190 26390 94 26641 44 74 26618 MUX2X1 $T=786400 569485 1 180 $X=780370 $Y=569095
X1191 26699 86 26650 44 74 26625 MUX2X1 $T=786960 600845 1 180 $X=780930 $Y=600455
X1192 26444 86 26454 44 74 26739 MUX2X1 $T=781920 530285 0 0 $X=781490 $Y=529895
X1193 104 86 92 44 74 105 MUX2X1 $T=789760 491085 0 180 $X=783730 $Y=486530
X1194 26609 80 101 44 74 26860 MUX2X1 $T=787520 694925 0 0 $X=787090 $Y=694535
X1195 26840 80 95 44 74 26761 MUX2X1 $T=793680 718445 0 180 $X=787650 $Y=713890
X1196 26792 80 102 44 74 26883 MUX2X1 $T=788640 702765 0 0 $X=788210 $Y=702375
X1197 26699 94 26839 44 74 26816 MUX2X1 $T=796480 694925 0 180 $X=790450 $Y=690370
X1198 26468 80 107 44 74 106 MUX2X1 $T=797600 726285 1 180 $X=791570 $Y=725895
X1199 27042 94 26974 44 74 26948 MUX2X1 $T=802640 600845 0 180 $X=796610 $Y=596290
X1200 109 94 26949 44 74 26973 MUX2X1 $T=803760 545965 0 180 $X=797730 $Y=541410
X1201 27042 86 26947 44 74 27172 MUX2X1 $T=811600 561645 1 180 $X=805570 $Y=561255
X1202 115 86 26808 44 74 110 MUX2X1 $T=819440 491085 0 180 $X=813410 $Y=486530
X1203 27508 86 27000 44 74 27409 MUX2X1 $T=819440 577325 1 180 $X=813410 $Y=576935
X1204 116 86 26991 44 74 27421 MUX2X1 $T=820000 506765 1 180 $X=813970 $Y=506375
X1205 115 94 27444 44 74 27422 MUX2X1 $T=820000 593005 0 180 $X=813970 $Y=588450
X1206 27554 86 26772 44 74 27466 MUX2X1 $T=821680 522445 1 180 $X=815650 $Y=522055
X1207 116 94 27489 44 74 27467 MUX2X1 $T=821680 608685 0 180 $X=815650 $Y=604130
X1208 27554 94 27425 44 74 27523 MUX2X1 $T=823920 616525 1 180 $X=817890 $Y=616135
X1209 27762 86 26868 44 74 27669 MUX2X1 $T=830080 506765 0 180 $X=824050 $Y=502210
X1210 27763 86 27055 44 74 27670 MUX2X1 $T=830080 522445 1 180 $X=824050 $Y=522055
X1211 27508 94 27696 44 74 27671 MUX2X1 $T=830080 624365 1 180 $X=824050 $Y=623975
X1212 27625 27860 27752 44 74 27859 MUX2X1 $T=839600 694925 0 180 $X=833570 $Y=690370
X1213 27987 135 26349 44 74 27917 MUX2X1 $T=840160 538125 0 180 $X=834130 $Y=533570
X1214 28033 135 26390 44 74 27956 MUX2X1 $T=842400 545965 1 180 $X=836370 $Y=545575
X1215 28123 135 26444 44 74 28032 MUX2X1 $T=846320 498925 1 180 $X=840290 $Y=498535
X1216 28124 86 26904 44 74 28034 MUX2X1 $T=846320 569485 1 180 $X=840290 $Y=569095
X1217 28125 135 27042 44 74 28035 MUX2X1 $T=846320 577325 0 180 $X=840290 $Y=572770
X1218 28201 86 27659 44 74 28105 MUX2X1 $T=849680 593005 0 180 $X=843650 $Y=588450
X1219 27764 86 27714 44 74 28106 MUX2X1 $T=849680 600845 0 180 $X=843650 $Y=596290
X1220 28267 135 104 44 74 28190 MUX2X1 $T=853040 498925 1 180 $X=847010 $Y=498535
X1221 145 135 27763 44 74 28214 MUX2X1 $T=854160 498925 0 180 $X=848130 $Y=494370
X1222 28318 135 26338 44 74 28231 MUX2X1 $T=855280 522445 0 180 $X=849250 $Y=517890
X1223 28331 86 26976 44 74 28244 MUX2X1 $T=855840 616525 0 180 $X=849810 $Y=611970
X1224 28354 135 27554 44 74 28268 MUX2X1 $T=856960 530285 1 180 $X=850930 $Y=529895
X1225 27762 94 27902 44 74 28379 MUX2X1 $T=851360 632205 1 0 $X=850930 $Y=627650
X1226 28751 135 26066 44 74 28610 MUX2X1 $T=868720 530285 1 180 $X=862690 $Y=529895
X1227 28768 135 27762 44 74 28626 MUX2X1 $T=869280 545965 0 180 $X=863250 $Y=541410
X1228 28124 94 28769 44 74 28803 MUX2X1 $T=863680 632205 0 0 $X=863250 $Y=631815
X1229 28784 135 28124 44 74 28646 MUX2X1 $T=869840 561645 0 180 $X=863810 $Y=557090
X1230 28827 135 28726 44 74 28679 MUX2X1 $T=870960 585165 0 180 $X=864930 $Y=580610
X1231 28868 135 27508 44 74 28725 MUX2X1 $T=872080 569485 1 180 $X=866050 $Y=569095
X1232 28726 86 27608 44 74 28727 MUX2X1 $T=872080 585165 1 180 $X=866050 $Y=584775
X1233 29294 135 28201 44 74 29186 MUX2X1 $T=886080 593005 0 180 $X=880050 $Y=588450
X1234 29347 135 27764 44 74 29249 MUX2X1 $T=888320 593005 1 180 $X=882290 $Y=592615
X1235 29281 94 29320 44 74 29295 MUX2X1 $T=890000 663565 1 180 $X=883970 $Y=663175
X1236 28331 94 29456 44 74 29479 MUX2X1 $T=887200 647885 0 0 $X=886770 $Y=647495
X1237 29467 86 29310 44 74 29373 MUX2X1 $T=893360 632205 1 180 $X=887330 $Y=631815
X1238 29659 94 29590 44 74 29562 MUX2X1 $T=901200 647885 1 180 $X=895170 $Y=647495
X1239 29679 94 29603 44 74 29573 MUX2X1 $T=901760 679245 0 180 $X=895730 $Y=674690
X1240 29778 206 29656 44 74 29602 MUX2X1 $T=908480 545965 0 180 $X=902450 $Y=541410
X1241 29859 135 29467 44 74 29776 MUX2X1 $T=909600 608685 0 180 $X=903570 $Y=604130
X1242 29790 206 29778 44 74 29954 MUX2X1 $T=906800 538125 1 0 $X=906370 $Y=533570
X1243 29929 135 29822 44 74 29843 MUX2X1 $T=912960 600845 1 180 $X=906930 $Y=600455
X1244 29822 94 29880 44 74 29861 MUX2X1 $T=913520 702765 0 180 $X=907490 $Y=698210
X1245 29790 212 29879 44 74 29984 MUX2X1 $T=908480 538125 0 0 $X=908050 $Y=537735
X1246 29659 86 29791 44 74 30144 MUX2X1 $T=915200 640045 1 0 $X=914770 $Y=635490
X1247 29679 86 30099 44 74 30145 MUX2X1 $T=915200 640045 0 0 $X=914770 $Y=639655
X1248 236 206 228 44 74 30037 MUX2X1 $T=921360 530285 1 180 $X=915330 $Y=529895
X1249 30129 94 30061 44 74 30050 MUX2X1 $T=921360 694925 1 180 $X=915330 $Y=694535
X1250 30182 135 29659 44 74 30096 MUX2X1 $T=923600 608685 0 180 $X=917570 $Y=604130
X1251 30098 206 30142 44 74 29895 MUX2X1 $T=924720 553805 1 180 $X=918690 $Y=553415
X1252 29633 212 29689 44 74 30159 MUX2X1 $T=926400 569485 1 180 $X=920370 $Y=569095
X1253 30188 206 30052 44 74 29858 MUX2X1 $T=921360 530285 0 0 $X=920930 $Y=529895
X1254 30190 94 29845 44 74 30268 MUX2X1 $T=921360 694925 0 0 $X=920930 $Y=694535
X1255 30290 94 30191 44 74 30210 MUX2X1 $T=929200 702765 0 180 $X=923170 $Y=698210
X1256 30299 94 30246 44 74 30222 MUX2X1 $T=929760 710605 0 180 $X=923730 $Y=706050
X1257 30127 135 30290 44 74 30366 MUX2X1 $T=925840 616525 0 0 $X=925410 $Y=616135
X1258 30335 212 30233 44 74 30164 MUX2X1 $T=932000 569485 1 180 $X=925970 $Y=569095
X1259 29633 206 30201 44 74 30313 MUX2X1 $T=934240 561645 1 180 $X=928210 $Y=561255
X1260 29774 212 30400 44 74 30542 MUX2X1 $T=934240 569485 0 0 $X=933810 $Y=569095
X1261 30129 86 30315 44 74 30568 MUX2X1 $T=935360 647885 1 0 $X=934930 $Y=643330
X1262 30582 135 28331 44 74 30500 MUX2X1 $T=942640 616525 0 180 $X=936610 $Y=611970
X1263 29925 212 29774 44 74 30631 MUX2X1 $T=939840 569485 0 0 $X=939410 $Y=569095
X1264 30400 212 30595 44 74 30625 MUX2X1 $T=941520 561645 0 0 $X=941090 $Y=561255
X1265 30190 86 30235 44 74 30659 MUX2X1 $T=949920 655725 1 180 $X=943890 $Y=655335
X1266 30290 86 30554 44 74 30780 MUX2X1 $T=944880 679245 1 0 $X=944450 $Y=674690
X1267 30838 212 30570 44 74 30709 MUX2X1 $T=953840 561645 1 180 $X=947810 $Y=561255
X1268 29925 206 30570 44 74 30767 MUX2X1 $T=954960 569485 0 180 $X=948930 $Y=564930
X1269 30606 212 261 44 74 30919 MUX2X1 $T=952720 553805 0 0 $X=952290 $Y=553415
X1270 31120 30743 31192 44 74 31165 MUX2X1 $T=962240 616525 0 0 $X=961810 $Y=616135
X1271 30221 212 29678 44 74 31027 MUX2X1 $T=968400 538125 1 180 $X=962370 $Y=537735
X1272 29678 212 29711 44 74 31191 MUX2X1 $T=963360 522445 0 0 $X=962930 $Y=522055
X1273 30299 86 31196 44 74 31323 MUX2X1 $T=965600 687085 0 0 $X=965170 $Y=686695
X1274 31557 135 30129 44 74 31438 MUX2X1 $T=979600 608685 0 180 $X=973570 $Y=604130
X1275 31596 31556 31379 44 74 31469 MUX2X1 $T=980720 647885 1 180 $X=974690 $Y=647495
X1276 31859 135 30190 44 74 31729 MUX2X1 $T=988560 608685 0 180 $X=982530 $Y=604130
X1277 32500 135 32285 44 74 32386 MUX2X1 $T=1009280 608685 1 180 $X=1003250 $Y=608295
X1278 32713 86 32631 44 74 32662 MUX2X1 $T=1018800 694925 1 180 $X=1012770 $Y=694535
X1279 32795 135 32713 44 74 32681 MUX2X1 $T=1019360 616525 1 180 $X=1013330 $Y=616135
X1280 32713 94 349 44 74 32830 MUX2X1 $T=1013760 726285 1 0 $X=1013330 $Y=721730
X1281 367 86 31840 44 74 32698 MUX2X1 $T=1019920 710605 1 180 $X=1013890 $Y=710215
X1282 32903 206 366 44 74 32377 MUX2X1 $T=1022720 530285 1 180 $X=1016690 $Y=529895
X1283 378 206 374 44 74 32436 MUX2X1 $T=1027760 491085 0 180 $X=1021730 $Y=486530
X1284 33063 33092 33049 44 74 33013 MUX2X1 $T=1030560 655725 1 180 $X=1024530 $Y=655335
X1285 397 86 33106 44 74 33291 MUX2X1 $T=1041760 710605 0 180 $X=1035730 $Y=706050
X1286 33377 94 379 44 74 33303 MUX2X1 $T=1042320 718445 1 180 $X=1036290 $Y=718055
X1287 33076 135 33377 44 74 33402 MUX2X1 $T=1037280 608685 1 0 $X=1036850 $Y=604130
X1288 33062 135 388 44 74 33403 MUX2X1 $T=1037280 624365 1 0 $X=1036850 $Y=619810
X1289 399 206 33384 44 74 32680 MUX2X1 $T=1045680 553805 1 180 $X=1039650 $Y=553415
X1290 402 212 32628 44 74 33503 MUX2X1 $T=1042880 561645 0 0 $X=1042450 $Y=561255
X1291 33066 212 33370 44 74 33520 MUX2X1 $T=1044000 577325 1 0 $X=1043570 $Y=572770
X1292 388 86 33466 44 74 33548 MUX2X1 $T=1045120 702765 1 0 $X=1044690 $Y=698210
X1293 33274 135 33537 44 74 33557 MUX2X1 $T=1045680 616525 0 0 $X=1045250 $Y=616135
X1294 33273 135 33578 44 74 33601 MUX2X1 $T=1047920 608685 1 0 $X=1047490 $Y=604130
X1295 33578 94 404 44 74 33662 MUX2X1 $T=1050720 710605 0 0 $X=1050290 $Y=710215
X1296 408 206 32455 44 74 33650 MUX2X1 $T=1060800 569485 0 180 $X=1054770 $Y=564930
X1297 33537 94 421 44 74 33685 MUX2X1 $T=1062480 694925 1 180 $X=1056450 $Y=694535
X1298 33523 206 33785 44 74 32725 MUX2X1 $T=1059120 514605 0 0 $X=1058690 $Y=514215
X1299 33093 206 33078 44 74 33820 MUX2X1 $T=1060800 553805 0 0 $X=1060370 $Y=553415
X1300 32614 206 33780 44 74 33709 MUX2X1 $T=1066960 545965 1 180 $X=1060930 $Y=545575
X1301 357 206 33523 44 74 33865 MUX2X1 $T=1072560 514605 1 180 $X=1066530 $Y=514215
X1302 33537 86 33915 44 74 33977 MUX2X1 $T=1068080 616525 0 0 $X=1067650 $Y=616135
X1303 33672 135 33955 44 74 33987 MUX2X1 $T=1068640 600845 1 0 $X=1068210 $Y=596290
X1304 33377 86 33978 44 74 34001 MUX2X1 $T=1069200 687085 1 0 $X=1068770 $Y=682530
X1305 32846 212 420 44 74 34041 MUX2X1 $T=1071440 522445 0 0 $X=1071010 $Y=522055
X1306 33590 206 33616 44 74 34056 MUX2X1 $T=1071440 530285 0 0 $X=1071010 $Y=529895
X1307 32833 206 32619 44 74 34130 MUX2X1 $T=1074240 514605 1 0 $X=1073810 $Y=510050
X1308 34053 212 33436 44 74 34158 MUX2X1 $T=1075360 545965 0 0 $X=1074930 $Y=545575
X1309 33996 212 33616 44 74 33832 MUX2X1 $T=1082640 530285 1 180 $X=1076610 $Y=529895
X1310 33955 94 416 44 74 34269 MUX2X1 $T=1079280 710605 1 0 $X=1078850 $Y=706050
X1311 34232 94 415 44 74 34132 MUX2X1 $T=1084880 718445 1 180 $X=1078850 $Y=718055
X1312 30415 135 34306 44 74 34334 MUX2X1 $T=1081520 600845 0 0 $X=1081090 $Y=600455
X1313 34306 86 34411 44 74 34492 MUX2X1 $T=1087680 647885 1 0 $X=1087250 $Y=643330
X1314 34232 86 34641 44 74 34747 MUX2X1 $T=1096080 702765 1 0 $X=1095650 $Y=698210
X1315 32793 135 34808 44 74 34845 MUX2X1 $T=1098880 593005 0 0 $X=1098450 $Y=592615
X1316 35207 86 33956 44 74 35125 MUX2X1 $T=1118480 702765 0 180 $X=1112450 $Y=698210
X1317 35207 94 35276 44 74 35310 MUX2X1 $T=1114560 710605 1 0 $X=1114130 $Y=706050
X1318 34808 86 35309 44 74 35343 MUX2X1 $T=1115680 624365 1 0 $X=1115250 $Y=619810
X1319 34808 94 34948 44 74 35360 MUX2X1 $T=1116240 671405 1 0 $X=1115810 $Y=666850
X1320 34306 94 35331 44 74 35361 MUX2X1 $T=1116240 679245 0 0 $X=1115810 $Y=678855
X1321 31195 135 35419 44 74 35451 MUX2X1 $T=1119600 600845 0 0 $X=1119170 $Y=600455
X1322 33119 135 35431 44 74 35461 MUX2X1 $T=1120160 577325 1 0 $X=1119730 $Y=572770
X1323 29789 135 35432 44 74 35462 MUX2X1 $T=1120160 593005 1 0 $X=1119730 $Y=588450
X1324 35431 94 35389 44 74 35359 MUX2X1 $T=1126880 655725 0 180 $X=1120850 $Y=651170
X1325 35419 86 35435 44 74 35420 MUX2X1 $T=1129120 624365 0 180 $X=1123090 $Y=619810
X1326 35419 94 35524 44 74 35504 MUX2X1 $T=1132480 655725 0 180 $X=1126450 $Y=651170
X1327 33316 135 35602 44 74 35632 MUX2X1 $T=1128000 585165 1 0 $X=1127570 $Y=580610
X1328 457 135 35614 44 74 35661 MUX2X1 $T=1129120 569485 1 0 $X=1128690 $Y=564930
X1329 33243 135 35763 44 74 35788 MUX2X1 $T=1134720 569485 1 0 $X=1134290 $Y=564930
X1330 31327 135 35773 44 74 35801 MUX2X1 $T=1135280 561645 1 0 $X=1134850 $Y=557090
X1331 33416 135 35800 44 74 35828 MUX2X1 $T=1136400 530285 0 0 $X=1135970 $Y=529895
X1332 34640 135 35826 44 74 35849 MUX2X1 $T=1137520 506765 0 0 $X=1137090 $Y=506375
X1333 30416 135 35827 44 74 35850 MUX2X1 $T=1137520 522445 1 0 $X=1137090 $Y=517890
X1334 251 135 35837 44 74 35862 MUX2X1 $T=1138080 498925 1 0 $X=1137650 $Y=494370
X1335 35614 86 35295 44 74 35954 MUX2X1 $T=1142000 624365 1 0 $X=1141570 $Y=619810
X1336 35432 86 35591 44 74 35965 MUX2X1 $T=1142560 600845 0 0 $X=1142130 $Y=600455
X1337 35432 94 35671 44 74 36003 MUX2X1 $T=1144240 624365 0 0 $X=1143810 $Y=623975
X1338 35787 94 35966 44 74 35937 MUX2X1 $T=1152080 663565 0 180 $X=1146050 $Y=659010
X1339 263 135 471 44 74 36270 MUX2X1 $T=1154880 491085 0 0 $X=1154450 $Y=490695
X1340 35811 94 36271 44 74 36247 MUX2X1 $T=1164400 553805 1 180 $X=1158370 $Y=553415
X1341 35773 86 36447 44 74 36466 MUX2X1 $T=1164960 553805 0 0 $X=1164530 $Y=553415
X1342 35800 94 36342 44 74 36408 MUX2X1 $T=1172240 561645 0 180 $X=1166210 $Y=557090
X1343 475 94 36449 44 74 36446 MUX2X1 $T=1174480 498925 0 180 $X=1168450 $Y=494370
X1344 471 94 36550 44 74 36576 MUX2X1 $T=1170560 491085 0 0 $X=1170130 $Y=490695
X1345 35602 94 36517 44 74 36498 MUX2X1 $T=1177280 616525 0 180 $X=1171250 $Y=611970
X1346 473 94 36599 44 74 36624 MUX2X1 $T=1172800 514605 1 0 $X=1172370 $Y=510050
X1347 35827 86 36416 44 74 36625 MUX2X1 $T=1172800 538125 1 0 $X=1172370 $Y=533570
X1348 35985 80 476 44 74 36637 MUX2X1 $T=1184000 726285 1 180 $X=1177970 $Y=725895
X1349 35787 86 36831 44 74 36854 MUX2X1 $T=1182320 593005 0 0 $X=1181890 $Y=592615
X1350 35800 86 36840 44 74 36882 MUX2X1 $T=1183440 561645 1 0 $X=1183010 $Y=557090
X1351 30922 80 480 44 74 481 MUX2X1 $T=1184000 726285 0 0 $X=1183570 $Y=725895
X1352 30843 80 36960 44 74 36998 MUX2X1 $T=1187360 687085 1 0 $X=1186930 $Y=682530
X1353 484 86 485 44 74 37256 MUX2X1 $T=1194640 491085 0 0 $X=1194210 $Y=490695
X1354 35826 94 37086 44 74 37285 MUX2X1 $T=1195760 616525 1 0 $X=1195330 $Y=611970
X1355 36579 80 37244 44 74 37211 MUX2X1 $T=1203600 702765 1 180 $X=1197570 $Y=702375
X1356 484 94 37257 44 74 37224 MUX2X1 $T=1204160 530285 0 180 $X=1198130 $Y=525730
X1357 35837 94 37258 44 74 37225 MUX2X1 $T=1204160 553805 1 180 $X=1198130 $Y=553415
X1358 30501 80 37260 44 74 37226 MUX2X1 $T=1204160 687085 1 180 $X=1198130 $Y=686695
X1359 35826 86 37348 44 74 37376 MUX2X1 $T=1199680 506765 1 0 $X=1199250 $Y=502210
X1360 33913 80 37300 44 74 37277 MUX2X1 $T=1205840 679245 0 180 $X=1199810 $Y=674690
X1361 35763 86 36275 44 74 37603 MUX2X1 $T=1208640 585165 0 0 $X=1208210 $Y=584775
X1362 35763 94 37436 44 74 37711 MUX2X1 $T=1214800 593005 0 0 $X=1214370 $Y=592615
X1363 29940 80 37466 44 74 37747 MUX2X1 $T=1217040 679245 1 0 $X=1216610 $Y=674690
X1364 491 94 37710 44 74 37696 MUX2X1 $T=1224320 522445 1 180 $X=1218290 $Y=522055
X1365 491 86 37855 44 74 37881 MUX2X1 $T=1223200 491085 0 0 $X=1222770 $Y=490695
X1366 490 86 37883 44 74 37923 MUX2X1 $T=1224880 585165 1 0 $X=1224450 $Y=580610
X1367 37884 80 37885 44 74 37882 MUX2X1 $T=1233840 671405 0 180 $X=1227810 $Y=666850
X1368 37822 80 37936 44 74 37909 MUX2X1 $T=1234960 679245 0 180 $X=1228930 $Y=674690
X1369 37604 80 498 44 74 37910 MUX2X1 $T=1234960 694925 1 180 $X=1228930 $Y=694535
X1370 36565 34348 38689 44 74 38637 MUX2X1 $T=1263520 655725 1 180 $X=1257490 $Y=655335
X1371 38993 38547 38900 44 74 38453 MUX2X1 $T=1269120 655725 0 180 $X=1263090 $Y=651170
X1372 39172 38521 39064 44 74 38837 MUX2X1 $T=1274160 640045 1 180 $X=1268130 $Y=639655
X1373 39423 36565 36950 44 74 39356 MUX2X1 $T=1287600 616525 1 180 $X=1281570 $Y=616135
X1374 24238 24265 44 74 24058 NAND2X1 $T=701840 640045 1 0 $X=701410 $Y=635490
X1375 24565 24078 44 74 24511 NAND2X1 $T=711920 608685 0 180 $X=708690 $Y=604130
X1376 24862 24752 44 74 24376 NAND2X1 $T=718080 608685 0 0 $X=717650 $Y=608295
X1377 24814 24862 44 74 24261 NAND2X1 $T=719200 647885 1 0 $X=718770 $Y=643330
X1378 24816 24814 44 74 24815 NAND2X1 $T=719200 655725 1 0 $X=718770 $Y=651170
X1379 24999 24797 44 74 25159 NAND2X1 $T=729280 624365 1 180 $X=726050 $Y=623975
X1380 25386 24144 44 74 25438 NAND2X1 $T=737680 640045 1 180 $X=734450 $Y=639655
X1381 25784 25850 44 74 25847 NAND2X1 $T=746640 710605 1 0 $X=746210 $Y=706050
X1382 79 25992 44 74 25967 NAND2X1 $T=751120 506765 1 0 $X=750690 $Y=502210
X1383 79 25825 44 74 25951 NAND2X1 $T=751120 530285 1 0 $X=750690 $Y=525730
X1384 83 25478 44 74 25993 NAND2X1 $T=753920 671405 1 180 $X=750690 $Y=671015
X1385 91 26296 44 74 93 NAND2X1 $T=762320 726285 0 0 $X=761890 $Y=725895
X1386 84 26327 44 74 25850 NAND2X1 $T=764000 702765 1 0 $X=763570 $Y=698210
X1387 84 26328 44 74 26177 NAND2X1 $T=764000 726285 1 0 $X=763570 $Y=721730
X1388 90 26294 44 74 26326 NAND2X1 $T=765680 616525 1 0 $X=765250 $Y=611970
X1389 26379 26259 44 74 96 NAND2X1 $T=769040 491085 0 180 $X=765810 $Y=486530
X1390 90 26231 44 74 26453 NAND2X1 $T=774080 616525 1 180 $X=770850 $Y=616135
X1391 97 98 44 74 26242 NAND2X1 $T=772400 679245 1 0 $X=771970 $Y=674690
X1392 81 26772 44 74 26750 NAND2X1 $T=786960 514605 0 0 $X=786530 $Y=514215
X1393 83 26555 44 74 26734 NAND2X1 $T=790320 640045 0 180 $X=787090 $Y=635490
X1394 83 26792 44 74 26807 NAND2X1 $T=791440 655725 1 0 $X=791010 $Y=651170
X1395 26859 97 44 74 26882 NAND2X1 $T=793680 655725 0 0 $X=793250 $Y=655335
X1396 79 26904 44 74 26740 NAND2X1 $T=797040 561645 0 180 $X=793810 $Y=557090
X1397 90 27044 44 74 26939 NAND2X1 $T=799280 655725 1 0 $X=798850 $Y=651170
X1398 79 27055 44 74 27100 NAND2X1 $T=805440 530285 0 180 $X=802210 $Y=525730
X1399 79 111 44 74 27443 NAND2X1 $T=813840 538125 1 0 $X=813410 $Y=533570
X1400 27511 27532 44 74 27510 NAND2X1 $T=817200 718445 0 0 $X=816770 $Y=718055
X1401 90 27489 44 74 27490 NAND2X1 $T=818320 632205 1 0 $X=817890 $Y=627650
X1402 81 27608 44 74 27492 NAND2X1 $T=820560 545965 0 0 $X=820130 $Y=545575
X1403 27686 27424 44 74 27674 NAND2X1 $T=826160 561645 1 180 $X=822930 $Y=561255
X1404 79 27714 44 74 27686 NAND2X1 $T=824480 593005 1 0 $X=824050 $Y=588450
X1405 120 27712 44 74 27660 NAND2X1 $T=826160 710605 0 0 $X=825730 $Y=710215
X1406 83 113 44 74 27785 NAND2X1 $T=827840 655725 0 0 $X=827410 $Y=655335
X1407 132 27605 44 74 131 NAND2X1 $T=835680 726285 1 180 $X=832450 $Y=725895
X1408 28136 28108 44 74 28128 NAND2X1 $T=846320 585165 1 180 $X=843090 $Y=584775
X1409 143 27766 44 74 27532 NAND2X1 $T=853040 718445 0 0 $X=852610 $Y=718055
X1410 27821 28134 44 74 28175 NAND2X1 $T=856400 710605 1 0 $X=855970 $Y=706050
X1411 28541 28079 44 74 28403 NAND2X1 $T=860880 694925 0 0 $X=860450 $Y=694535
X1412 90 26839 44 74 29055 NAND2X1 $T=877680 702765 1 180 $X=874450 $Y=702375
X1413 83 164 44 74 29375 NAND2X1 $T=891680 718445 1 180 $X=888450 $Y=718055
X1414 166 28354 44 74 29457 NAND2X1 $T=892800 522445 1 180 $X=889570 $Y=522055
X1415 166 28123 44 74 29508 NAND2X1 $T=895040 498925 0 180 $X=891810 $Y=494370
X1416 79 27608 44 74 29536 NAND2X1 $T=896160 616525 1 180 $X=892930 $Y=616135
X1417 90 29456 44 74 29537 NAND2X1 $T=896160 710605 1 180 $X=892930 $Y=710215
X1418 159 28868 44 74 172 NAND2X1 $T=893920 514605 0 0 $X=893490 $Y=514215
X1419 29335 29507 44 74 173 NAND2X1 $T=894480 506765 1 0 $X=894050 $Y=502210
X1420 29572 29575 44 74 177 NAND2X1 $T=895600 506765 0 0 $X=895170 $Y=506375
X1421 90 29603 44 74 183 NAND2X1 $T=897280 718445 0 0 $X=896850 $Y=718055
X1422 166 28868 44 74 29645 NAND2X1 $T=900640 522445 1 180 $X=897410 $Y=522055
X1423 166 29348 44 74 29662 NAND2X1 $T=898400 530285 0 0 $X=897970 $Y=529895
X1424 29710 29508 44 74 187 NAND2X1 $T=902880 491085 0 180 $X=899650 $Y=486530
X1425 175 182 44 74 29698 NAND2X1 $T=904000 545965 1 180 $X=900770 $Y=545575
X1426 29323 29788 44 74 181 NAND2X1 $T=902880 498925 0 0 $X=902450 $Y=498535
X1427 29773 29422 44 74 29778 NAND2X1 $T=905680 522445 0 180 $X=902450 $Y=517890
X1428 29423 29422 44 74 192 NAND2X1 $T=906240 530285 0 180 $X=903010 $Y=525730
X1429 200 29689 44 74 29736 NAND2X1 $T=907920 569485 0 180 $X=904690 $Y=564930
X1430 29712 29644 44 74 203 NAND2X1 $T=909040 498925 0 180 $X=905810 $Y=494370
X1431 29857 29457 44 74 205 NAND2X1 $T=909040 506765 1 180 $X=905810 $Y=506375
X1432 29860 29739 44 74 29844 NAND2X1 $T=909040 624365 0 180 $X=905810 $Y=619810
X1433 29878 29423 44 74 208 NAND2X1 $T=910160 522445 1 180 $X=906930 $Y=522055
X1434 29662 29712 44 74 214 NAND2X1 $T=909040 498925 1 0 $X=908610 $Y=494370
X1435 29999 29907 44 74 29958 NAND2X1 $T=914640 577325 1 180 $X=911410 $Y=576935
X1436 29984 221 44 74 30001 NAND2X1 $T=912400 553805 1 0 $X=911970 $Y=549250
X1437 30049 30029 44 74 29956 NAND2X1 $T=916880 585165 0 180 $X=913650 $Y=580610
X1438 186 231 44 74 29955 NAND2X1 $T=915760 545965 0 0 $X=915330 $Y=545575
X1439 185 232 44 74 29993 NAND2X1 $T=915760 561645 1 0 $X=915330 $Y=557090
X1440 29895 221 44 74 30082 NAND2X1 $T=916320 553805 0 0 $X=915890 $Y=553415
X1441 81 30099 44 74 30073 NAND2X1 $T=916320 655725 1 0 $X=915890 $Y=651170
X1442 29376 29507 44 74 30094 NAND2X1 $T=919680 498925 1 180 $X=916450 $Y=498535
X1443 30128 30160 44 74 30146 NAND2X1 $T=919120 663565 0 0 $X=918690 $Y=663175
X1444 29857 29507 44 74 242 NAND2X1 $T=923600 506765 1 180 $X=920370 $Y=506375
X1445 240 29656 44 74 30140 NAND2X1 $T=920800 522445 1 0 $X=920370 $Y=517890
X1446 29391 29645 44 74 30142 NAND2X1 $T=921360 522445 0 0 $X=920930 $Y=522055
X1447 244 30098 44 74 30036 NAND2X1 $T=924160 545965 1 180 $X=920930 $Y=545575
X1448 218 245 44 74 234 NAND2X1 $T=923040 491085 1 0 $X=922610 $Y=486530
X1449 244 30142 44 74 30212 NAND2X1 $T=924160 545965 0 0 $X=923730 $Y=545575
X1450 30070 221 44 74 30256 NAND2X1 $T=927520 585165 0 180 $X=924290 $Y=580610
X1451 29391 30232 44 74 249 NAND2X1 $T=925280 498925 0 0 $X=924850 $Y=498535
X1452 166 251 44 74 30000 NAND2X1 $T=926960 506765 1 0 $X=926530 $Y=502210
X1453 244 29774 44 74 30298 NAND2X1 $T=926960 553805 1 0 $X=926530 $Y=549250
X1454 244 30188 44 74 30107 NAND2X1 $T=930880 522445 1 180 $X=927650 $Y=522055
X1455 30159 216 44 74 30234 NAND2X1 $T=928080 577325 0 0 $X=927650 $Y=576935
X1456 30313 216 44 74 30373 NAND2X1 $T=930320 569485 1 0 $X=929890 $Y=564930
X1457 29857 30168 44 74 30201 NAND2X1 $T=930880 522445 0 0 $X=930450 $Y=522055
X1458 259 255 44 74 261 NAND2X1 $T=932560 491085 1 0 $X=932130 $Y=486530
X1459 30444 237 44 74 29999 NAND2X1 $T=935360 585165 0 180 $X=932130 $Y=580610
X1460 79 30147 44 74 30448 NAND2X1 $T=935920 679245 1 180 $X=932690 $Y=678855
X1461 29879 264 44 74 30405 NAND2X1 $T=934240 506765 0 0 $X=933810 $Y=506375
X1462 197 261 44 74 30486 NAND2X1 $T=936480 553805 0 0 $X=936050 $Y=553415
X1463 30553 30286 44 74 30532 NAND2X1 $T=940960 577325 1 180 $X=937730 $Y=576935
X1464 81 30554 44 74 30546 NAND2X1 $T=938160 679245 1 0 $X=937730 $Y=674690
X1465 29391 265 44 74 277 NAND2X1 $T=938720 498925 1 0 $X=938290 $Y=494370
X1466 30596 237 44 74 30583 NAND2X1 $T=942640 577325 0 180 $X=939410 $Y=572770
X1467 280 29645 44 74 283 NAND2X1 $T=943760 514605 1 180 $X=940530 $Y=514215
X1468 166 30608 44 74 30168 NAND2X1 $T=944880 522445 1 180 $X=941650 $Y=522055
X1469 30625 273 44 74 30522 NAND2X1 $T=942080 593005 1 0 $X=941650 $Y=588450
X1470 30529 29482 44 74 288 NAND2X1 $T=948240 498925 1 180 $X=945010 $Y=498535
X1471 30709 273 44 74 30571 NAND2X1 $T=946000 577325 0 0 $X=945570 $Y=576935
X1472 172 30744 44 74 292 NAND2X1 $T=946560 491085 1 0 $X=946130 $Y=486530
X1473 227 30188 44 74 30742 NAND2X1 $T=948800 522445 1 0 $X=948370 $Y=517890
X1474 254 30744 44 74 299 NAND2X1 $T=949920 498925 1 0 $X=949490 $Y=494370
X1475 298 30821 44 74 30817 NAND2X1 $T=949920 710605 1 0 $X=949490 $Y=706050
X1476 303 30188 44 74 30835 NAND2X1 $T=954960 514605 1 180 $X=951730 $Y=514215
X1477 303 30838 44 74 30800 NAND2X1 $T=955520 530285 1 180 $X=952290 $Y=529895
X1478 30767 273 44 74 30880 NAND2X1 $T=952720 577325 0 0 $X=952290 $Y=576935
X1479 30840 309 44 74 305 NAND2X1 $T=953280 718445 0 0 $X=952850 $Y=718055
X1480 30917 30465 44 74 30903 NAND2X1 $T=956640 538125 1 180 $X=953410 $Y=537735
X1481 30335 212 44 74 30918 NAND2X1 $T=954400 577325 1 0 $X=953970 $Y=572770
X1482 313 29678 44 74 30836 NAND2X1 $T=955520 530285 0 0 $X=955090 $Y=529895
X1483 186 288 44 74 30745 NAND2X1 $T=958880 545965 1 180 $X=955650 $Y=545575
X1484 301 250 44 74 30957 NAND2X1 $T=956640 498925 1 0 $X=956210 $Y=494370
X1485 316 314 44 74 30809 NAND2X1 $T=959440 718445 0 180 $X=956210 $Y=713890
X1486 244 232 44 74 30972 NAND2X1 $T=962800 561645 1 180 $X=959570 $Y=561255
X1487 313 30838 44 74 31043 NAND2X1 $T=960560 530285 1 0 $X=960130 $Y=525730
X1488 320 322 44 74 30686 NAND2X1 $T=961120 491085 1 0 $X=960690 $Y=486530
X1489 290 250 44 74 31058 NAND2X1 $T=963920 491085 1 180 $X=960690 $Y=490695
X1490 30821 324 44 74 323 NAND2X1 $T=962800 726285 0 0 $X=962370 $Y=725895
X1491 328 30142 44 74 31147 NAND2X1 $T=967840 553805 1 180 $X=964610 $Y=553415
X1492 30919 207 44 74 31164 NAND2X1 $T=965600 569485 1 0 $X=965170 $Y=564930
X1493 31060 221 44 74 31225 NAND2X1 $T=966160 577325 1 0 $X=965730 $Y=572770
X1494 31102 332 44 74 30958 NAND2X1 $T=966720 514605 0 0 $X=966290 $Y=514215
X1495 79 29310 44 74 31245 NAND2X1 $T=969520 679245 0 180 $X=966290 $Y=674690
X1496 31168 316 44 74 31271 NAND2X1 $T=967280 718445 1 0 $X=966850 $Y=713890
X1497 31287 30930 44 74 31270 NAND2X1 $T=970640 663565 0 180 $X=967410 $Y=659010
X1498 31028 31118 44 74 31166 NAND2X1 $T=971200 632205 1 180 $X=967970 $Y=631815
X1499 166 31327 44 74 30744 NAND2X1 $T=968960 530285 1 0 $X=968530 $Y=525730
X1500 31191 273 44 74 31374 NAND2X1 $T=971760 522445 1 0 $X=971330 $Y=517890
X1501 79 30554 44 74 31558 NAND2X1 $T=979600 687085 1 180 $X=976370 $Y=686695
X1502 31494 30743 44 74 31636 NAND2X1 $T=979040 632205 0 0 $X=978610 $Y=631815
X1503 81 31840 44 74 31821 NAND2X1 $T=984640 687085 1 0 $X=984210 $Y=682530
X1504 31415 31782 44 74 31221 NAND2X1 $T=987440 647885 0 0 $X=987010 $Y=647495
X1505 332 31092 44 74 290 NAND2X1 $T=989680 491085 0 0 $X=989250 $Y=490695
X1506 31864 30816 44 74 31996 NAND2X1 $T=993040 671405 0 180 $X=989810 $Y=666850
X1507 32081 31167 44 74 32063 NAND2X1 $T=995280 640045 0 180 $X=992050 $Y=635490
X1508 31626 31167 44 74 32118 NAND2X1 $T=996400 663565 1 0 $X=995970 $Y=659010
X1509 32320 32286 44 74 32304 NAND2X1 $T=1002560 671405 0 180 $X=999330 $Y=666850
X1510 32370 338 44 74 32360 NAND2X1 $T=1004240 498925 1 180 $X=1001010 $Y=498535
X1511 81 31031 44 74 32361 NAND2X1 $T=1004240 679245 1 180 $X=1001010 $Y=678855
X1512 32387 32361 44 74 32371 NAND2X1 $T=1004800 687085 0 180 $X=1001570 $Y=682530
X1513 200 32455 44 74 32485 NAND2X1 $T=1005360 530285 0 0 $X=1004930 $Y=529895
X1514 356 328 44 74 32587 NAND2X1 $T=1012080 514605 0 180 $X=1008850 $Y=510050
X1515 79 32631 44 74 32387 NAND2X1 $T=1010400 687085 1 0 $X=1009970 $Y=682530
X1516 354 334 44 74 32865 NAND2X1 $T=1018800 491085 0 0 $X=1018370 $Y=490695
X1517 32881 32847 44 74 32866 NAND2X1 $T=1021600 561645 1 180 $X=1018370 $Y=561255
X1518 32835 237 44 74 32881 NAND2X1 $T=1019920 553805 0 0 $X=1019490 $Y=553415
X1519 303 375 44 74 32839 NAND2X1 $T=1021600 506765 1 0 $X=1021170 $Y=502210
X1520 197 33066 44 74 33029 NAND2X1 $T=1024960 561645 1 0 $X=1024530 $Y=557090
X1521 166 28033 44 74 33047 NAND2X1 $T=1024960 569485 1 0 $X=1024530 $Y=564930
X1522 313 33093 44 74 33044 NAND2X1 $T=1030000 514605 1 180 $X=1026770 $Y=514215
X1523 33030 33047 44 74 371 NAND2X1 $T=1030000 561645 1 180 $X=1026770 $Y=561255
X1524 287 382 44 74 33077 NAND2X1 $T=1029440 506765 1 0 $X=1029010 $Y=502210
X1525 217 33094 44 74 386 NAND2X1 $T=1035040 506765 1 180 $X=1031810 $Y=506375
X1526 33213 33267 44 74 390 NAND2X1 $T=1033360 530285 1 0 $X=1032930 $Y=525730
X1527 33172 33267 44 74 33078 NAND2X1 $T=1033360 553805 1 0 $X=1032930 $Y=549250
X1528 33255 33280 44 74 32535 NAND2X1 $T=1033920 514605 0 0 $X=1033490 $Y=514215
X1529 33277 33317 44 74 33199 NAND2X1 $T=1035600 679245 1 0 $X=1035170 $Y=674690
X1530 33255 33338 44 74 356 NAND2X1 $T=1036720 514605 1 0 $X=1036290 $Y=510050
X1531 159 33274 44 74 33272 NAND2X1 $T=1039520 538125 0 180 $X=1036290 $Y=533570
X1532 32629 33316 44 74 33335 NAND2X1 $T=1037280 585165 1 0 $X=1036850 $Y=580610
X1533 79 31840 44 74 33350 NAND2X1 $T=1040640 694925 0 180 $X=1037410 $Y=690370
X1534 33344 33047 44 74 33370 NAND2X1 $T=1041760 569485 0 180 $X=1038530 $Y=564930
X1535 166 33062 44 74 33386 NAND2X1 $T=1042880 561645 1 180 $X=1039650 $Y=561255
X1536 33370 206 44 74 33413 NAND2X1 $T=1041200 577325 1 0 $X=1040770 $Y=572770
X1537 33401 401 44 74 385 NAND2X1 $T=1041760 498925 0 0 $X=1041330 $Y=498535
X1538 33435 32865 44 74 33424 NAND2X1 $T=1045120 498925 0 180 $X=1041890 $Y=494370
X1539 159 27987 44 74 33430 NAND2X1 $T=1042320 522445 0 0 $X=1041890 $Y=522055
X1540 166 33416 44 74 33280 NAND2X1 $T=1043440 530285 0 0 $X=1043010 $Y=529895
X1541 33226 33454 44 74 402 NAND2X1 $T=1043440 538125 0 0 $X=1043010 $Y=537735
X1542 33430 401 44 74 375 NAND2X1 $T=1047360 506765 0 180 $X=1044130 $Y=502210
X1543 33447 33384 44 74 384 NAND2X1 $T=1047360 514605 1 180 $X=1044130 $Y=514215
X1544 33384 33486 44 74 364 NAND2X1 $T=1047360 514605 0 0 $X=1046930 $Y=514215
X1545 166 33119 44 74 33447 NAND2X1 $T=1047360 553805 1 0 $X=1046930 $Y=549250
X1546 33476 33542 44 74 363 NAND2X1 $T=1051840 538125 0 180 $X=1048610 $Y=533570
X1547 200 33066 44 74 33517 NAND2X1 $T=1052400 577325 0 180 $X=1049170 $Y=572770
X1548 33465 33387 44 74 33049 NAND2X1 $T=1053520 655725 1 180 $X=1050290 $Y=655335
X1549 33401 33369 44 74 33592 NAND2X1 $T=1054080 530285 0 180 $X=1050850 $Y=525730
X1550 200 32628 44 74 33628 NAND2X1 $T=1055760 569485 1 180 $X=1052530 $Y=569095
X1551 186 414 44 74 33635 NAND2X1 $T=1056880 553805 0 180 $X=1053650 $Y=549250
X1552 175 33152 44 74 33698 NAND2X1 $T=1060240 530285 0 180 $X=1057010 $Y=525730
X1553 200 408 44 74 33728 NAND2X1 $T=1061360 561645 1 180 $X=1058130 $Y=561255
X1554 159 28267 44 74 425 NAND2X1 $T=1062480 498925 0 180 $X=1059250 $Y=494370
X1555 175 33348 44 74 33745 NAND2X1 $T=1062480 538125 1 180 $X=1059250 $Y=537735
X1556 159 33119 44 74 33683 NAND2X1 $T=1060240 545965 1 0 $X=1059810 $Y=541410
X1557 185 32614 44 74 33801 NAND2X1 $T=1062480 538125 0 0 $X=1062050 $Y=537735
X1558 159 28751 44 74 33831 NAND2X1 $T=1068080 522445 0 180 $X=1064850 $Y=517890
X1559 33835 33329 44 74 33824 NAND2X1 $T=1065840 647885 0 0 $X=1065410 $Y=647495
X1560 427 429 44 74 33780 NAND2X1 $T=1069760 506765 1 180 $X=1066530 $Y=506375
X1561 218 422 44 74 33887 NAND2X1 $T=1069760 545965 0 180 $X=1066530 $Y=541410
X1562 33845 33746 44 74 33892 NAND2X1 $T=1070320 663565 0 180 $X=1067090 $Y=659010
X1563 33902 33329 44 74 33065 NAND2X1 $T=1070320 671405 1 180 $X=1067090 $Y=671015
X1564 352 264 44 74 33909 NAND2X1 $T=1071440 498925 0 180 $X=1068210 $Y=494370
X1565 186 434 44 74 33914 NAND2X1 $T=1071440 538125 0 180 $X=1068210 $Y=533570
X1566 33650 216 44 74 33776 NAND2X1 $T=1068640 577325 0 0 $X=1068210 $Y=576935
X1567 33833 33228 44 74 33911 NAND2X1 $T=1069200 647885 1 0 $X=1068770 $Y=643330
X1568 33930 33313 44 74 33921 NAND2X1 $T=1072000 655725 0 180 $X=1068770 $Y=651170
X1569 33857 33884 44 74 33902 NAND2X1 $T=1072000 679245 1 180 $X=1068770 $Y=678855
X1570 33769 33932 44 74 33930 NAND2X1 $T=1070320 663565 1 0 $X=1069890 $Y=659010
X1571 33785 197 44 74 33945 NAND2X1 $T=1070880 538125 0 0 $X=1070450 $Y=537735
X1572 33954 216 44 74 33949 NAND2X1 $T=1073680 585165 0 180 $X=1070450 $Y=580610
X1573 197 33780 44 74 33953 NAND2X1 $T=1074240 514605 0 180 $X=1071010 $Y=510050
X1574 218 33348 44 74 440 NAND2X1 $T=1074800 491085 1 180 $X=1071570 $Y=490695
X1575 33997 33831 44 74 33693 NAND2X1 $T=1075360 514605 1 180 $X=1072130 $Y=514215
X1576 33503 216 44 74 34000 NAND2X1 $T=1073120 577325 1 0 $X=1072690 $Y=572770
X1577 34025 33900 44 74 370 NAND2X1 $T=1077600 491085 0 180 $X=1074370 $Y=486530
X1578 197 33078 44 74 34159 NAND2X1 $T=1082080 553805 1 180 $X=1078850 $Y=553415
X1579 217 33315 44 74 34173 NAND2X1 $T=1082640 514605 0 180 $X=1079410 $Y=510050
X1580 34158 184 44 74 34143 NAND2X1 $T=1083760 545965 1 180 $X=1080530 $Y=545575
X1581 197 33592 44 74 34289 NAND2X1 $T=1083760 545965 0 0 $X=1083330 $Y=545575
X1582 34025 437 44 74 34175 NAND2X1 $T=1085440 491085 1 0 $X=1085010 $Y=486530
X1583 33350 34370 44 74 34349 NAND2X1 $T=1086000 687085 0 0 $X=1085570 $Y=686695
X1584 34304 237 44 74 34367 NAND2X1 $T=1086560 561645 0 0 $X=1086130 $Y=561255
X1585 34382 34177 44 74 34368 NAND2X1 $T=1089360 569485 1 180 $X=1086130 $Y=569095
X1586 244 375 44 74 34378 NAND2X1 $T=1089920 498925 0 180 $X=1086690 $Y=494370
X1587 34130 207 44 74 34230 NAND2X1 $T=1088240 514605 0 0 $X=1087810 $Y=514215
X1588 34367 33834 44 74 34353 NAND2X1 $T=1091040 577325 0 180 $X=1087810 $Y=572770
X1589 34521 34491 44 74 34508 NAND2X1 $T=1094960 632205 0 180 $X=1091730 $Y=627650
X1590 81 34411 44 74 34491 NAND2X1 $T=1094960 640045 1 180 $X=1091730 $Y=639655
X1591 81 33956 44 74 34398 NAND2X1 $T=1092160 655725 0 0 $X=1091730 $Y=655335
X1592 217 454 44 74 34523 NAND2X1 $T=1095520 530285 0 180 $X=1092290 $Y=525730
X1593 34488 237 44 74 34603 NAND2X1 $T=1098320 561645 0 180 $X=1095090 $Y=557090
X1594 159 457 44 74 34025 NAND2X1 $T=1096640 491085 1 0 $X=1096210 $Y=486530
X1595 34570 97 44 74 34652 NAND2X1 $T=1097200 726285 1 0 $X=1096770 $Y=721730
X1596 159 34685 44 74 438 NAND2X1 $T=1097760 514605 1 0 $X=1097330 $Y=510050
X1597 79 34409 44 74 35034 NAND2X1 $T=1111200 655725 1 180 $X=1107970 $Y=655335
X1598 81 35309 44 74 35208 NAND2X1 $T=1120160 640045 0 0 $X=1119730 $Y=639655
X1599 35390 35238 44 74 35371 NAND2X1 $T=1123520 687085 1 180 $X=1120290 $Y=686695
X1600 35034 35675 44 74 35662 NAND2X1 $T=1133040 600845 0 0 $X=1132610 $Y=600455
X1601 83 30922 44 74 35779 NAND2X1 $T=1140320 687085 1 0 $X=1139890 $Y=682530
X1602 90 35966 44 74 466 NAND2X1 $T=1145920 694925 0 0 $X=1145490 $Y=694535
X1603 79 35309 44 74 36050 NAND2X1 $T=1153200 624365 0 180 $X=1149970 $Y=619810
X1604 90 35913 44 74 36219 NAND2X1 $T=1157120 687085 0 0 $X=1156690 $Y=686695
X1605 90 36174 44 74 36273 NAND2X1 $T=1158800 663565 1 0 $X=1158370 $Y=659010
X1606 83 472 44 74 36276 NAND2X1 $T=1158800 702765 1 0 $X=1158370 $Y=698210
X1607 90 36449 44 74 36427 NAND2X1 $T=1167200 608685 0 0 $X=1166770 $Y=608295
X1608 83 36059 44 74 36442 NAND2X1 $T=1170560 663565 1 180 $X=1167330 $Y=663175
X1609 90 36517 44 74 36532 NAND2X1 $T=1175600 624365 0 0 $X=1175170 $Y=623975
X1610 97 34369 44 74 36561 NAND2X1 $T=1175600 655725 0 0 $X=1175170 $Y=655335
X1611 36050 36841 44 74 36832 NAND2X1 $T=1185120 600845 0 0 $X=1184690 $Y=600455
X1612 81 36840 44 74 36799 NAND2X1 $T=1189040 569485 1 180 $X=1185810 $Y=569095
X1613 79 36840 44 74 36903 NAND2X1 $T=1190720 545965 1 180 $X=1187490 $Y=545575
X1614 97 30843 44 74 36904 NAND2X1 $T=1190720 624365 0 180 $X=1187490 $Y=619810
X1615 90 37086 44 74 37066 NAND2X1 $T=1192960 616525 1 0 $X=1192530 $Y=611970
X1616 79 482 44 74 483 NAND2X1 $T=1197440 491085 0 180 $X=1194210 $Y=486530
X1617 81 36447 44 74 37284 NAND2X1 $T=1202480 545965 0 180 $X=1199250 $Y=541410
X1618 81 36759 44 74 37279 NAND2X1 $T=1203600 577325 1 0 $X=1203170 $Y=572770
X1619 79 37348 44 74 37388 NAND2X1 $T=1208080 506765 0 180 $X=1204850 $Y=502210
X1620 83 29940 44 74 37536 NAND2X1 $T=1215920 632205 0 180 $X=1212690 $Y=627650
X1621 90 37436 44 74 37687 NAND2X1 $T=1219840 616525 1 180 $X=1216610 $Y=616135
X1622 37774 37686 44 74 37765 NAND2X1 $T=1224880 585165 1 180 $X=1221650 $Y=584775
X1623 37799 97 44 74 37664 NAND2X1 $T=1226000 624365 1 180 $X=1222770 $Y=623975
X1624 37818 37709 44 74 37802 NAND2X1 $T=1226560 522445 0 180 $X=1223330 $Y=517890
X1625 90 37821 44 74 37756 NAND2X1 $T=1223760 616525 0 0 $X=1223330 $Y=616135
X1626 79 37797 44 74 37818 NAND2X1 $T=1226560 522445 1 0 $X=1226130 $Y=517890
X1627 83 37884 44 74 37819 NAND2X1 $T=1226560 640045 0 0 $X=1226130 $Y=639655
X1628 37676 497 44 74 500 NAND2X1 $T=1232160 726285 0 0 $X=1231730 $Y=725895
X1629 37901 38023 44 74 38170 NAND2X1 $T=1241120 514605 0 180 $X=1237890 $Y=510050
X1630 38191 37690 44 74 38172 NAND2X1 $T=1241120 718445 1 180 $X=1237890 $Y=718055
X1631 38311 38280 44 74 38291 NAND2X1 $T=1245040 530285 0 180 $X=1241810 $Y=525730
X1632 38546 38521 44 74 38402 NAND2X1 $T=1253440 655725 0 180 $X=1250210 $Y=651170
X1633 38351 38449 44 74 38532 NAND2X1 $T=1251200 545965 1 0 $X=1250770 $Y=541410
X1634 38601 34481 44 74 38463 NAND2X1 $T=1255680 616525 0 180 $X=1252450 $Y=611970
X1635 38822 38855 44 74 38975 NAND2X1 $T=1268560 561645 1 180 $X=1265330 $Y=561255
X1636 39192 38914 44 74 39104 NAND2X1 $T=1274160 632205 0 180 $X=1270930 $Y=627650
X1637 39262 39118 44 74 39010 NAND2X1 $T=1275840 616525 0 180 $X=1272610 $Y=611970
X1638 39590 36950 44 74 39350 NAND2X1 $T=1286480 632205 1 180 $X=1283250 $Y=631815
X1639 39424 39651 44 74 38636 NAND2X1 $T=1284240 624365 1 0 $X=1283810 $Y=619810
X1640 38716 39629 44 74 39806 NAND2X1 $T=1291520 655725 0 180 $X=1288290 $Y=651170
X1641 39842 38463 44 74 39821 NAND2X1 $T=1292080 632205 1 180 $X=1288850 $Y=631815
X1981 44 74 24144 24196 24146 ICV_68 $T=698480 616525 0 0 $X=698050 $Y=616135
X1982 44 74 24376 24701 24832 ICV_68 $T=716960 632205 1 0 $X=716530 $Y=627650
X1983 44 74 25159 24196 25460 ICV_68 $T=733760 624365 0 0 $X=733330 $Y=623975
X1984 44 74 81 25825 25870 ICV_68 $T=750000 545965 1 0 $X=749570 $Y=541410
X1985 44 74 79 26454 26293 ICV_68 $T=769040 538125 0 0 $X=768610 $Y=537735
X1986 44 74 97 26468 26110 ICV_68 $T=769600 663565 1 0 $X=769170 $Y=659010
X1987 44 74 90 26641 26700 ICV_68 $T=783600 616525 1 0 $X=783170 $Y=611970
X1988 44 74 90 26949 26937 ICV_68 $T=794240 608685 0 0 $X=793810 $Y=608295
X1989 44 74 90 27696 27820 ICV_68 $T=830080 647885 0 0 $X=829650 $Y=647495
X1990 44 74 27808 28051 27967 ICV_68 $T=838480 702765 0 0 $X=838050 $Y=702375
X1991 44 74 79 28573 28136 ICV_68 $T=859200 608685 0 0 $X=858770 $Y=608295
X1992 44 74 90 28245 149 ICV_68 $T=867040 679245 0 0 $X=866610 $Y=678855
X1993 44 74 29468 97 29494 ICV_68 $T=890560 718445 1 0 $X=890130 $Y=713890
X1994 44 74 185 29656 29762 ICV_68 $T=900640 561645 1 0 $X=900210 $Y=557090
X1995 44 74 159 29825 29710 ICV_68 $T=903440 577325 1 0 $X=903010 $Y=572770
X1996 44 74 29858 207 29871 ICV_68 $T=906240 530285 1 0 $X=905810 $Y=525730
X1997 44 74 166 29825 29788 ICV_68 $T=911840 569485 0 0 $X=911410 $Y=569095
X1998 44 74 29954 184 30027 ICV_68 $T=912400 538125 1 0 $X=911970 $Y=533570
X1999 44 74 30430 30460 30445 ICV_68 $T=932000 585165 0 0 $X=931570 $Y=584775
X2000 44 74 30508 273 30365 ICV_68 $T=935920 545965 1 0 $X=935490 $Y=541410
X2001 44 74 30477 29645 274 ICV_68 $T=937040 522445 1 0 $X=936610 $Y=517890
X2002 44 74 30631 273 30733 ICV_68 $T=945440 585165 0 0 $X=945010 $Y=584775
X2003 44 74 291 295 30633 ICV_68 $T=945440 718445 0 0 $X=945010 $Y=718055
X2004 44 74 79 31031 30414 ICV_68 $T=957200 679245 1 0 $X=956770 $Y=674690
X2005 44 74 31118 29251 31415 ICV_68 $T=971200 640045 0 0 $X=970770 $Y=639655
X2006 44 74 31286 338 31413 ICV_68 $T=972320 498925 0 0 $X=971890 $Y=498535
X2007 44 74 32318 32440 351 ICV_68 $T=1002560 569485 1 0 $X=1002130 $Y=564930
X2008 44 74 32415 350 32437 ICV_68 $T=1003120 530285 1 0 $X=1002690 $Y=525730
X2009 44 74 32416 32548 32553 ICV_68 $T=1007040 553805 1 0 $X=1006610 $Y=549250
X2010 44 74 31149 28125 32520 ICV_68 $T=1009280 585165 0 0 $X=1008850 $Y=584775
X2011 44 74 81 33106 32834 ICV_68 $T=1025520 694925 1 0 $X=1025090 $Y=690370
X2012 44 74 33132 33172 382 ICV_68 $T=1028880 538125 0 0 $X=1028450 $Y=537735
X2013 44 74 218 385 33168 ICV_68 $T=1030560 498925 0 0 $X=1030130 $Y=498535
X2014 44 74 33257 33220 33277 ICV_68 $T=1032800 671405 1 0 $X=1032370 $Y=666850
X2015 44 74 33105 33328 32696 ICV_68 $T=1035040 506765 0 0 $X=1034610 $Y=506375
X2016 44 74 33049 33495 33487 ICV_68 $T=1044560 663565 1 0 $X=1044130 $Y=659010
X2017 44 74 313 33616 33547 ICV_68 $T=1050720 506765 0 0 $X=1050290 $Y=506375
X2018 44 74 175 422 33711 ICV_68 $T=1056320 545965 1 0 $X=1055890 $Y=541410
X2019 44 74 33669 33732 33733 ICV_68 $T=1057440 506765 1 0 $X=1057010 $Y=502210
X2020 44 74 34026 170 33960 ICV_68 $T=1073680 593005 1 0 $X=1073250 $Y=588450
X2021 44 74 33973 244 34160 ICV_68 $T=1078160 498925 0 0 $X=1077730 $Y=498535
X2022 44 74 244 34053 34179 ICV_68 $T=1082640 522445 1 0 $X=1082210 $Y=517890
X2023 44 74 79 34411 32320 ICV_68 $T=1086560 663565 1 0 $X=1086130 $Y=659010
X2024 44 74 35159 35208 35193 ICV_68 $T=1112880 640045 0 0 $X=1112450 $Y=639655
X2025 44 74 90 35276 461 ICV_68 $T=1115680 726285 1 0 $X=1115250 $Y=721730
X2026 44 74 97 342 35865 ICV_68 $T=1140880 702765 0 0 $X=1140450 $Y=702375
X2027 44 74 36351 97 36367 ICV_68 $T=1162160 694925 1 0 $X=1161730 $Y=690370
X2028 44 74 83 30501 36739 ICV_68 $T=1185120 640045 1 0 $X=1184690 $Y=635490
X2029 44 74 38545 38575 38452 ICV_68 $T=1250640 632205 1 0 $X=1250210 $Y=627650
X2030 44 74 38506 38601 38545 ICV_68 $T=1251760 624365 0 0 $X=1251330 $Y=623975
X2031 44 24034 24078 23960 74 ICV_69 $T=695120 632205 1 0 $X=694690 $Y=627650
X2032 44 24124 24144 24076 74 ICV_69 $T=697360 608685 1 0 $X=696930 $Y=604130
X2033 44 24196 24265 24181 74 ICV_69 $T=699600 632205 1 0 $X=699170 $Y=627650
X2034 44 24078 24126 24483 74 ICV_69 $T=705760 655725 0 0 $X=705330 $Y=655335
X2035 44 24632 24460 24568 74 ICV_69 $T=710240 655725 0 0 $X=709810 $Y=655335
X2036 44 24285 24862 24883 74 ICV_69 $T=719760 640045 0 0 $X=719330 $Y=639655
X2037 44 24078 24196 25385 74 ICV_69 $T=730960 632205 1 0 $X=730530 $Y=627650
X2038 44 79 25915 25900 74 ICV_69 $T=746640 491085 1 0 $X=746210 $Y=486530
X2039 44 84 26340 26296 74 ICV_69 $T=762880 718445 1 0 $X=762450 $Y=713890
X2040 44 90 26582 26607 74 ICV_69 $T=777440 632205 1 0 $X=777010 $Y=627650
X2041 44 26838 26869 26861 74 ICV_69 $T=789760 585165 1 0 $X=789330 $Y=580610
X2042 44 83 26840 26901 74 ICV_69 $T=791440 640045 0 0 $X=791010 $Y=639655
X2043 44 81 26868 27072 74 ICV_69 $T=799280 514605 1 0 $X=798850 $Y=510050
X2044 44 27443 27548 27529 74 ICV_69 $T=816080 561645 0 0 $X=815650 $Y=561255
X2045 44 120 114 28037 74 ICV_69 $T=837360 687085 1 0 $X=836930 $Y=682530
X2046 44 27919 27752 28138 74 ICV_69 $T=841840 687085 1 0 $X=841410 $Y=682530
X2047 44 90 29590 178 74 ICV_69 $T=893920 710605 1 0 $X=893490 $Y=706050
X2048 44 159 29789 29773 74 ICV_69 $T=901200 514605 0 0 $X=900770 $Y=514215
X2049 44 29662 29423 29774 74 ICV_69 $T=901200 530285 0 0 $X=900770 $Y=529895
X2050 44 194 199 196 74 ICV_69 $T=902880 491085 1 0 $X=902450 $Y=486530
X2051 44 29426 29878 210 74 ICV_69 $T=905680 522445 1 0 $X=905250 $Y=517890
X2052 44 29712 29788 29925 74 ICV_69 $T=907920 569485 1 0 $X=907490 $Y=564930
X2053 44 197 30400 30288 74 ICV_69 $T=929200 530285 0 0 $X=928770 $Y=529895
X2054 44 244 29925 30397 74 ICV_69 $T=929760 553805 1 0 $X=929330 $Y=549250
X2055 44 166 30416 29878 74 ICV_69 $T=933680 514605 0 0 $X=933250 $Y=514215
X2056 44 197 29774 30623 74 ICV_69 $T=939840 569485 1 0 $X=939410 $Y=564930
X2057 44 30709 184 30163 74 ICV_69 $T=944320 569485 1 0 $X=943890 $Y=564930
X2058 44 30625 260 30736 74 ICV_69 $T=944880 593005 1 0 $X=944450 $Y=588450
X2059 44 30767 184 30657 74 ICV_69 $T=947680 569485 0 0 $X=947250 $Y=569095
X2060 44 79 31196 30839 74 ICV_69 $T=962800 671405 0 0 $X=962370 $Y=671015
X2061 44 31214 30816 31307 74 ICV_69 $T=966720 671405 1 0 $X=966290 $Y=666850
X2062 44 32485 32588 32583 74 ICV_69 $T=1007040 530285 1 0 $X=1006610 $Y=525730
X2063 44 31194 364 32627 74 ICV_69 $T=1012640 522445 1 0 $X=1012210 $Y=517890
X2064 44 31558 32834 32810 74 ICV_69 $T=1015440 687085 0 0 $X=1015010 $Y=686695
X2065 44 301 369 32791 74 ICV_69 $T=1016000 498925 1 0 $X=1015570 $Y=494370
X2066 44 166 28125 33158 74 ICV_69 $T=1027760 569485 1 0 $X=1027330 $Y=564930
X2067 44 33172 33170 389 74 ICV_69 $T=1031120 545965 0 0 $X=1030690 $Y=545575
X2068 44 218 33152 391 74 ICV_69 $T=1032240 491085 1 0 $X=1031810 $Y=486530
X2069 44 166 33076 33267 74 ICV_69 $T=1032800 577325 1 0 $X=1032370 $Y=572770
X2070 44 33131 398 32846 74 ICV_69 $T=1036720 514605 0 0 $X=1036290 $Y=514215
X2071 44 33275 33387 33375 74 ICV_69 $T=1037840 655725 0 0 $X=1037410 $Y=655335
X2072 44 33406 33313 33452 74 ICV_69 $T=1042320 647885 0 0 $X=1041890 $Y=647495
X2073 44 33425 221 33504 74 ICV_69 $T=1044560 585165 1 0 $X=1044130 $Y=580610
X2074 44 33487 33441 33427 74 ICV_69 $T=1044560 663565 0 0 $X=1044130 $Y=663175
X2075 44 290 32614 33555 74 ICV_69 $T=1047920 498925 0 0 $X=1047490 $Y=498535
X2076 44 33444 33581 33140 74 ICV_69 $T=1048480 624365 0 0 $X=1048050 $Y=623975
X2077 44 33454 33214 410 74 ICV_69 $T=1050160 561645 1 0 $X=1049730 $Y=557090
X2078 44 83 271 423 74 ICV_69 $T=1056880 726285 1 0 $X=1056450 $Y=721730
X2079 44 33682 33486 426 74 ICV_69 $T=1058560 522445 0 0 $X=1058130 $Y=522055
X2080 44 33709 221 33786 74 ICV_69 $T=1059680 577325 0 0 $X=1059250 $Y=576935
X2081 44 186 33315 33946 74 ICV_69 $T=1069200 561645 1 0 $X=1068770 $Y=557090
X2082 44 159 34640 433 74 ICV_69 $T=1094960 498925 0 0 $X=1094530 $Y=498535
X2083 44 166 34685 427 74 ICV_69 $T=1097200 506765 1 0 $X=1096770 $Y=502210
X2084 44 79 36334 36234 74 ICV_69 $T=1159360 585165 1 0 $X=1158930 $Y=580610
X2085 44 97 36059 36253 74 ICV_69 $T=1162720 702765 0 0 $X=1162290 $Y=702375
X2086 44 36218 36799 36781 74 ICV_69 $T=1181760 577325 0 0 $X=1181330 $Y=576935
X2087 44 36675 97 36869 74 ICV_69 $T=1185120 647885 0 0 $X=1184690 $Y=647495
X2088 44 83 37822 37720 74 ICV_69 $T=1222080 647885 0 0 $X=1221650 $Y=647495
X2089 44 38393 38421 38299 74 ICV_69 $T=1244480 616525 0 0 $X=1244050 $Y=616135
X2090 44 38601 38667 38722 74 ICV_69 $T=1255680 624365 0 0 $X=1255250 $Y=623975
X2091 44 38902 39069 39028 74 ICV_69 $T=1266320 663565 1 0 $X=1265890 $Y=659010
X2092 44 39396 34348 38573 74 ICV_69 $T=1276400 663565 0 0 $X=1275970 $Y=663175
X2093 44 34348 34119 39193 74 ICV_69 $T=1278080 655725 0 0 $X=1277650 $Y=655335
X2094 23987 23935 44 74 23966 NOR2X1 $T=697360 647885 0 180 $X=694130 $Y=643330
X2095 24181 24261 44 74 24262 NOR2X1 $T=701280 640045 0 0 $X=700850 $Y=639655
X2096 24126 24308 44 74 24155 NOR2X1 $T=702400 647885 1 0 $X=701970 $Y=643330
X2097 24286 24262 44 74 24308 NOR2X1 $T=702960 647885 0 0 $X=702530 $Y=647495
X2098 24330 24376 44 74 24214 NOR2X1 $T=704080 600845 0 0 $X=703650 $Y=600455
X2099 24418 24126 44 74 24238 NOR2X1 $T=708000 640045 0 180 $X=704770 $Y=635490
X2100 24348 24438 44 74 24286 NOR2X1 $T=705760 647885 0 0 $X=705330 $Y=647495
X2101 24376 24481 44 74 24458 NOR2X1 $T=706880 600845 1 0 $X=706450 $Y=596290
X2102 24458 24504 44 74 24480 NOR2X1 $T=707440 593005 1 0 $X=707010 $Y=588450
X2103 24040 24126 44 74 24331 NOR2X1 $T=710800 624365 0 180 $X=707570 $Y=619810
X2104 24547 24588 44 74 24481 NOR2X1 $T=709680 600845 1 0 $X=709250 $Y=596290
X2105 24418 24752 44 74 24814 NOR2X1 $T=719200 624365 0 180 $X=715970 $Y=619810
X2106 24418 24376 44 74 24945 NOR2X1 $T=722560 624365 1 180 $X=719330 $Y=623975
X2107 24883 24962 44 74 24215 NOR2X1 $T=719760 632205 0 0 $X=719330 $Y=631815
X2108 24862 24589 44 74 24961 NOR2X1 $T=723120 608685 0 180 $X=719890 $Y=604130
X2109 24963 24999 44 74 24438 NOR2X1 $T=720880 647885 0 0 $X=720450 $Y=647495
X2110 24701 24285 44 74 24964 NOR2X1 $T=724800 647885 0 180 $X=721570 $Y=643330
X2111 24797 24330 44 74 24144 NOR2X1 $T=726480 600845 1 0 $X=726050 $Y=596290
X2112 24862 24285 44 74 24078 NOR2X1 $T=730960 616525 0 180 $X=727730 $Y=611970
X2113 24078 24962 44 74 25215 NOR2X1 $T=730960 632205 0 180 $X=727730 $Y=627650
X2114 24078 24341 44 74 25218 NOR2X1 $T=730960 632205 1 180 $X=727730 $Y=631815
X2115 25138 25192 44 74 25232 NOR2X1 $T=728160 647885 0 0 $X=727730 $Y=647495
X2116 25218 25215 44 74 25254 NOR2X1 $T=729280 640045 0 0 $X=728850 $Y=639655
X2117 24701 24862 44 74 24963 NOR2X1 $T=729280 647885 1 0 $X=728850 $Y=643330
X2118 24144 25254 44 74 25324 NOR2X1 $T=734880 640045 1 180 $X=731650 $Y=639655
X2119 25324 25323 44 74 25346 NOR2X1 $T=732080 647885 1 0 $X=731650 $Y=643330
X2120 24265 24330 44 74 24777 NOR2X1 $T=733760 600845 0 0 $X=733330 $Y=600455
X2121 24265 24196 44 74 24039 NOR2X1 $T=735440 616525 1 0 $X=735010 $Y=611970
X2122 25215 25459 44 74 25494 NOR2X1 $T=737680 640045 1 0 $X=737250 $Y=635490
X2123 24840 25567 44 74 25585 NOR2X1 $T=739360 655725 1 0 $X=738930 $Y=651170
X2124 25644 24102 44 74 25714 NOR2X1 $T=742720 640045 0 0 $X=742290 $Y=639655
X2125 24701 24752 44 74 25540 NOR2X1 $T=746640 632205 1 180 $X=743410 $Y=631815
X2126 27531 27512 44 74 117 NOR2X1 $T=820000 726285 1 180 $X=816770 $Y=725895
X2127 27625 27655 44 74 27626 NOR2X1 $T=822240 694925 1 0 $X=821810 $Y=690370
X2128 27656 27626 44 74 27538 NOR2X1 $T=825040 702765 0 180 $X=821810 $Y=698210
X2129 120 27737 44 74 27726 NOR2X1 $T=825600 687085 1 0 $X=825170 $Y=682530
X2130 127 27711 44 74 27737 NOR2X1 $T=828960 687085 1 180 $X=825730 $Y=686695
X2131 27766 27605 44 74 27512 NOR2X1 $T=829520 718445 1 180 $X=826290 $Y=718055
X2132 27625 27752 44 74 120 NOR2X1 $T=827280 694925 1 0 $X=826850 $Y=690370
X2133 27766 27711 44 74 27808 NOR2X1 $T=831760 710605 1 180 $X=828530 $Y=710215
X2134 27821 27726 44 74 27839 NOR2X1 $T=832880 687085 0 180 $X=829650 $Y=682530
X2135 123 27532 44 74 129 NOR2X1 $T=830080 726285 0 0 $X=829650 $Y=725895
X2136 27605 127 44 74 27802 NOR2X1 $T=834560 710605 1 180 $X=831330 $Y=710215
X2137 27840 128 44 74 27918 NOR2X1 $T=836240 718445 1 180 $X=833010 $Y=718055
X2138 27918 27839 44 74 27935 NOR2X1 $T=837360 687085 0 180 $X=834130 $Y=682530
X2139 27766 27946 44 74 27656 NOR2X1 $T=834560 710605 0 0 $X=834130 $Y=710215
X2140 118 27935 44 74 27914 NOR2X1 $T=837920 687085 1 180 $X=834690 $Y=686695
X2141 27712 27860 44 74 27892 NOR2X1 $T=839040 702765 1 0 $X=838610 $Y=698210
X2142 28007 28019 44 74 136 NOR2X1 $T=839040 726285 1 0 $X=838610 $Y=721730
X2143 28232 27752 44 74 143 NOR2X1 $T=850800 702765 0 180 $X=847570 $Y=698210
X2144 27625 137 44 74 140 NOR2X1 $T=850800 702765 1 0 $X=850370 $Y=698210
X2145 28320 27512 44 74 144 NOR2X1 $T=855280 726285 0 180 $X=852050 $Y=721730
X2146 28134 123 44 74 28079 NOR2X1 $T=863680 702765 1 180 $X=860450 $Y=702375
X2147 127 27860 44 74 28320 NOR2X1 $T=860880 718445 1 0 $X=860450 $Y=713890
X2148 29872 29926 44 74 29907 NOR2X1 $T=909040 569485 0 0 $X=908610 $Y=569095
X2149 30048 29982 44 74 29904 NOR2X1 $T=916880 561645 1 180 $X=913650 $Y=561255
X2150 30028 30095 44 74 30111 NOR2X1 $T=918560 545965 0 0 $X=918130 $Y=545575
X2151 30126 30245 44 74 30265 NOR2X1 $T=926400 538125 1 0 $X=925970 $Y=533570
X2152 30336 30312 44 74 29549 NOR2X1 $T=930880 538125 1 180 $X=927650 $Y=537735
X2153 30428 30069 44 74 30475 NOR2X1 $T=934800 514605 1 0 $X=934370 $Y=510050
X2154 30470 30471 44 74 30478 NOR2X1 $T=937600 561645 1 180 $X=934370 $Y=561255
X2155 30379 30491 44 74 30476 NOR2X1 $T=934800 593005 0 0 $X=934370 $Y=592615
X2156 30531 30429 44 74 30460 NOR2X1 $T=939840 577325 0 180 $X=936610 $Y=572770
X2157 30511 270 44 74 29591 NOR2X1 $T=937040 718445 0 0 $X=936610 $Y=718055
X2158 237 30475 44 74 30528 NOR2X1 $T=940400 514605 0 180 $X=937170 $Y=510050
X2159 30528 30607 44 74 30555 NOR2X1 $T=940400 514605 1 0 $X=939970 $Y=510050
X2160 30674 30458 44 74 30658 NOR2X1 $T=946000 530285 0 180 $X=942770 $Y=525730
X2161 30687 30616 44 74 30636 NOR2X1 $T=946560 600845 0 180 $X=943330 $Y=596290
X2162 30708 30732 44 74 30121 NOR2X1 $T=946000 538125 1 0 $X=945570 $Y=533570
X2163 30856 30398 44 74 30881 NOR2X1 $T=952160 593005 0 0 $X=951730 $Y=592615
X2164 281 286 44 74 309 NOR2X1 $T=953840 718445 1 0 $X=953410 $Y=713890
X2165 30891 30937 44 74 30553 NOR2X1 $T=954400 514605 1 0 $X=953970 $Y=510050
X2166 30821 314 44 74 311 NOR2X1 $T=954400 710605 0 0 $X=953970 $Y=710215
X2167 30948 30338 44 74 30959 NOR2X1 $T=956080 569485 1 0 $X=955650 $Y=564930
X2168 237 30959 44 74 30964 NOR2X1 $T=956080 577325 0 0 $X=955650 $Y=576935
X2169 30949 30964 44 74 30978 NOR2X1 $T=956640 593005 1 0 $X=956210 $Y=588450
X2170 314 293 44 74 298 NOR2X1 $T=959440 710605 1 0 $X=959010 $Y=706050
X2171 31075 30545 44 74 30960 NOR2X1 $T=962800 647885 0 180 $X=959570 $Y=643330
X2172 30545 31167 44 74 31028 NOR2X1 $T=965040 640045 0 0 $X=964610 $Y=639655
X2173 319 330 44 74 316 NOR2X1 $T=966160 726285 0 0 $X=965730 $Y=725895
X2174 31207 30743 44 74 31029 NOR2X1 $T=968400 624365 0 0 $X=967970 $Y=623975
X2175 29251 31167 44 74 30930 NOR2X1 $T=971200 640045 1 180 $X=967970 $Y=639655
X2176 31207 31328 44 74 31256 NOR2X1 $T=970640 632205 1 0 $X=970210 $Y=627650
X2177 31290 31118 44 74 31066 NOR2X1 $T=974000 632205 1 180 $X=970770 $Y=631815
X2178 312 321 44 74 337 NOR2X1 $T=975680 726285 0 180 $X=972450 $Y=721730
X2179 31456 31490 44 74 31470 NOR2X1 $T=974000 663565 0 0 $X=973570 $Y=663175
X2180 31493 31227 44 74 30920 NOR2X1 $T=978480 608685 1 180 $X=975250 $Y=608295
X2181 31556 31493 44 74 31639 NOR2X1 $T=979040 624365 0 0 $X=978610 $Y=623975
X2182 30545 31451 44 74 31637 NOR2X1 $T=979040 640045 0 0 $X=978610 $Y=639655
X2183 30545 30743 44 74 31626 NOR2X1 $T=982960 616525 1 180 $X=979730 $Y=616135
X2184 31451 31328 44 74 31539 NOR2X1 $T=982960 624365 0 180 $X=979730 $Y=619810
X2185 29251 31075 44 74 31578 NOR2X1 $T=986320 640045 1 180 $X=983090 $Y=639655
X2186 212 159 44 74 31148 NOR2X1 $T=991360 577325 1 0 $X=990930 $Y=572770
X2187 212 166 44 74 31149 NOR2X1 $T=993600 577325 0 0 $X=993170 $Y=576935
X2188 31074 32080 44 74 32261 NOR2X1 $T=998080 624365 0 0 $X=997650 $Y=623975
X2189 31860 32214 44 74 32245 NOR2X1 $T=998080 632205 0 0 $X=997650 $Y=631815
X2190 30921 31973 44 74 32262 NOR2X1 $T=998640 655725 0 0 $X=998210 $Y=655335
X2191 206 166 44 74 32378 NOR2X1 $T=1005360 569485 0 0 $X=1004930 $Y=569095
X2192 32564 32595 44 74 32584 NOR2X1 $T=1009280 538125 0 0 $X=1008850 $Y=537735
X2193 328 32628 44 74 32564 NOR2X1 $T=1010400 545965 1 0 $X=1009970 $Y=541410
X2194 159 206 44 74 32629 NOR2X1 $T=1013200 577325 1 0 $X=1012770 $Y=572770
X2195 32763 365 44 74 31241 NOR2X1 $T=1016000 491085 0 0 $X=1015570 $Y=490695
X2196 32806 32581 44 74 32792 NOR2X1 $T=1019360 514605 0 180 $X=1016130 $Y=510050
X2197 32981 33010 44 74 32994 NOR2X1 $T=1023280 553805 1 0 $X=1022850 $Y=549250
X2198 32982 33011 44 74 376 NOR2X1 $T=1023280 608685 1 0 $X=1022850 $Y=604130
X2199 33012 33048 44 74 33032 NOR2X1 $T=1024400 632205 0 0 $X=1023970 $Y=631815
X2200 33063 33032 44 74 33034 NOR2X1 $T=1027760 663565 0 180 $X=1024530 $Y=659010
X2201 33064 33034 44 74 33021 NOR2X1 $T=1027760 663565 1 180 $X=1024530 $Y=663175
X2202 33103 33013 44 74 33095 NOR2X1 $T=1029440 655725 0 180 $X=1026210 $Y=651170
X2203 33092 33115 44 74 33012 NOR2X1 $T=1027200 632205 1 0 $X=1026770 $Y=627650
X2204 33095 33159 44 74 33102 NOR2X1 $T=1029440 640045 0 0 $X=1029010 $Y=639655
X2205 33275 33220 44 74 33103 NOR2X1 $T=1036720 640045 0 180 $X=1033490 $Y=635490
X2206 33174 33257 44 74 33242 NOR2X1 $T=1034480 655725 1 0 $X=1034050 $Y=651170
X2207 33313 33337 44 74 33064 NOR2X1 $T=1036720 671405 1 0 $X=1036290 $Y=666850
X2208 33092 33228 44 74 33339 NOR2X1 $T=1037280 655725 1 0 $X=1036850 $Y=651170
X2209 33257 33337 44 74 33349 NOR2X1 $T=1037840 671405 0 0 $X=1037410 $Y=671015
X2210 33339 33379 44 74 33257 NOR2X1 $T=1040080 655725 1 0 $X=1039650 $Y=651170
X2211 33426 33407 44 74 33117 NOR2X1 $T=1044560 671405 0 180 $X=1041330 $Y=666850
X2212 33428 33408 44 74 33407 NOR2X1 $T=1044560 679245 0 180 $X=1041330 $Y=674690
X2213 33361 33437 44 74 33426 NOR2X1 $T=1042320 655725 0 0 $X=1041890 $Y=655335
X2214 33202 33387 44 74 33406 NOR2X1 $T=1047360 647885 0 180 $X=1044130 $Y=643330
X2215 33092 33428 44 74 33515 NOR2X1 $T=1050160 679245 0 180 $X=1046930 $Y=674690
X2216 33536 33443 44 74 33525 NOR2X1 $T=1050720 593005 0 180 $X=1047490 $Y=588450
X2217 33329 33228 44 74 33465 NOR2X1 $T=1050720 647885 0 180 $X=1047490 $Y=643330
X2218 33539 33515 44 74 33526 NOR2X1 $T=1050720 679245 1 180 $X=1047490 $Y=678855
X2219 33540 33349 44 74 33527 NOR2X1 $T=1050720 687085 0 180 $X=1047490 $Y=682530
X2220 33489 33362 44 74 33540 NOR2X1 $T=1049040 671405 0 0 $X=1048610 $Y=671015
X2221 33477 33241 44 74 33220 NOR2X1 $T=1050160 632205 0 0 $X=1049730 $Y=631815
X2222 33579 33558 44 74 33568 NOR2X1 $T=1052960 655725 0 180 $X=1049730 $Y=651170
X2223 33474 33610 44 74 33611 NOR2X1 $T=1051840 585165 0 0 $X=1051410 $Y=584775
X2224 33608 33524 44 74 33617 NOR2X1 $T=1055200 577325 1 180 $X=1051970 $Y=576935
X2225 33630 33568 44 74 33271 NOR2X1 $T=1053520 655725 0 0 $X=1053090 $Y=655335
X2226 33651 33579 44 74 33489 NOR2X1 $T=1056320 671405 0 180 $X=1053090 $Y=666850
X2227 33631 33325 44 74 33640 NOR2X1 $T=1053520 687085 0 0 $X=1053090 $Y=686695
X2228 33661 33189 44 74 33558 NOR2X1 $T=1056880 663565 0 180 $X=1053650 $Y=659010
X2229 33092 33387 44 74 33141 NOR2X1 $T=1057440 640045 1 180 $X=1054210 $Y=639655
X2230 33581 33627 44 74 33674 NOR2X1 $T=1058000 632205 0 180 $X=1054770 $Y=627650
X2231 33220 33684 44 74 33691 NOR2X1 $T=1059120 640045 0 180 $X=1055890 $Y=635490
X2232 33477 33651 44 74 33661 NOR2X1 $T=1056880 663565 1 0 $X=1056450 $Y=659010
X2233 33691 33612 44 74 33712 NOR2X1 $T=1060240 640045 1 180 $X=1057010 $Y=639655
X2234 33444 33674 44 74 33684 NOR2X1 $T=1058000 632205 1 0 $X=1057570 $Y=627650
X2235 33701 33718 44 74 33834 NOR2X1 $T=1064160 577325 1 0 $X=1063730 $Y=572770
X2236 33556 33901 44 74 33959 NOR2X1 $T=1071440 561645 0 0 $X=1071010 $Y=561255
X2237 33910 34100 44 74 34101 NOR2X1 $T=1077040 585165 0 0 $X=1076610 $Y=584775
X2238 33844 34054 44 74 34177 NOR2X1 $T=1079840 569485 1 0 $X=1079410 $Y=564930
X2239 170 34252 44 74 33760 NOR2X1 $T=1082080 585165 0 0 $X=1081650 $Y=584775
X2240 33779 34268 44 74 34251 NOR2X1 $T=1082640 577325 1 0 $X=1082210 $Y=572770
X2241 34220 34346 44 74 34336 NOR2X1 $T=1085440 522445 0 0 $X=1085010 $Y=522055
X2242 34381 33976 44 74 34296 NOR2X1 $T=1089360 545965 1 180 $X=1086130 $Y=545575
X2243 34365 34172 44 74 34379 NOR2X1 $T=1087120 522445 1 0 $X=1086690 $Y=517890
X2244 34520 34449 44 74 34434 NOR2X1 $T=1096080 553805 0 180 $X=1092850 $Y=549250
X2245 34408 34487 44 74 34541 NOR2X1 $T=1093840 506765 0 0 $X=1093410 $Y=506375
X2246 84 135 44 74 78 NOR2X1 $T=1170560 679245 0 180 $X=1167330 $Y=674690
X2247 497 37945 44 74 37902 NOR2X1 $T=1229360 553805 0 0 $X=1228930 $Y=553415
X2248 497 38050 44 74 501 NOR2X1 $T=1237760 694925 1 180 $X=1234530 $Y=694535
X2249 38152 38189 44 74 86 NOR2X1 $T=1238320 553805 1 0 $X=1237890 $Y=549250
X2250 38153 38190 44 74 38171 NOR2X1 $T=1238320 577325 0 0 $X=1237890 $Y=576935
X2251 38004 38064 44 74 38292 NOR2X1 $T=1245040 545965 1 180 $X=1241810 $Y=545575
X2252 497 38312 44 74 79 NOR2X1 $T=1242240 569485 1 0 $X=1241810 $Y=564930
X2253 38288 38371 44 74 503 NOR2X1 $T=1244480 600845 0 0 $X=1244050 $Y=600455
X2254 25419 38371 44 74 38050 NOR2X1 $T=1244480 608685 0 0 $X=1244050 $Y=608295
X2255 38069 38007 44 74 38370 NOR2X1 $T=1245040 545965 0 0 $X=1244610 $Y=545575
X2256 38486 38450 44 74 38338 NOR2X1 $T=1251200 624365 0 180 $X=1247970 $Y=619810
X2257 38310 38351 44 74 38529 NOR2X1 $T=1250640 530285 0 0 $X=1250210 $Y=529895
X2258 497 38564 44 74 38544 NOR2X1 $T=1251200 561645 1 0 $X=1250770 $Y=557090
X2259 38566 38590 44 74 38446 NOR2X1 $T=1252320 647885 0 0 $X=1251890 $Y=647495
X2260 504 38517 44 74 38589 NOR2X1 $T=1252880 569485 0 0 $X=1252450 $Y=569095
X2261 38609 38573 44 74 38451 NOR2X1 $T=1255680 632205 1 180 $X=1252450 $Y=631815
X2262 38479 38351 44 74 38610 NOR2X1 $T=1256240 530285 1 180 $X=1253010 $Y=529895
X2263 38310 38327 44 74 38588 NOR2X1 $T=1255120 538125 0 0 $X=1254690 $Y=537735
X2264 38517 38558 44 74 38703 NOR2X1 $T=1256800 553805 1 0 $X=1256370 $Y=549250
X2265 38701 38736 44 74 38024 NOR2X1 $T=1257360 640045 1 0 $X=1256930 $Y=635490
X2266 36565 38530 44 74 38772 NOR2X1 $T=1261840 671405 0 180 $X=1258610 $Y=666850
X2267 38772 38506 44 74 38773 NOR2X1 $T=1261840 671405 1 180 $X=1258610 $Y=671015
X2268 38803 38837 44 74 38823 NOR2X1 $T=1260720 640045 1 0 $X=1260290 $Y=635490
X2269 38764 38556 44 74 38803 NOR2X1 $T=1264640 647885 0 180 $X=1261410 $Y=643330
X2270 38716 39131 44 74 38757 NOR2X1 $T=1269680 647885 1 0 $X=1269250 $Y=643330
X2271 39130 39091 44 74 36159 NOR2X1 $T=1272480 679245 0 180 $X=1269250 $Y=674690
X2272 39222 39193 44 74 39172 NOR2X1 $T=1275280 647885 0 180 $X=1272050 $Y=643330
X2273 39235 39118 44 74 39131 NOR2X1 $T=1275280 655725 0 180 $X=1272050 $Y=651170
X2274 38930 39303 44 74 39246 NOR2X1 $T=1278080 647885 1 180 $X=1274850 $Y=647495
X2275 38766 39356 44 74 39277 NOR2X1 $T=1275840 616525 1 0 $X=1275410 $Y=611970
X2276 32914 38764 44 74 38930 NOR2X1 $T=1280320 640045 0 0 $X=1279890 $Y=639655
X2277 38764 39494 44 74 39408 NOR2X1 $T=1283680 632205 1 180 $X=1280450 $Y=631815
X2278 34119 38716 44 74 39590 NOR2X1 $T=1282560 647885 1 0 $X=1282130 $Y=643330
X2279 39627 39303 44 74 39483 NOR2X1 $T=1285920 608685 0 180 $X=1282690 $Y=604130
X2280 39651 34119 44 74 39396 NOR2X1 $T=1286480 647885 1 180 $X=1283250 $Y=647495
X2281 36565 36950 44 74 39627 NOR2X1 $T=1287040 608685 1 180 $X=1283810 $Y=608295
X2282 36565 39651 44 74 39064 NOR2X1 $T=1289280 632205 1 180 $X=1286050 $Y=631815
X2283 39780 39624 44 74 39334 NOR2X1 $T=1289840 671405 0 180 $X=1286610 $Y=666850
X2284 39629 34348 44 74 39118 NOR2X1 $T=1290400 663565 0 180 $X=1287170 $Y=659010
X2285 32914 39629 44 74 39780 NOR2X1 $T=1288160 663565 0 0 $X=1287730 $Y=663175
X2286 38764 39423 44 74 39303 NOR2X1 $T=1288720 616525 1 0 $X=1288290 $Y=611970
X2287 44 74 79 26085 25867 ICV_81 $T=751680 545965 0 0 $X=751250 $Y=545575
X2288 44 74 83 26486 26429 ICV_81 $T=772400 632205 1 0 $X=771970 $Y=627650
X2289 44 74 97 108 26913 ICV_81 $T=797040 663565 0 0 $X=796610 $Y=663175
X2290 44 74 81 27055 27043 ICV_81 $T=797600 530285 1 0 $X=797170 $Y=525730
X2291 44 74 83 126 27594 ICV_81 $T=822800 655725 0 0 $X=822370 $Y=655335
X2292 44 74 27802 28232 28544 ICV_81 $T=858080 702765 1 0 $X=857650 $Y=698210
X2293 44 74 29620 29647 182 ICV_81 $T=895040 514605 1 0 $X=894610 $Y=510050
X2294 44 74 79 30235 28435 ICV_81 $T=920800 640045 1 0 $X=920370 $Y=635490
X2295 44 74 30248 30745 30735 ICV_81 $T=944320 561645 1 0 $X=943890 $Y=557090
X2296 44 74 30477 272 30233 ICV_81 $T=961680 530285 0 0 $X=961250 $Y=529895
X2297 44 74 31227 31118 31371 ICV_81 $T=968960 608685 0 0 $X=968530 $Y=608295
X2298 44 74 32794 260 32969 ICV_81 $T=1019920 593005 1 0 $X=1019490 $Y=588450
X2299 44 74 33300 33329 33211 ICV_81 $T=1033920 624365 0 0 $X=1033490 $Y=623975
X2300 44 74 32629 33076 33240 ICV_81 $T=1035600 593005 0 0 $X=1035170 $Y=592615
X2301 44 74 313 33590 33566 ICV_81 $T=1050160 514605 1 0 $X=1049730 $Y=510050
X2302 44 74 185 32846 33744 ICV_81 $T=1057440 522445 1 0 $X=1057010 $Y=517890
X2303 44 74 32725 260 33899 ICV_81 $T=1066400 553805 0 0 $X=1065970 $Y=553415
X2304 44 74 185 34175 34153 ICV_81 $T=1077600 561645 1 0 $X=1077170 $Y=557090
X2305 44 74 197 32619 34308 ICV_81 $T=1082080 498925 1 0 $X=1081650 $Y=494370
X2306 44 74 166 34640 33997 ICV_81 $T=1093840 498925 1 0 $X=1093410 $Y=494370
X2307 44 74 34683 35275 35294 ICV_81 $T=1115680 655725 1 0 $X=1115250 $Y=651170
X2308 44 74 83 470 35967 ICV_81 $T=1148720 702765 0 0 $X=1148290 $Y=702375
X2309 44 74 79 36275 35342 ICV_81 $T=1156000 600845 0 0 $X=1155570 $Y=600455
X2310 44 74 90 36271 36333 ICV_81 $T=1159360 647885 0 0 $X=1158930 $Y=647495
X2311 44 74 97 30922 36372 ICV_81 $T=1164400 694925 0 0 $X=1163970 $Y=694535
X2312 44 74 78 493 37567 ICV_81 $T=1213120 726285 1 0 $X=1212690 $Y=721730
X2313 44 74 37961 38069 37922 ICV_81 $T=1232160 545965 0 0 $X=1231730 $Y=545575
X2314 44 74 38531 38685 38665 ICV_81 $T=1253440 530285 1 0 $X=1253010 $Y=525730
X2315 44 74 24285 24330 24307 ICV_76 $T=702400 616525 0 0 $X=701970 $Y=616135
X2316 44 74 24330 24040 24548 ICV_76 $T=713040 616525 1 0 $X=712610 $Y=611970
X2317 44 74 24261 24701 24611 ICV_76 $T=713040 647885 0 0 $X=712610 $Y=647495
X2318 44 74 24692 25661 25644 ICV_76 $T=740480 640045 1 0 $X=740050 $Y=635490
X2319 44 74 25826 25870 25846 ICV_76 $T=746640 545965 1 0 $X=746210 $Y=541410
X2320 44 74 25902 26009 25996 ICV_76 $T=750560 718445 1 0 $X=750130 $Y=713890
X2321 44 74 84 26174 89 ICV_76 $T=758400 718445 0 0 $X=757970 $Y=718055
X2322 44 74 26098 97 26366 ICV_76 $T=765680 647885 1 0 $X=765250 $Y=643330
X2323 44 74 97 26486 26472 ICV_76 $T=774640 640045 0 0 $X=774210 $Y=639655
X2324 44 74 97 26555 26588 ICV_76 $T=778000 663565 0 0 $X=777570 $Y=663175
X2325 44 74 90 26619 26604 ICV_76 $T=778560 616525 0 0 $X=778130 $Y=616135
X2326 44 74 79 26772 26815 ICV_76 $T=794240 530285 1 0 $X=793810 $Y=525730
X2327 44 74 79 26991 26891 ICV_76 $T=796480 498925 0 0 $X=796050 $Y=498535
X2328 44 74 81 26808 26918 ICV_76 $T=798720 491085 1 0 $X=798290 $Y=486530
X2329 44 74 81 27659 27548 ICV_76 $T=821680 569485 0 0 $X=821250 $Y=569095
X2330 44 74 27627 27660 27570 ICV_76 $T=821680 718445 1 0 $X=821250 $Y=713890
X2331 44 74 27675 28098 28051 ICV_76 $T=842400 702765 0 0 $X=841970 $Y=702375
X2332 44 74 28079 28320 28246 ICV_76 $T=851360 702765 0 0 $X=850930 $Y=702375
X2333 44 74 27752 28134 28303 ICV_76 $T=852480 679245 1 0 $X=852050 $Y=674690
X2334 44 74 114 27802 28367 ICV_76 $T=855280 710605 0 0 $X=854850 $Y=710215
X2335 44 74 90 28769 28905 ICV_76 $T=869840 663565 1 0 $X=869410 $Y=659010
X2336 44 74 90 29003 150 ICV_76 $T=872080 702765 1 0 $X=871650 $Y=698210
X2337 44 74 90 29320 29308 ICV_76 $T=883840 710605 1 0 $X=883410 $Y=706050
X2338 44 74 97 158 29332 ICV_76 $T=884400 710605 0 0 $X=883970 $Y=710215
X2339 44 74 29602 184 29621 ICV_76 $T=896160 538125 0 0 $X=895730 $Y=537735
X2340 44 74 29536 29663 29646 ICV_76 $T=897280 624365 0 0 $X=896850 $Y=623975
X2341 44 74 29775 29806 193 ICV_76 $T=902880 585165 1 0 $X=902450 $Y=580610
X2342 44 74 29376 29846 201 ICV_76 $T=905120 491085 0 0 $X=904690 $Y=490695
X2343 44 74 90 29880 215 ICV_76 $T=909040 718445 0 0 $X=908610 $Y=718055
X2344 44 74 30087 30121 28524 ICV_76 $T=916880 569485 1 0 $X=916450 $Y=564930
X2345 44 74 159 30127 239 ICV_76 $T=919680 506765 1 0 $X=919250 $Y=502210
X2346 44 74 81 30147 30160 ICV_76 $T=923040 663565 1 0 $X=922610 $Y=659010
X2347 44 74 90 30246 247 ICV_76 $T=924160 718445 0 0 $X=923730 $Y=718055
X2348 44 74 166 30182 255 ICV_76 $T=930320 514605 0 0 $X=929890 $Y=514215
X2349 44 74 30414 30447 30432 ICV_76 $T=932000 663565 0 0 $X=931570 $Y=663175
X2350 44 74 255 30477 30314 ICV_76 $T=933680 522445 0 0 $X=933250 $Y=522055
X2351 44 74 287 283 30731 ICV_76 $T=945440 522445 1 0 $X=945010 $Y=517890
X2352 44 74 30892 30924 30904 ICV_76 $T=953280 624365 0 0 $X=952850 $Y=623975
X2353 44 74 313 261 30947 ICV_76 $T=958320 530285 0 0 $X=957890 $Y=529895
X2354 44 74 31045 31077 31067 ICV_76 $T=959440 647885 0 0 $X=959010 $Y=647495
X2355 44 74 30930 31075 31045 ICV_76 $T=959440 655725 1 0 $X=959010 $Y=651170
X2356 44 74 294 31194 327 ICV_76 $T=963920 491085 0 0 $X=963490 $Y=490695
X2357 44 74 159 31195 310 ICV_76 $T=963920 522445 1 0 $X=963490 $Y=517890
X2358 44 74 30221 331 31255 ICV_76 $T=966160 498925 1 0 $X=965730 $Y=494370
X2359 44 74 31256 31290 31239 ICV_76 $T=967280 632205 1 0 $X=966850 $Y=627650
X2360 44 74 329 312 31288 ICV_76 $T=967840 718445 0 0 $X=967410 $Y=718055
X2361 44 74 30545 31328 31192 ICV_76 $T=968400 616525 1 0 $X=967970 $Y=611970
X2362 44 74 32284 184 32323 ICV_76 $T=999760 545965 0 0 $X=999330 $Y=545575
X2363 44 74 32378 32793 32728 ICV_76 $T=1016000 577325 1 0 $X=1015570 $Y=572770
X2364 44 74 303 377 32958 ICV_76 $T=1022160 498925 0 0 $X=1021730 $Y=498535
X2365 44 74 244 32833 32980 ICV_76 $T=1022160 522445 0 0 $X=1021730 $Y=522055
X2366 44 74 159 30582 33030 ICV_76 $T=1023840 577325 1 0 $X=1023410 $Y=572770
X2367 44 74 218 33094 32966 ICV_76 $T=1025520 538125 0 0 $X=1025090 $Y=537735
X2368 44 74 33114 33189 33148 ICV_76 $T=1029440 663565 0 0 $X=1029010 $Y=663175
X2369 44 74 33105 33280 392 ICV_76 $T=1033360 514605 1 0 $X=1032930 $Y=510050
X2370 44 74 33328 33430 400 ICV_76 $T=1041200 506765 1 0 $X=1040770 $Y=502210
X2371 44 74 33405 33275 33404 ICV_76 $T=1041200 632205 1 0 $X=1040770 $Y=627650
X2372 44 74 79 33466 33302 ICV_76 $T=1043440 694925 0 0 $X=1043010 $Y=694535
X2373 44 74 303 357 33475 ICV_76 $T=1044560 498925 0 0 $X=1044130 $Y=498535
X2374 44 74 303 33523 33514 ICV_76 $T=1046800 514605 1 0 $X=1046370 $Y=510050
X2375 44 74 33394 33542 408 ICV_76 $T=1047920 545965 0 0 $X=1047490 $Y=545575
X2376 44 74 33213 409 33590 ICV_76 $T=1050160 514605 0 0 $X=1049730 $Y=514215
X2377 44 74 166 33243 409 ICV_76 $T=1054080 530285 1 0 $X=1053650 $Y=525730
X2378 44 74 290 33693 33681 ICV_76 $T=1055200 514605 1 0 $X=1054770 $Y=510050
X2379 44 74 425 431 32614 ICV_76 $T=1062480 498925 1 0 $X=1062050 $Y=494370
X2380 44 74 33768 33824 33808 ICV_76 $T=1062480 647885 0 0 $X=1062050 $Y=647495
X2381 44 74 166 28751 33729 ICV_76 $T=1063040 522445 0 0 $X=1062610 $Y=522055
X2382 44 74 33189 33387 33845 ICV_76 $T=1064160 663565 1 0 $X=1063730 $Y=659010
X2383 44 74 33525 33960 439 ICV_76 $T=1070320 593005 1 0 $X=1069890 $Y=588450
X2384 44 74 185 33436 33998 ICV_76 $T=1072000 553805 1 0 $X=1071570 $Y=549250
X2385 44 74 33520 221 34094 ICV_76 $T=1076480 577325 0 0 $X=1076050 $Y=576935
X2386 44 74 33650 221 34117 ICV_76 $T=1077040 569485 0 0 $X=1076610 $Y=569095
X2387 44 74 197 33996 34309 ICV_76 $T=1083760 506765 1 0 $X=1083330 $Y=502210
X2388 44 74 34130 184 34451 ICV_76 $T=1089360 506765 0 0 $X=1088930 $Y=506375
X2389 44 74 81 34409 34354 ICV_76 $T=1090480 687085 1 0 $X=1090050 $Y=682530
X2390 44 74 79 34641 33979 ICV_76 $T=1095520 687085 0 0 $X=1095090 $Y=686695
X2391 44 74 90 34948 34933 ICV_76 $T=1106160 718445 0 0 $X=1105730 $Y=718055
X2392 44 74 81 35295 35275 ICV_76 $T=1116800 640045 0 0 $X=1116370 $Y=639655
X2393 44 74 90 35331 35505 ICV_76 $T=1125200 702765 1 0 $X=1124770 $Y=698210
X2394 44 74 79 35591 34521 ICV_76 $T=1129120 624365 1 0 $X=1128690 $Y=619810
X2395 44 74 81 35752 35675 ICV_76 $T=1135840 600845 0 0 $X=1135410 $Y=600455
X2396 44 74 83 35985 36398 ICV_76 $T=1172800 694925 1 0 $X=1172370 $Y=690370
X2397 44 74 90 36550 36687 ICV_76 $T=1178960 608685 0 0 $X=1178530 $Y=608295
X2398 44 74 83 36579 36594 ICV_76 $T=1181760 663565 1 0 $X=1181330 $Y=659010
X2399 44 74 84 37244 487 ICV_76 $T=1200800 726285 1 0 $X=1200370 $Y=721730
X2400 44 74 81 37348 37261 ICV_76 $T=1203040 522445 0 0 $X=1202610 $Y=522055
X2401 44 74 90 37258 37497 ICV_76 $T=1208080 616525 0 0 $X=1207650 $Y=616135
X2402 44 74 37922 37946 37937 ICV_76 $T=1228800 545965 0 0 $X=1228370 $Y=545575
X2403 44 74 84 37936 37992 ICV_76 $T=1231600 702765 1 0 $X=1231170 $Y=698210
X2404 44 74 78 502 38082 ICV_76 $T=1234960 702765 0 0 $X=1234530 $Y=702375
X2405 44 74 38498 38532 38392 ICV_76 $T=1249520 538125 1 0 $X=1249090 $Y=533570
X2406 44 74 79 38529 38531 ICV_76 $T=1250080 530285 1 0 $X=1249650 $Y=525730
X2407 44 74 36950 38667 38609 ICV_76 $T=1254560 632205 1 0 $X=1254130 $Y=627650
X2408 44 74 39235 38930 39278 ICV_76 $T=1275280 655725 1 0 $X=1274850 $Y=651170
X2409 44 74 39118 32914 39795 ICV_76 $T=1287600 616525 0 0 $X=1287170 $Y=616135
X2410 44 74 39821 39866 39150 ICV_76 $T=1288720 624365 0 0 $X=1288290 $Y=623975
X2411 24077 24010 23960 44 74 23935 NAND3X1 $T=699600 624365 1 180 $X=695250 $Y=623975
X2412 24191 24014 24076 44 74 24102 NAND3X1 $T=702400 608685 1 180 $X=698050 $Y=608295
X2413 23988 24181 24238 44 74 24216 NAND3X1 $T=699040 647885 0 0 $X=698610 $Y=647495
X2414 24331 24386 24418 44 74 24417 NAND3X1 $T=704080 632205 1 0 $X=703650 $Y=627650
X2415 24181 24348 24285 44 74 24419 NAND3X1 $T=704080 640045 0 0 $X=703650 $Y=639655
X2416 24566 24511 24460 44 74 24459 NAND3X1 $T=711920 616525 1 180 $X=707570 $Y=616135
X2417 24482 24531 24265 44 74 24566 NAND3X1 $T=708000 632205 1 0 $X=707570 $Y=627650
X2418 23966 24480 24590 44 74 24567 NAND3X1 $T=708000 647885 1 0 $X=707570 $Y=643330
X2419 24751 24600 24654 44 74 24504 NAND3X1 $T=716960 593005 0 180 $X=712610 $Y=588450
X2420 24331 24532 24265 44 74 24793 NAND3X1 $T=714160 608685 0 0 $X=713730 $Y=608295
X2421 24753 24815 24216 44 74 24840 NAND3X1 $T=715280 655725 1 0 $X=714850 $Y=651170
X2422 24863 24814 24531 44 74 24077 NAND3X1 $T=719760 624365 1 180 $X=715410 $Y=623975
X2423 24674 24832 24883 44 74 24841 NAND3X1 $T=715840 640045 0 0 $X=715410 $Y=639655
X2424 24752 24330 24797 44 74 24924 NAND3X1 $T=723680 600845 1 180 $X=719330 $Y=600455
X2425 24863 24814 24196 44 74 25084 NAND3X1 $T=722560 624365 0 0 $X=722130 $Y=623975
X2426 25032 25062 24797 44 74 25155 NAND3X1 $T=724800 600845 0 0 $X=724370 $Y=600455
X2427 25252 24285 24040 44 74 25214 NAND3X1 $T=731520 616525 1 180 $X=727170 $Y=616135
X2428 24747 25214 25365 44 74 25304 NAND3X1 $T=731520 616525 0 0 $X=731090 $Y=616135
X2429 25346 25232 25366 44 74 25420 NAND3X1 $T=732640 655725 1 0 $X=732210 $Y=651170
X2430 25252 24039 24752 44 74 25512 NAND3X1 $T=735440 616525 0 0 $X=735010 $Y=616135
X2431 25512 24793 25322 44 74 25459 NAND3X1 $T=739920 608685 0 180 $X=735570 $Y=604130
X2432 24863 25540 24531 44 74 25541 NAND3X1 $T=737120 632205 1 0 $X=736690 $Y=627650
X2433 25993 26242 26232 44 74 26257 NAND3X1 $T=759520 671405 0 0 $X=759090 $Y=671015
X2434 26241 26357 26326 44 74 26339 NAND3X1 $T=769600 663565 0 180 $X=765250 $Y=659010
X2435 26366 26371 26315 44 74 26350 NAND3X1 $T=770160 647885 1 180 $X=765810 $Y=647495
X2436 26305 26429 26453 44 74 26445 NAND3X1 $T=768480 632205 1 0 $X=768050 $Y=627650
X2437 26446 26472 26475 44 74 26465 NAND3X1 $T=770720 640045 0 0 $X=770290 $Y=639655
X2438 26715 26734 26700 44 74 26716 NAND3X1 $T=789200 640045 1 180 $X=784850 $Y=639655
X2439 26807 26780 26607 44 74 26760 NAND3X1 $T=791440 655725 0 180 $X=787090 $Y=651170
X2440 26882 26901 26937 44 74 26926 NAND3X1 $T=793120 640045 1 0 $X=792690 $Y=635490
X2441 26788 26913 26939 44 74 26927 NAND3X1 $T=793120 663565 0 0 $X=792690 $Y=663175
X2442 26678 26866 26975 44 74 26938 NAND3X1 $T=794800 624365 0 0 $X=794370 $Y=623975
X2443 27442 27399 27366 44 74 26741 NAND3X1 $T=816080 694925 1 180 $X=811730 $Y=694535
X2444 27426 27416 27379 44 74 27389 NAND3X1 $T=816640 640045 1 180 $X=812290 $Y=639655
X2445 27530 27502 27469 44 74 27456 NAND3X1 $T=820000 710605 0 180 $X=815650 $Y=706050
X2446 27555 27525 27490 44 74 27509 NAND3X1 $T=821120 671405 1 180 $X=816770 $Y=671015
X2447 27594 27440 27445 44 74 27545 NAND3X1 $T=822800 655725 1 180 $X=818450 $Y=655335
X2448 27687 27580 27605 44 74 27511 NAND3X1 $T=826160 718445 1 180 $X=821810 $Y=718055
X2449 27655 27859 27712 44 74 27882 NAND3X1 $T=830080 694925 1 0 $X=829650 $Y=690370
X2450 27891 27785 27820 44 74 27838 NAND3X1 $T=834560 655725 1 180 $X=830210 $Y=655335
X2451 27892 27752 27821 44 74 27579 NAND3X1 $T=834560 702765 0 180 $X=830210 $Y=698210
X2452 27967 27944 27780 44 74 133 NAND3X1 $T=838480 702765 1 180 $X=834130 $Y=702375
X2453 27957 28027 28068 44 74 28019 NAND3X1 $T=838480 710605 0 0 $X=838050 $Y=710215
X2454 27919 120 27860 44 74 28060 NAND3X1 $T=839600 694925 1 0 $X=839170 $Y=690370
X2455 28088 28060 28018 44 74 28007 NAND3X1 $T=844080 694925 1 180 $X=839730 $Y=694535
X2456 28087 27882 28154 44 74 27881 NAND3X1 $T=842400 679245 0 0 $X=841970 $Y=678855
X2457 28155 27919 137 44 74 138 NAND3X1 $T=846880 726285 0 180 $X=842530 $Y=721730
X2458 28155 28079 137 44 74 27469 NAND3X1 $T=847440 710605 1 180 $X=843090 $Y=710215
X2459 140 114 127 44 74 139 NAND3X1 $T=847440 726285 1 180 $X=843090 $Y=725895
X2460 28182 27919 127 44 74 28087 NAND3X1 $T=850240 679245 1 180 $X=845890 $Y=678855
X2461 28155 28079 27946 44 74 28027 NAND3X1 $T=851360 710605 1 180 $X=847010 $Y=710215
X2462 28198 114 27752 44 74 28018 NAND3X1 $T=852480 687085 0 180 $X=848130 $Y=682530
X2463 28175 143 27860 44 74 28074 NAND3X1 $T=853040 718445 1 180 $X=848690 $Y=718055
X2464 123 28134 27860 44 74 27675 NAND3X1 $T=855280 710605 1 180 $X=850930 $Y=710215
X2465 114 28320 28232 44 74 28341 NAND3X1 $T=858080 702765 0 180 $X=853730 $Y=698210
X2466 28403 28372 28341 44 74 28006 NAND3X1 $T=858640 694925 0 180 $X=854290 $Y=690370
X2467 28414 28329 28367 44 74 28380 NAND3X1 $T=859760 718445 0 180 $X=855410 $Y=713890
X2468 29296 29105 29055 44 74 156 NAND3X1 $T=885520 726285 0 180 $X=881170 $Y=721730
X2469 29375 29332 29308 44 74 160 NAND3X1 $T=888880 718445 1 180 $X=884530 $Y=718055
X2470 29494 29442 28905 44 74 29437 NAND3X1 $T=893920 710605 0 180 $X=889570 $Y=706050
X2471 29535 174 180 44 74 29548 NAND3X1 $T=893920 530285 1 0 $X=893490 $Y=525730
X2472 29658 29698 29736 44 74 29723 NAND3X1 $T=898960 577325 0 0 $X=898530 $Y=576935
X2473 29621 29717 29748 44 74 29598 NAND3X1 $T=899520 538125 0 0 $X=899090 $Y=537735
X2474 29749 29762 29803 44 74 29804 NAND3X1 $T=902320 561645 0 0 $X=901890 $Y=561255
X2475 29807 202 29537 44 74 209 NAND3X1 $T=905120 726285 0 0 $X=904690 $Y=725895
X2476 29924 29892 29835 44 74 29872 NAND3X1 $T=911840 561645 0 180 $X=907490 $Y=557090
X2477 29871 29923 29998 44 74 29982 NAND3X1 $T=910160 522445 0 0 $X=909730 $Y=522055
X2478 30001 29993 29955 44 74 29926 NAND3X1 $T=915760 561645 0 180 $X=911410 $Y=557090
X2479 223 29983 230 44 74 30069 NAND3X1 $T=914080 506765 0 0 $X=913650 $Y=506375
X2480 30047 234 30120 44 74 30095 NAND3X1 $T=916320 538125 1 0 $X=915890 $Y=533570
X2481 229 30079 30140 44 74 30126 NAND3X1 $T=916880 522445 1 0 $X=916450 $Y=517890
X2482 30157 248 30288 44 74 30276 NAND3X1 $T=924160 522445 0 0 $X=923730 $Y=522055
X2483 29939 30298 30345 44 74 30337 NAND3X1 $T=926960 545965 0 0 $X=926530 $Y=545575
X2484 30365 30082 30297 44 74 30312 NAND3X1 $T=932000 545965 0 180 $X=927650 $Y=541410
X2485 30230 30405 30442 44 74 30428 NAND3X1 $T=930880 514605 1 0 $X=930450 $Y=510050
X2486 30373 30300 30443 44 74 30429 NAND3X1 $T=930880 577325 1 0 $X=930450 $Y=572770
X2487 257 30436 30469 44 74 30458 NAND3X1 $T=932000 530285 1 0 $X=931570 $Y=525730
X2488 30509 30459 30397 44 74 30470 NAND3X1 $T=938720 545965 1 180 $X=934370 $Y=545575
X2489 30510 30486 29985 44 74 30471 NAND3X1 $T=938720 561645 0 180 $X=934370 $Y=557090
X2490 29942 30522 30544 44 74 30491 NAND3X1 $T=935920 585165 0 0 $X=935490 $Y=584775
X2491 30574 30567 30650 44 74 30624 NAND3X1 $T=940400 561645 1 0 $X=939970 $Y=557090
X2492 30632 30600 30273 44 74 30616 NAND3X1 $T=944320 593005 1 180 $X=939970 $Y=592615
X2493 30634 282 30569 44 74 30511 NAND3X1 $T=944320 726285 1 180 $X=939970 $Y=725895
X2494 30686 285 30581 44 74 30531 NAND3X1 $T=946560 491085 0 180 $X=942210 $Y=486530
X2495 30658 30657 30623 44 74 30596 NAND3X1 $T=946560 577325 0 180 $X=942210 $Y=572770
X2496 290 30441 30594 44 74 30675 NAND3X1 $T=948240 545965 1 180 $X=943890 $Y=545575
X2497 30679 289 30731 44 74 30732 NAND3X1 $T=944880 522445 0 0 $X=944450 $Y=522055
X2498 30778 30753 30717 44 74 30687 NAND3X1 $T=951040 553805 0 180 $X=946690 $Y=549250
X2499 30791 296 293 44 74 30569 NAND3X1 $T=951600 726285 1 180 $X=947250 $Y=725895
X2500 30760 30800 30836 44 74 30336 NAND3X1 $T=948800 530285 0 0 $X=948370 $Y=529895
X2501 30583 30801 30675 44 74 30815 NAND3X1 $T=948800 577325 0 0 $X=948370 $Y=576935
X2502 295 30809 30817 44 74 30840 NAND3X1 $T=949360 718445 0 0 $X=948930 $Y=718055
X2503 30835 30873 30716 44 74 30891 NAND3X1 $T=951600 506765 0 0 $X=951170 $Y=506375
X2504 30903 30874 30777 44 74 30856 NAND3X1 $T=956080 545965 1 180 $X=951730 $Y=545575
X2505 30893 30930 30960 44 74 30939 NAND3X1 $T=953840 640045 0 0 $X=953410 $Y=639655
X2506 31000 30972 30769 44 74 30948 NAND3X1 $T=960000 561645 1 180 $X=955650 $Y=561255
X2507 31001 30844 30880 44 74 30949 NAND3X1 $T=960000 585165 0 180 $X=955650 $Y=580610
X2508 30957 30854 30998 44 74 31010 NAND3X1 $T=956640 506765 1 0 $X=956210 $Y=502210
X2509 31011 30984 30947 44 74 30708 NAND3X1 $T=960560 538125 1 180 $X=956210 $Y=537735
X2510 318 30935 30853 44 74 30977 NAND3X1 $T=961120 491085 0 180 $X=956770 $Y=486530
X2511 30977 30855 31043 44 74 30999 NAND3X1 $T=957200 522445 0 0 $X=956770 $Y=522055
X2512 31013 31053 31012 44 74 31074 NAND3X1 $T=958880 632205 1 0 $X=958450 $Y=627650
X2513 31044 31052 30837 44 74 31059 NAND3X1 $T=963360 553805 0 180 $X=959010 $Y=549250
X2514 286 281 314 44 74 31062 NAND3X1 $T=963360 718445 0 180 $X=959010 $Y=713890
X2515 31090 31128 31164 44 74 30444 NAND3X1 $T=961680 569485 1 0 $X=961250 $Y=564930
X2516 30656 31109 326 44 74 31128 NAND3X1 $T=962240 545965 0 0 $X=961810 $Y=545575
X2517 30918 31133 31134 44 74 31060 NAND3X1 $T=962240 577325 1 0 $X=961810 $Y=572770
X2518 31190 31158 31100 44 74 30607 NAND3X1 $T=967280 506765 1 180 $X=962930 $Y=506375
X2519 31135 31041 297 44 74 31168 NAND3X1 $T=967280 718445 0 180 $X=962930 $Y=713890
X2520 31225 31179 31147 44 74 30857 NAND3X1 $T=968400 561645 1 180 $X=964050 $Y=561255
X2521 31240 31207 31167 44 74 31077 NAND3X1 $T=968960 647885 0 180 $X=964610 $Y=643330
X2522 31269 31234 31082 44 74 31214 NAND3X1 $T=970080 655725 1 180 $X=965730 $Y=655335
X2523 31288 31259 31180 44 74 31359 NAND3X1 $T=968960 710605 1 0 $X=968530 $Y=706050
X2524 31413 31374 31322 44 74 30937 NAND3X1 $T=974560 514605 0 180 $X=970210 $Y=510050
X2525 31414 31371 31207 44 74 31269 NAND3X1 $T=974560 616525 1 180 $X=970210 $Y=616135
X2526 31203 31029 31328 44 74 31416 NAND3X1 $T=970640 663565 1 0 $X=970210 $Y=659010
X2527 31270 31416 31560 44 74 31456 NAND3X1 $T=974560 663565 1 0 $X=974130 $Y=659010
X2528 31556 31075 31400 44 74 31489 NAND3X1 $T=979040 640045 1 180 $X=974690 $Y=639655
X2529 298 321 30821 44 74 343 NAND3X1 $T=981840 726285 0 180 $X=977490 $Y=721730
X2530 31221 31626 31400 44 74 31560 NAND3X1 $T=982400 663565 0 180 $X=978050 $Y=659010
X2531 31553 31776 30816 44 74 31783 NAND3X1 $T=982400 663565 1 0 $X=981970 $Y=659010
X2532 31488 31833 31635 44 74 31860 NAND3X1 $T=984080 616525 1 0 $X=983650 $Y=611970
X2533 31810 31207 31290 44 74 31802 NAND3X1 $T=988560 632205 0 180 $X=984210 $Y=627650
X2534 344 31509 31835 44 74 347 NAND3X1 $T=985200 726285 1 0 $X=984770 $Y=721730
X2535 31539 31782 30816 44 74 31995 NAND3X1 $T=988560 640045 1 0 $X=988130 $Y=635490
X2536 31990 31993 29251 44 74 31994 NAND3X1 $T=994720 616525 1 180 $X=990370 $Y=616135
X2537 31994 31802 32055 44 74 32080 NAND3X1 $T=991360 624365 0 0 $X=990930 $Y=623975
X2538 31578 31626 30816 44 74 32055 NAND3X1 $T=995280 632205 1 180 $X=990930 $Y=631815
X2539 31636 32063 31995 44 74 32214 NAND3X1 $T=995280 640045 1 0 $X=994850 $Y=635490
X2540 32260 32136 159 44 74 32213 NAND3X1 $T=1000880 577325 1 180 $X=996530 $Y=576935
X2541 32213 32226 32303 44 74 32284 NAND3X1 $T=997520 569485 0 0 $X=997090 $Y=569095
X2542 32244 32292 166 44 74 32319 NAND3X1 $T=998640 585165 1 0 $X=998210 $Y=580610
X2543 32262 32102 31783 44 74 32344 NAND3X1 $T=999200 663565 0 0 $X=998770 $Y=663175
X2544 32283 32334 32302 44 74 32318 NAND3X1 $T=999760 561645 1 0 $X=999330 $Y=557090
X2545 32453 32409 237 44 74 32333 NAND3X1 $T=1007040 553805 0 180 $X=1002690 $Y=549250
X2546 32401 32444 212 44 74 32434 NAND3X1 $T=1003680 491085 0 0 $X=1003250 $Y=490695
X2547 32434 353 32518 44 74 32370 NAND3X1 $T=1004800 498925 1 0 $X=1004370 $Y=494370
X2548 32647 32435 32562 44 74 32581 NAND3X1 $T=1013760 506765 1 180 $X=1009410 $Y=506375
X2549 358 32360 32563 44 74 32582 NAND3X1 $T=1013760 522445 1 180 $X=1009410 $Y=522055
X2550 32472 32648 32697 44 74 32440 NAND3X1 $T=1010960 553805 0 0 $X=1010530 $Y=553415
X2551 32323 32770 32726 44 74 32775 NAND3X1 $T=1014880 545965 0 0 $X=1014450 $Y=545575
X2552 32808 32649 32728 44 74 32519 NAND3X1 $T=1019360 569485 0 180 $X=1015010 $Y=564930
X2553 32776 32520 32630 44 74 32794 NAND3X1 $T=1019920 593005 0 180 $X=1015570 $Y=588450
X2554 32844 32802 212 44 74 32776 NAND3X1 $T=1020480 577325 1 180 $X=1016130 $Y=576935
X2555 32880 32839 32791 44 74 32806 NAND3X1 $T=1021600 506765 0 180 $X=1017250 $Y=502210
X2556 32844 32930 159 44 74 32967 NAND3X1 $T=1020480 577325 0 0 $X=1020050 $Y=576935
X2557 32999 32958 32913 44 74 32763 NAND3X1 $T=1025520 491085 1 180 $X=1021170 $Y=490695
X2558 32947 32770 33029 44 74 32981 NAND3X1 $T=1022160 545965 0 0 $X=1021730 $Y=545575
X2559 32968 33005 33042 44 74 33011 NAND3X1 $T=1022720 600845 1 0 $X=1022290 $Y=596290
X2560 33045 33006 32935 44 74 32979 NAND3X1 $T=1027200 514605 1 180 $X=1022850 $Y=514215
X2561 32983 33021 33065 44 74 29847 NAND3X1 $T=1023280 679245 1 0 $X=1022850 $Y=674690
X2562 32967 32649 33091 44 74 33031 NAND3X1 $T=1024400 577325 0 0 $X=1023970 $Y=576935
X2563 33102 33056 33033 44 74 28036 NAND3X1 $T=1029440 640045 1 180 $X=1025090 $Y=639655
X2564 33075 33169 33196 44 74 33198 NAND3X1 $T=1029440 530285 0 0 $X=1029010 $Y=529895
X2565 33211 33180 33140 44 74 33159 NAND3X1 $T=1033920 624365 1 180 $X=1029570 $Y=623975
X2566 33256 32521 33187 44 74 33227 NAND3X1 $T=1035600 585165 1 180 $X=1031250 $Y=584775
X2567 33299 33379 33406 44 74 33392 NAND3X1 $T=1038960 647885 1 0 $X=1038530 $Y=643330
X2568 33413 33345 33335 44 74 33425 NAND3X1 $T=1045680 577325 1 180 $X=1041330 $Y=576935
X2569 33127 33417 33359 44 74 33443 NAND3X1 $T=1041760 593005 1 0 $X=1041330 $Y=588450
X2570 33387 33241 33202 44 74 33437 NAND3X1 $T=1043440 640045 0 0 $X=1043010 $Y=639655
X2571 318 33360 406 44 74 33494 NAND3X1 $T=1046240 491085 1 0 $X=1045810 $Y=486530
X2572 33494 33514 33547 44 74 33536 NAND3X1 $T=1046800 506765 0 0 $X=1046370 $Y=506375
X2573 33591 33564 33516 44 74 32982 NAND3X1 $T=1053520 561645 1 180 $X=1049170 $Y=561255
X2574 33567 33392 33629 44 74 33612 NAND3X1 $T=1050720 647885 1 0 $X=1050290 $Y=643330
X2575 33538 33558 33579 44 74 33567 NAND3X1 $T=1052960 655725 1 0 $X=1052530 $Y=651170
X2576 33673 33527 33613 44 74 33631 NAND3X1 $T=1057440 687085 0 180 $X=1053090 $Y=682530
X2577 32553 33671 33670 44 74 33718 NAND3X1 $T=1056320 561645 1 0 $X=1055890 $Y=557090
X2578 33719 33698 33609 44 74 33701 NAND3X1 $T=1060240 577325 0 180 $X=1055890 $Y=572770
X2579 33220 33387 33092 44 74 33629 NAND3X1 $T=1060800 647885 0 180 $X=1056450 $Y=643330
X2580 33083 33749 33375 44 74 33768 NAND3X1 $T=1059120 655725 1 0 $X=1058690 $Y=651170
X2581 33174 33092 33477 44 74 33746 NAND3X1 $T=1059120 663565 0 0 $X=1058690 $Y=663175
X2582 33733 33744 33767 44 74 33779 NAND3X1 $T=1059680 514605 1 0 $X=1059250 $Y=510050
X2583 33658 33776 33786 44 74 33759 NAND3X1 $T=1060240 577325 1 0 $X=1059810 $Y=572770
X2584 33787 33764 33722 44 74 33747 NAND3X1 $T=1064160 671405 1 180 $X=1059810 $Y=671015
X2585 33855 33711 33728 44 74 33840 NAND3X1 $T=1067520 569485 0 180 $X=1063170 $Y=564930
X2586 33866 33745 33628 44 74 33844 NAND3X1 $T=1068080 569485 1 180 $X=1063730 $Y=569095
X2587 33720 33801 33914 44 74 33910 NAND3X1 $T=1066960 538125 0 0 $X=1066530 $Y=537735
X2588 33999 33998 33946 44 74 34054 NAND3X1 $T=1073680 561645 1 0 $X=1073250 $Y=557090
X2589 34084 443 33953 44 74 34026 NAND3X1 $T=1078720 506765 1 180 $X=1074370 $Y=506375
X2590 34131 34094 33949 44 74 34100 NAND3X1 $T=1080400 585165 0 180 $X=1076050 $Y=580610
X2591 34115 33975 33909 44 74 34172 NAND3X1 $T=1078160 498925 1 0 $X=1077730 $Y=494370
X2592 34116 34149 33894 44 74 34174 NAND3X1 $T=1078160 530285 1 0 $X=1077730 $Y=525730
X2593 34042 34153 34057 44 74 34176 NAND3X1 $T=1078160 561645 0 0 $X=1077730 $Y=561255
X2594 34143 34040 34219 44 74 33010 NAND3X1 $T=1079280 545965 1 0 $X=1078850 $Y=541410
X2595 34230 386 442 44 74 34303 NAND3X1 $T=1082640 514605 1 0 $X=1082210 $Y=510050
X2596 34305 34000 34117 44 74 34268 NAND3X1 $T=1086560 569485 1 180 $X=1082210 $Y=569095
X2597 440 34173 34302 44 74 34346 NAND3X1 $T=1086560 514605 1 0 $X=1086130 $Y=510050
X2598 34460 452 34289 44 74 34449 NAND3X1 $T=1093280 553805 0 180 $X=1088930 $Y=549250
X2599 34377 34378 453 44 74 34487 NAND3X1 $T=1089920 491085 0 0 $X=1089490 $Y=490695
X2600 451 34450 34308 44 74 34488 NAND3X1 $T=1089920 498925 1 0 $X=1089490 $Y=494370
X2601 34447 34457 34282 44 74 34365 NAND3X1 $T=1093840 522445 0 180 $X=1089490 $Y=517890
X2602 34420 34347 34523 44 74 34520 NAND3X1 $T=1091040 545965 1 0 $X=1090610 $Y=541410
X2603 34652 459 34933 44 74 460 NAND3X1 $T=1102800 726285 1 0 $X=1102370 $Y=721730
X2604 463 35599 35570 44 74 462 NAND3X1 $T=1134160 718445 0 180 $X=1129810 $Y=713890
X2605 35802 35770 35505 44 74 35749 NAND3X1 $T=1141440 702765 0 180 $X=1137090 $Y=698210
X2606 35813 35779 35748 44 74 35764 NAND3X1 $T=1142000 679245 1 180 $X=1137650 $Y=678855
X2607 35967 35865 35889 44 74 35914 NAND3X1 $T=1148720 702765 1 180 $X=1144370 $Y=702375
X2608 36072 36213 36248 44 74 36235 NAND3X1 $T=1155440 647885 0 0 $X=1155010 $Y=647495
X2609 36089 36243 36273 44 74 36261 NAND3X1 $T=1156560 671405 0 0 $X=1156130 $Y=671015
X2610 36276 36253 36219 44 74 36236 NAND3X1 $T=1161600 710605 0 180 $X=1157250 $Y=706050
X2611 36398 36372 36333 44 74 36377 NAND3X1 $T=1167200 687085 1 180 $X=1162850 $Y=686695
X2612 36360 36272 36427 44 74 36417 NAND3X1 $T=1164400 624365 0 0 $X=1163970 $Y=623975
X2613 36367 36442 36332 44 74 36461 NAND3X1 $T=1166640 663565 1 0 $X=1166210 $Y=659010
X2614 36594 36561 36532 44 74 36539 NAND3X1 $T=1177280 663565 1 180 $X=1172930 $Y=663175
X2615 36686 36739 36687 44 74 36714 NAND3X1 $T=1185120 640045 0 180 $X=1180770 $Y=635490
X2616 36935 36904 36867 44 74 36883 NAND3X1 $T=1191840 624365 1 180 $X=1187490 $Y=623975
X2617 36869 36760 37066 44 74 37062 NAND3X1 $T=1191280 647885 0 0 $X=1190850 $Y=647495
X2618 37479 37349 37361 44 74 37418 NAND3X1 $T=1209760 640045 1 180 $X=1205410 $Y=639655
X2619 37566 37536 37497 44 74 37511 NAND3X1 $T=1213120 632205 0 180 $X=1208770 $Y=627650
X2620 37664 37673 37687 44 74 37703 NAND3X1 $T=1216480 624365 0 0 $X=1216050 $Y=623975
X2621 37720 37646 37674 44 74 37689 NAND3X1 $T=1221520 647885 0 180 $X=1217170 $Y=643330
X2622 37819 37688 37756 44 74 37767 NAND3X1 $T=1226560 640045 1 180 $X=1222210 $Y=639655
X2623 79 38064 37945 44 74 37946 NAND3X1 $T=1238320 553805 0 180 $X=1233970 $Y=549250
X2624 38338 38299 38262 44 74 37982 NAND3X1 $T=1246160 624365 0 180 $X=1241810 $Y=619810
X2625 38370 38004 25419 44 74 38152 NAND3X1 $T=1247280 553805 1 180 $X=1242930 $Y=553415
X2626 79 38351 38292 44 74 38311 NAND3X1 $T=1247840 530285 1 180 $X=1243490 $Y=529895
X2627 38480 38446 38402 44 74 38025 NAND3X1 $T=1251200 647885 1 180 $X=1246850 $Y=647495
X2628 38588 38558 38517 44 74 38189 NAND3X1 $T=1255120 553805 0 180 $X=1250770 $Y=549250
X2629 38589 38361 38518 44 74 38371 NAND3X1 $T=1255120 585165 0 180 $X=1250770 $Y=580610
X2630 38565 38573 38636 44 74 38393 NAND3X1 $T=1252320 616525 0 0 $X=1251890 $Y=616135
X2631 38591 38526 38573 44 74 38546 NAND3X1 $T=1253440 655725 1 0 $X=1253010 $Y=651170
X2632 38680 38734 38601 44 74 38684 NAND3X1 $T=1261280 608685 0 180 $X=1256930 $Y=604130
X2633 38771 38732 38684 44 74 38590 NAND3X1 $T=1261280 647885 1 180 $X=1256930 $Y=647495
X2634 38680 38764 34481 44 74 38790 NAND3X1 $T=1257920 616525 1 0 $X=1257490 $Y=611970
X2635 38506 38765 38722 44 74 38791 NAND3X1 $T=1257920 632205 1 0 $X=1257490 $Y=627650
X2636 79 38812 38558 44 74 38789 NAND3X1 $T=1264080 545965 1 180 $X=1259730 $Y=545575
X2637 79 38702 38610 44 74 38821 NAND3X1 $T=1265200 530285 1 180 $X=1260850 $Y=529895
X2638 38823 38864 38790 44 74 38701 NAND3X1 $T=1265760 632205 1 180 $X=1261410 $Y=631815
X2639 38848 38930 34348 44 74 38771 NAND3X1 $T=1268000 647885 1 180 $X=1263650 $Y=647495
X2640 38892 39118 38601 44 74 39149 NAND3X1 $T=1269120 616525 1 0 $X=1268690 $Y=611970
X2641 39150 39096 38992 44 74 38736 NAND3X1 $T=1273040 632205 1 180 $X=1268690 $Y=631815
X2642 39173 39105 38887 44 74 39091 NAND3X1 $T=1273600 671405 1 180 $X=1269250 $Y=671015
X2643 39215 39166 39104 44 74 39130 NAND3X1 $T=1274720 624365 1 180 $X=1270370 $Y=623975
X2644 38521 38930 34119 44 74 39302 NAND3X1 $T=1275280 640045 0 0 $X=1274850 $Y=639655
X2645 38783 39334 39278 44 74 39090 NAND3X1 $T=1279200 671405 0 180 $X=1274850 $Y=666850
X2646 39395 39350 39302 44 74 38946 NAND3X1 $T=1279760 624365 1 180 $X=1275410 $Y=623975
X2647 38463 39424 32914 44 74 39395 NAND3X1 $T=1280320 624365 1 0 $X=1279890 $Y=619810
X2648 39569 39806 39651 44 74 39842 NAND3X1 $T=1287600 647885 0 0 $X=1287170 $Y=647495
X2649 39628 39795 39423 44 74 39866 NAND3X1 $T=1288720 624365 1 0 $X=1288290 $Y=619810
X2650 24214 24154 44 74 23985 OR2X1 $T=702400 600845 0 180 $X=698610 $Y=596290
X2651 24215 24155 44 74 23987 OR2X1 $T=702400 647885 0 180 $X=698610 $Y=643330
X2652 24285 24352 44 74 24356 OR2X1 $T=703520 608685 0 0 $X=703090 $Y=608295
X2653 24307 24341 44 74 24192 OR2X1 $T=706880 624365 1 180 $X=703090 $Y=623975
X2654 24589 24078 44 74 24306 OR2X1 $T=711920 608685 1 180 $X=708130 $Y=608295
X2655 24386 24622 44 74 24460 OR2X1 $T=710800 640045 0 0 $X=710370 $Y=639655
X2656 24548 24645 44 74 24600 OR2X1 $T=714720 593005 1 180 $X=710930 $Y=592615
X2657 24418 24460 44 74 24747 OR2X1 $T=713040 624365 1 0 $X=712610 $Y=619810
X2658 24548 24341 44 74 24794 OR2X1 $T=715280 640045 1 0 $X=714850 $Y=635490
X2659 24331 24674 44 74 24816 OR2X1 $T=720320 663565 0 180 $X=716530 $Y=659010
X2660 24589 24924 44 74 24979 OR2X1 $T=719200 600845 1 0 $X=718770 $Y=596290
X2661 24352 24924 44 74 24654 OR2X1 $T=723120 593005 1 180 $X=719330 $Y=592615
X2662 24797 24352 44 74 24341 OR2X1 $T=724240 624365 0 180 $X=720450 $Y=619810
X2663 24964 24814 44 74 25035 OR2X1 $T=721440 655725 0 0 $X=721010 $Y=655335
X2664 24961 24945 44 74 25081 OR2X1 $T=722560 616525 0 0 $X=722130 $Y=616135
X2665 24352 24883 44 74 25101 OR2X1 $T=723120 632205 0 0 $X=722690 $Y=631815
X2666 26248 25969 44 74 26241 OR2X1 $T=764560 663565 0 180 $X=760770 $Y=659010
X2667 26248 26278 44 74 26305 OR2X1 $T=761760 632205 1 0 $X=761330 $Y=627650
X2668 26248 26662 44 74 26678 OR2X1 $T=781360 640045 0 0 $X=780930 $Y=639655
X2669 26248 26642 44 74 26715 OR2X1 $T=783040 663565 0 0 $X=782610 $Y=663175
X2670 118 27538 44 74 27366 OR2X1 $T=821120 694925 1 180 $X=817330 $Y=694535
X2671 27765 27711 44 74 27604 OR2X1 $T=828960 702765 0 180 $X=825170 $Y=698210
X2672 27711 27637 44 74 27780 OR2X1 $T=826160 710605 1 0 $X=825730 $Y=706050
X2673 27881 27914 44 74 27932 OR2X1 $T=832880 679245 0 0 $X=832450 $Y=678855
X2674 27840 27675 44 74 27994 OR2X1 $T=836240 718445 0 0 $X=835810 $Y=718055
X2675 28303 28220 44 74 28154 OR2X1 $T=853600 679245 1 180 $X=849810 $Y=678855
X2676 27766 27675 44 74 28329 OR2X1 $T=851360 718445 1 0 $X=850930 $Y=713890
X2677 27902 83 44 74 28377 OR2X1 $T=853600 663565 1 0 $X=853170 $Y=659010
X2678 28175 27532 44 74 28414 OR2X1 $T=855280 726285 1 0 $X=854850 $Y=721730
X2679 148 90 44 74 28611 OR2X1 $T=869840 663565 0 180 $X=866050 $Y=659010
X2680 170 29904 44 74 29775 OR2X1 $T=911840 577325 1 180 $X=908050 $Y=576935
X2681 237 30111 44 74 30087 OR2X1 $T=920800 569485 1 180 $X=917010 $Y=569095
X2682 237 30265 44 74 30286 OR2X1 $T=924720 577325 0 0 $X=924290 $Y=576935
X2683 29633 175 44 74 30441 OR2X1 $T=931440 545965 0 0 $X=931010 $Y=545575
X2684 30201 175 44 74 30465 OR2X1 $T=932560 545965 1 0 $X=932130 $Y=541410
X2685 170 30478 44 74 30430 OR2X1 $T=938160 577325 1 180 $X=934370 $Y=576935
X2686 242 200 44 74 30594 OR2X1 $T=938720 545965 0 0 $X=938290 $Y=545575
X2687 197 242 44 74 30656 OR2X1 $T=941520 553805 1 0 $X=941090 $Y=549250
X2688 245 301 44 74 30853 OR2X1 $T=949920 491085 1 0 $X=949490 $Y=486530
X2689 277 287 44 74 30935 OR2X1 $T=953280 491085 1 0 $X=952850 $Y=486530
X2690 299 200 44 74 30936 OR2X1 $T=953280 506765 1 0 $X=952850 $Y=502210
X2691 281 317 44 74 31041 OR2X1 $T=957760 718445 0 0 $X=957330 $Y=718055
X2692 31029 31114 44 74 31082 OR2X1 $T=965040 663565 0 180 $X=961250 $Y=659010
X2693 29711 218 44 74 31109 OR2X1 $T=966160 545965 0 180 $X=962370 $Y=541410
X2694 321 31062 44 74 31259 OR2X1 $T=971760 710605 1 180 $X=967970 $Y=710215
X2695 31062 295 44 74 336 OR2X1 $T=970080 718445 1 0 $X=969650 $Y=713890
X2696 340 31286 44 74 31306 OR2X1 $T=976800 491085 1 180 $X=973010 $Y=490695
X2697 31256 31028 44 74 31556 OR2X1 $T=975120 632205 1 0 $X=974690 $Y=627650
X2698 324 295 44 74 341 OR2X1 $T=975120 726285 0 0 $X=974690 $Y=725895
X2699 31118 31539 44 74 31414 OR2X1 $T=975680 616525 0 0 $X=975250 $Y=616135
X2700 31637 31029 44 74 31553 OR2X1 $T=980720 655725 0 180 $X=976930 $Y=651170
X2701 31451 31415 44 74 31596 OR2X1 $T=984640 647885 0 180 $X=980850 $Y=643330
X2702 31439 31553 44 74 31798 OR2X1 $T=982400 655725 1 0 $X=981970 $Y=651170
X2703 31287 31755 44 74 31617 OR2X1 $T=985760 671405 0 180 $X=981970 $Y=666850
X2704 31207 31539 44 74 31888 OR2X1 $T=985200 624365 1 0 $X=984770 $Y=619810
X2705 31810 31864 44 74 31755 OR2X1 $T=989120 663565 1 180 $X=985330 $Y=663175
X2706 31493 31864 44 74 31990 OR2X1 $T=988560 624365 1 0 $X=988130 $Y=619810
X2707 31782 31893 44 74 32076 OR2X1 $T=991360 640045 0 0 $X=990930 $Y=639655
X2708 31557 31149 44 74 32136 OR2X1 $T=993040 585165 0 0 $X=992610 $Y=584775
X2709 31167 31578 44 74 31951 OR2X1 $T=996960 655725 0 180 $X=993170 $Y=651170
X2710 30582 31148 44 74 32244 OR2X1 $T=996960 585165 0 0 $X=996530 $Y=584775
X2711 350 32377 44 74 32334 OR2X1 $T=1005360 530285 1 180 $X=1001570 $Y=529895
X2712 28267 32378 44 74 32260 OR2X1 $T=1005360 569485 1 180 $X=1001570 $Y=569095
X2713 354 352 44 74 32401 OR2X1 $T=1007600 491085 0 180 $X=1003810 $Y=486530
X2714 32614 328 44 74 32548 OR2X1 $T=1012080 545965 1 180 $X=1008290 $Y=545575
X2715 331 32619 44 74 32444 OR2X1 $T=1013760 498925 0 180 $X=1009970 $Y=494370
X2716 32793 32629 44 74 32292 OR2X1 $T=1018240 585165 1 180 $X=1014450 $Y=584775
X2717 373 32775 44 74 32835 OR2X1 $T=1022160 545965 1 180 $X=1018370 $Y=545575
X2718 30582 31149 44 74 32930 OR2X1 $T=1019360 585165 0 0 $X=1018930 $Y=584775
X2719 237 32994 44 74 32829 OR2X1 $T=1022720 553805 0 0 $X=1022290 $Y=553415
X2720 33094 287 44 74 33055 OR2X1 $T=1029440 506765 0 180 $X=1025650 $Y=502210
X2721 33116 33083 44 74 33056 OR2X1 $T=1029440 647885 0 180 $X=1025650 $Y=643330
X2722 33119 32629 44 74 32802 OR2X1 $T=1031680 577325 1 180 $X=1027890 $Y=576935
X2723 301 33152 44 74 383 OR2X1 $T=1028880 491085 1 0 $X=1028450 $Y=486530
X2724 366 33113 44 74 33196 OR2X1 $T=1029440 538125 1 0 $X=1029010 $Y=533570
X2725 33062 32378 44 74 32844 OR2X1 $T=1035040 577325 1 180 $X=1031250 $Y=576935
X2726 33063 33271 44 74 33276 OR2X1 $T=1033920 663565 1 0 $X=1033490 $Y=659010
X2727 33361 33083 44 74 33310 OR2X1 $T=1041200 663565 0 180 $X=1037410 $Y=659010
X2728 33361 33375 44 74 33376 OR2X1 $T=1044560 663565 0 180 $X=1040770 $Y=659010
X2729 407 287 44 74 33492 OR2X1 $T=1050160 498925 0 180 $X=1046370 $Y=494370
X2730 369 200 44 74 33554 OR2X1 $T=1047920 530285 0 0 $X=1047490 $Y=529895
X2731 33477 33362 44 74 33495 OR2X1 $T=1049040 663565 0 0 $X=1048610 $Y=663175
X2732 364 175 44 74 33637 OR2X1 $T=1051840 491085 1 0 $X=1051410 $Y=486530
X2733 399 332 44 74 33586 OR2X1 $T=1055200 545965 1 180 $X=1051410 $Y=545575
X2734 33441 33526 44 74 33613 OR2X1 $T=1051840 679245 0 0 $X=1051410 $Y=678855
X2735 420 175 44 74 33602 OR2X1 $T=1058560 522445 1 180 $X=1054770 $Y=522055
X2736 33592 175 44 74 33649 OR2X1 $T=1056320 538125 0 0 $X=1055890 $Y=537735
X2737 33477 33579 44 74 33581 OR2X1 $T=1056320 624365 0 0 $X=1055890 $Y=623975
X2738 33174 33441 44 74 33675 OR2X1 $T=1059680 679245 1 180 $X=1055890 $Y=678855
X2739 407 200 44 74 33732 OR2X1 $T=1057440 498925 0 0 $X=1057010 $Y=498535
X2740 426 200 44 74 33706 OR2X1 $T=1061360 530285 1 180 $X=1057570 $Y=529895
X2741 33759 33760 44 74 33710 OR2X1 $T=1063600 593005 0 180 $X=1059810 $Y=588450
X2742 33735 33581 44 74 33764 OR2X1 $T=1060240 624365 0 0 $X=1059810 $Y=623975
X2743 33329 33141 44 74 33750 OR2X1 $T=1064160 632205 1 180 $X=1060370 $Y=631815
X2744 33651 33375 44 74 33787 OR2X1 $T=1064160 671405 0 0 $X=1063730 $Y=671015
X2745 264 33785 44 74 33973 OR2X1 $T=1070320 506765 0 0 $X=1069890 $Y=506375
X2746 170 34296 44 74 34131 OR2X1 $T=1087120 585165 0 180 $X=1083330 $Y=580610
X2747 237 34434 44 74 33919 OR2X1 $T=1092720 561645 1 180 $X=1088930 $Y=561255
X2748 170 34379 44 74 34382 OR2X1 $T=1093280 569485 1 180 $X=1089490 $Y=569095
X2749 170 34541 44 74 34305 OR2X1 $T=1092720 569485 1 0 $X=1092290 $Y=564930
X2750 26248 35984 44 74 36072 OR2X1 $T=1149840 655725 1 0 $X=1149410 $Y=651170
X2751 26248 36383 44 74 36360 OR2X1 $T=1167200 632205 0 180 $X=1163410 $Y=627650
X2752 26248 36660 44 74 36686 OR2X1 $T=1177840 640045 1 0 $X=1177410 $Y=635490
X2753 37902 81 44 74 37961 OR2X1 $T=1228800 553805 1 0 $X=1228370 $Y=549250
X2754 38153 25419 44 74 38288 OR2X1 $T=1240560 593005 1 0 $X=1240130 $Y=588450
X2755 38544 38695 44 74 38733 OR2X1 $T=1256240 561645 0 0 $X=1255810 $Y=561255
X2756 38463 38766 44 74 38575 OR2X1 $T=1261840 632205 1 180 $X=1258050 $Y=631815
X2757 38667 38783 44 74 38732 OR2X1 $T=1259040 655725 1 0 $X=1258610 $Y=651170
X2758 38547 38773 44 74 38887 OR2X1 $T=1267440 671405 0 180 $X=1263650 $Y=666850
X2759 38892 38766 44 74 38913 OR2X1 $T=1268000 616525 1 180 $X=1264210 $Y=616135
X2760 38968 38547 44 74 38864 OR2X1 $T=1268000 640045 1 180 $X=1264210 $Y=639655
X2761 38764 38766 44 74 38968 OR2X1 $T=1269680 647885 0 180 $X=1265890 $Y=643330
X2762 39216 39118 44 74 39011 OR2X1 $T=1274160 663565 0 180 $X=1270370 $Y=659010
X2763 39193 39246 44 74 39173 OR2X1 $T=1276400 663565 1 180 $X=1272610 $Y=663175
X2764 38930 38521 44 74 39357 OR2X1 $T=1275280 640045 1 0 $X=1274850 $Y=635490
X2765 34348 39381 44 74 38766 OR2X1 $T=1280320 647885 0 180 $X=1276530 $Y=643330
X2766 38930 39193 44 74 39569 OR2X1 $T=1280320 647885 0 0 $X=1279890 $Y=647495
X2767 39707 39590 44 74 39192 OR2X1 $T=1287600 632205 0 180 $X=1283810 $Y=627650
X2768 44 74 79 25477 25826 ICV_74 $T=748320 545965 0 0 $X=747890 $Y=545575
X2769 44 74 84 25829 26009 ICV_74 $T=751120 702765 0 0 $X=750690 $Y=702375
X2770 44 74 26293 26187 26282 ICV_74 $T=761760 538125 1 0 $X=761330 $Y=533570
X2771 44 74 26769 26750 26763 ICV_74 $T=786400 506765 1 0 $X=785970 $Y=502210
X2772 44 74 79 26976 26992 ICV_74 $T=797040 553805 0 0 $X=796610 $Y=553415
X2773 44 74 27752 27625 27711 ICV_74 $T=825600 694925 0 0 $X=825170 $Y=694535
X2774 44 74 27802 27821 27637 ICV_74 $T=830080 702765 0 0 $X=829650 $Y=702375
X2775 44 74 90 28137 141 ICV_74 $T=844640 679245 1 0 $X=844210 $Y=674690
X2776 44 74 159 162 29376 ICV_74 $T=886080 491085 1 0 $X=885650 $Y=486530
X2777 44 74 166 162 29482 ICV_74 $T=890560 491085 0 0 $X=890130 $Y=490695
X2778 44 74 166 28827 29507 ICV_74 $T=891680 514605 1 0 $X=891250 $Y=510050
X2779 44 74 166 29294 29575 ICV_74 $T=894480 569485 0 0 $X=894050 $Y=569095
X2780 44 74 29710 29575 29689 ICV_74 $T=898960 569485 1 0 $X=898530 $Y=564930
X2781 44 74 29426 29422 191 ICV_74 $T=902880 506765 0 0 $X=902450 $Y=506375
X2782 44 74 29662 29773 204 ICV_74 $T=905680 514605 1 0 $X=905250 $Y=510050
X2783 44 74 217 167 29923 ICV_74 $T=909040 506765 0 0 $X=908610 $Y=506375
X2784 44 74 197 29925 30106 ICV_74 $T=918560 561645 1 0 $X=918130 $Y=557090
X2785 44 74 30542 207 30510 ICV_74 $T=937600 561645 0 0 $X=937170 $Y=561255
X2786 44 74 303 30595 30855 ICV_74 $T=951600 522445 1 0 $X=951170 $Y=517890
X2787 44 74 30920 30545 30892 ICV_74 $T=953280 616525 0 0 $X=952850 $Y=616135
X2788 44 74 30904 30743 30905 ICV_74 $T=953840 632205 1 0 $X=953410 $Y=627650
X2789 44 74 301 299 30873 ICV_74 $T=954400 498925 0 0 $X=953970 $Y=498535
X2790 44 74 313 30606 30998 ICV_74 $T=957200 514605 1 0 $X=956770 $Y=510050
X2791 44 74 31027 273 31011 ICV_74 $T=957760 545965 1 0 $X=957330 $Y=541410
X2792 44 74 31027 184 31044 ICV_74 $T=958880 545965 0 0 $X=958450 $Y=545575
X2793 44 74 31060 184 31000 ICV_74 $T=958880 569485 0 0 $X=958450 $Y=569095
X2794 44 74 31061 31030 31013 ICV_74 $T=958880 632205 0 0 $X=958450 $Y=631815
X2795 44 74 31028 29251 31120 ICV_74 $T=963360 624365 1 0 $X=962930 $Y=619810
X2796 44 74 31489 31340 31494 ICV_74 $T=974000 632205 0 0 $X=973570 $Y=631815
X2797 44 74 31451 30816 31893 ICV_74 $T=986320 640045 0 0 $X=985890 $Y=639655
X2798 44 74 32436 221 32414 ICV_74 $T=1003120 514605 0 0 $X=1002690 $Y=514215
X2799 44 74 32439 346 32416 ICV_74 $T=1003120 545965 0 0 $X=1002690 $Y=545575
X2800 44 74 32535 325 32518 ICV_74 $T=1006480 506765 1 0 $X=1006050 $Y=502210
X2801 44 74 357 30894 32562 ICV_74 $T=1009840 506765 1 0 $X=1009410 $Y=502210
X2802 44 74 32661 326 32648 ICV_74 $T=1010960 561645 0 0 $X=1010530 $Y=561255
X2803 44 74 32696 331 361 ICV_74 $T=1012080 491085 1 0 $X=1011650 $Y=486530
X2804 44 74 380 313 32913 ICV_74 $T=1027200 491085 0 0 $X=1026770 $Y=490695
X2805 44 74 33324 33158 394 ICV_74 $T=1035600 545965 0 0 $X=1035170 $Y=545575
X2806 44 74 159 32795 398 ICV_74 $T=1041200 514605 0 0 $X=1040770 $Y=514215
X2807 44 74 159 29347 33819 ICV_74 $T=1063600 491085 0 0 $X=1063170 $Y=490695
X2808 44 74 33189 33579 33835 ICV_74 $T=1063600 655725 0 0 $X=1063170 $Y=655335
X2809 44 74 33845 33375 33856 ICV_74 $T=1064720 663565 0 0 $X=1064290 $Y=663175
X2810 44 74 197 33590 33894 ICV_74 $T=1066960 530285 0 0 $X=1066530 $Y=529895
X2811 44 74 79 33915 29860 ICV_74 $T=1068640 624365 1 0 $X=1068210 $Y=619810
X2812 44 74 79 29791 33920 ICV_74 $T=1068640 632205 0 0 $X=1068210 $Y=631815
X2813 44 74 33997 33682 34053 ICV_74 $T=1074800 522445 1 0 $X=1074370 $Y=517890
X2814 44 74 227 420 34040 ICV_74 $T=1074800 530285 1 0 $X=1074370 $Y=525730
X2815 44 74 34083 207 34377 ICV_74 $T=1086560 491085 0 0 $X=1086130 $Y=490695
X2816 44 74 33865 207 34447 ICV_74 $T=1089360 530285 1 0 $X=1088930 $Y=525730
X2817 44 74 81 33915 34547 ICV_74 $T=1092720 608685 0 0 $X=1092290 $Y=608295
X2818 44 74 79 33956 35159 ICV_74 $T=1112320 655725 1 0 $X=1111890 $Y=651170
X2819 44 74 79 35435 35390 ICV_74 $T=1122960 640045 0 0 $X=1122530 $Y=639655
X2820 44 74 83 446 35599 ICV_74 $T=1137520 726285 1 0 $X=1137090 $Y=721730
X2821 44 74 81 35435 36131 ICV_74 $T=1152640 600845 0 0 $X=1152210 $Y=600455
X2822 44 74 36234 36131 36221 ICV_74 $T=1156000 585165 1 0 $X=1155570 $Y=580610
X2823 44 74 90 36205 36248 ICV_74 $T=1158240 608685 0 0 $X=1157810 $Y=608295
X2824 44 74 83 31803 36213 ICV_74 $T=1162160 655725 1 0 $X=1161730 $Y=651170
X2825 44 74 81 35591 36511 ICV_74 $T=1170560 600845 1 0 $X=1170130 $Y=596290
X2826 44 74 37567 37468 489 ICV_74 $T=1209760 726285 1 0 $X=1209330 $Y=721730
X2827 44 74 84 37243 37616 ICV_74 $T=1212560 702765 0 0 $X=1212130 $Y=702375
X2828 44 74 83 33913 37673 ICV_74 $T=1215920 632205 1 0 $X=1215490 $Y=627650
X2829 44 74 97 33913 37688 ICV_74 $T=1216480 640045 0 0 $X=1216050 $Y=639655
X2830 44 74 38720 38498 38695 ICV_74 $T=1256240 545965 0 0 $X=1255810 $Y=545575
X2831 44 74 38757 38914 38992 ICV_74 $T=1265760 632205 0 0 $X=1265330 $Y=631815
X2832 44 74 39131 39064 38993 ICV_74 $T=1269120 655725 1 0 $X=1268690 $Y=651170
X2833 44 74 39629 36565 39069 ICV_74 $T=1282560 663565 1 0 $X=1282130 $Y=659010
X2834 44 25035 24331 25017 74 ICV_78 $T=720320 663565 1 0 $X=719890 $Y=659010
X2835 44 25017 24483 25156 74 ICV_78 $T=724800 655725 0 0 $X=724370 $Y=655335
X2836 44 25304 24531 25253 74 ICV_78 $T=728720 624365 1 0 $X=728290 $Y=619810
X2837 44 25384 24078 25365 74 ICV_78 $T=730960 616525 1 0 $X=730530 $Y=611970
X2838 44 26740 26717 26726 74 ICV_78 $T=783600 545965 0 0 $X=783170 $Y=545575
X2839 44 81 26650 26683 74 ICV_78 $T=785280 585165 1 0 $X=784850 $Y=580610
X2840 44 27100 27072 27083 74 ICV_78 $T=799840 522445 1 0 $X=799410 $Y=517890
X2841 44 79 26947 27261 74 ICV_78 $T=806000 538125 0 0 $X=805570 $Y=537735
X2842 44 81 26947 27424 74 ICV_78 $T=811600 561645 0 0 $X=811170 $Y=561255
X2843 44 28138 28037 28139 74 ICV_78 $T=842400 687085 0 0 $X=841970 $Y=686695
X2844 44 27802 123 28220 74 ICV_78 $T=854720 702765 0 0 $X=854290 $Y=702375
X2845 44 29548 170 29520 74 ICV_78 $T=891680 538125 1 0 $X=891250 $Y=533570
X2846 44 29426 29482 29656 74 ICV_78 $T=896720 514605 0 0 $X=896290 $Y=514215
X2847 44 29647 29575 188 74 ICV_78 $T=898400 506765 0 0 $X=897970 $Y=506375
X2848 44 197 29790 29748 74 ICV_78 $T=902320 538125 1 0 $X=901890 $Y=533570
X2849 44 29323 29644 29790 74 ICV_78 $T=905680 498925 0 0 $X=905250 $Y=498535
X2850 44 30035 29455 222 74 ICV_78 $T=911840 498925 1 0 $X=911410 $Y=494370
X2851 44 30037 216 29924 74 ICV_78 $T=912400 569485 1 0 $X=911970 $Y=564930
X2852 44 29984 184 30047 74 ICV_78 $T=912960 545965 1 0 $X=912530 $Y=541410
X2853 44 30097 30073 30083 74 ICV_78 $T=914640 663565 0 0 $X=914210 $Y=663175
X2854 44 30412 29788 256 74 ICV_78 $T=929760 498925 1 0 $X=929330 $Y=494370
X2855 44 268 30232 267 74 ICV_78 $T=934240 498925 1 0 $X=933810 $Y=494370
X2856 44 287 262 30698 74 ICV_78 $T=943200 514605 1 0 $X=942770 $Y=510050
X2857 44 312 314 317 74 ICV_78 $T=956640 726285 1 0 $X=956210 $Y=721730
X2858 44 244 30595 31052 74 ICV_78 $T=958320 561645 1 0 $X=957890 $Y=557090
X2859 44 31149 29825 31134 74 ICV_78 $T=961120 585165 0 0 $X=960690 $Y=584775
X2860 44 296 323 31135 74 ICV_78 $T=961120 726285 1 0 $X=960690 $Y=721730
X2861 44 31191 260 31158 74 ICV_78 $T=962800 514605 1 0 $X=962370 $Y=510050
X2862 44 31194 30233 31179 74 ICV_78 $T=963360 553805 1 0 $X=962930 $Y=549250
X2863 44 337 286 31507 74 ICV_78 $T=973440 718445 1 0 $X=973010 $Y=713890
X2864 44 31495 298 31659 74 ICV_78 $T=977920 718445 1 0 $X=977490 $Y=713890
X2865 44 31075 31290 31782 74 ICV_78 $T=981840 632205 0 0 $X=981410 $Y=631815
X2866 44 31287 31221 32047 74 ICV_78 $T=990240 647885 0 0 $X=989810 $Y=647495
X2867 44 32115 31415 32102 74 ICV_78 $T=991920 663565 1 0 $X=991490 $Y=659010
X2868 44 32436 184 32415 74 ICV_78 $T=1002560 522445 0 0 $X=1002130 $Y=522055
X2869 44 32725 273 32647 74 ICV_78 $T=1012080 514605 1 0 $X=1011650 $Y=510050
X2870 44 363 240 32726 74 ICV_78 $T=1012640 530285 0 0 $X=1012210 $Y=529895
X2871 44 197 352 32935 74 ICV_78 $T=1019360 514605 1 0 $X=1018930 $Y=510050
X2872 44 33202 33092 33116 74 ICV_78 $T=1029440 647885 1 0 $X=1029010 $Y=643330
X2873 44 159 28125 33214 74 ICV_78 $T=1030000 561645 0 0 $X=1029570 $Y=561255
X2874 44 33272 33267 33016 74 ICV_78 $T=1033360 530285 0 0 $X=1032930 $Y=529895
X2875 44 33255 33158 33315 74 ICV_78 $T=1034480 561645 1 0 $X=1034050 $Y=557090
X2876 44 159 33076 33344 74 ICV_78 $T=1037840 569485 0 0 $X=1037410 $Y=569095
X2877 44 33404 33346 33300 74 ICV_78 $T=1038960 624365 0 0 $X=1038530 $Y=623975
X2878 44 33425 216 33417 74 ICV_78 $T=1040080 585165 1 0 $X=1039650 $Y=580610
X2879 44 79 33106 33455 74 ICV_78 $T=1042320 687085 0 0 $X=1041890 $Y=686695
X2880 44 33430 33369 405 74 ICV_78 $T=1045120 522445 0 0 $X=1044690 $Y=522055
X2881 44 33049 33452 33538 74 ICV_78 $T=1046800 647885 0 0 $X=1046370 $Y=647495
X2882 44 33709 216 33690 74 ICV_78 $T=1055200 577325 0 0 $X=1054770 $Y=576935
X2883 44 33721 33706 33720 74 ICV_78 $T=1056320 538125 1 0 $X=1055890 $Y=533570
X2884 44 33820 273 33807 74 ICV_78 $T=1061360 561645 0 0 $X=1060930 $Y=561255
X2885 44 33875 221 33868 74 ICV_78 $T=1064160 577325 0 0 $X=1063730 $Y=576935
X2886 44 33892 33579 33884 74 ICV_78 $T=1065280 671405 1 0 $X=1064850 $Y=666850
X2887 44 433 33729 434 74 ICV_78 $T=1066400 498925 0 0 $X=1065970 $Y=498535
X2888 44 33856 33329 33932 74 ICV_78 $T=1068080 663565 0 0 $X=1067650 $Y=663175
X2889 44 218 33016 442 74 ICV_78 $T=1071440 538125 1 0 $X=1071010 $Y=533570
X2890 44 227 32833 34099 74 ICV_78 $T=1075360 514605 0 0 $X=1074930 $Y=514215
X2891 44 244 32535 34149 74 ICV_78 $T=1078160 522445 1 0 $X=1077730 $Y=517890
X2892 44 278 375 34282 74 ICV_78 $T=1082080 491085 0 0 $X=1081650 $Y=490695
X2893 44 79 34461 34615 74 ICV_78 $T=1094400 616525 1 0 $X=1093970 $Y=611970
X2894 44 35342 35312 35330 74 ICV_78 $T=1117360 608685 1 0 $X=1116930 $Y=604130
X2895 44 83 342 35770 74 ICV_78 $T=1136400 702765 0 0 $X=1135970 $Y=702375
X2896 44 97 31803 36243 74 ICV_78 $T=1160480 671405 0 0 $X=1160050 $Y=671015
X2897 44 36601 36511 36602 74 ICV_78 $T=1173920 600845 1 0 $X=1173490 $Y=596290
X2898 44 83 34369 36760 74 ICV_78 $T=1180640 647885 0 0 $X=1180210 $Y=647495
X2899 44 81 482 37278 74 ICV_78 $T=1197440 491085 1 0 $X=1197010 $Y=486530
X2900 44 37112 37284 37392 74 ICV_78 $T=1202480 545965 1 0 $X=1202050 $Y=541410
X2901 44 37766 97 37566 74 ICV_78 $T=1219840 632205 0 0 $X=1219410 $Y=631815
X2902 44 38645 34119 38556 74 ICV_78 $T=1252880 663565 0 0 $X=1252450 $Y=663175
X2903 44 38610 38327 38702 74 ICV_78 $T=1255120 538125 1 0 $X=1254690 $Y=533570
X2904 44 38463 36565 38765 74 ICV_78 $T=1260160 624365 0 0 $X=1259730 $Y=623975
X2905 44 38645 36565 38902 74 ICV_78 $T=1261840 663565 0 0 $X=1261410 $Y=663175
X2955 44 74 24568 24611 24590 ICV_72 $T=710240 655725 1 0 $X=709810 $Y=651170
X2956 44 74 24532 24797 24645 ICV_72 $T=715280 608685 1 0 $X=714850 $Y=604130
X2957 44 74 25900 26010 82 ICV_72 $T=751120 491085 1 0 $X=750690 $Y=486530
X2958 44 74 81 88 26010 ICV_72 $T=756160 491085 1 0 $X=755730 $Y=486530
X2959 44 74 81 92 26259 ICV_72 $T=761200 491085 1 0 $X=760770 $Y=486530
X2960 44 74 83 26468 26371 ICV_72 $T=772400 647885 0 0 $X=771970 $Y=647495
X2961 44 74 26891 26918 26903 ICV_72 $T=793680 491085 1 0 $X=793250 $Y=486530
X2962 44 74 26992 27043 27069 ICV_72 $T=800960 538125 0 0 $X=800530 $Y=537735
X2963 44 74 90 27444 27379 ICV_72 $T=813280 632205 1 0 $X=812850 $Y=627650
X2964 44 74 97 113 27440 ICV_72 $T=813840 663565 1 0 $X=813410 $Y=659010
X2965 44 74 27439 27492 27480 ICV_72 $T=815520 545965 0 0 $X=815090 $Y=545575
X2966 44 74 27934 97 27891 ICV_72 $T=837360 655725 1 0 $X=836930 $Y=651170
X2967 44 74 28380 137 28372 ICV_72 $T=855840 694925 0 0 $X=855410 $Y=694535
X2968 44 74 28166 29174 29150 ICV_72 $T=878240 616525 1 0 $X=877810 $Y=611970
X2969 44 74 159 28318 163 ICV_72 $T=887200 498925 1 0 $X=886770 $Y=494370
X2970 44 74 30037 221 30029 ICV_72 $T=914640 577325 0 0 $X=914210 $Y=576935
X2971 44 74 244 30233 29717 ICV_72 $T=923040 545965 1 0 $X=922610 $Y=541410
X2972 44 74 217 30314 246 ICV_72 $T=926960 530285 1 0 $X=926530 $Y=525730
X2973 44 74 79 30315 30097 ICV_72 $T=926960 663565 0 0 $X=926530 $Y=663175
X2974 44 74 268 29455 30595 ICV_72 $T=940400 498925 0 0 $X=939970 $Y=498535
X2975 44 74 280 265 30606 ICV_72 $T=940960 506765 1 0 $X=940530 $Y=502210
X2976 44 74 30508 260 30679 ICV_72 $T=943760 530285 0 0 $X=943330 $Y=529895
X2977 44 74 30905 30939 30921 ICV_72 $T=954400 647885 0 0 $X=953970 $Y=647495
X2978 44 74 290 236 31102 ICV_72 $T=961680 514605 0 0 $X=961250 $Y=514215
X2979 44 74 31029 30930 31119 ICV_72 $T=962240 608685 0 0 $X=961810 $Y=608295
X2980 44 74 30094 325 31163 ICV_72 $T=963360 506765 1 0 $X=962930 $Y=502210
X2981 44 74 31150 31493 31488 ICV_72 $T=974000 616525 1 0 $X=973570 $Y=611970
X2982 44 74 30920 31626 31635 ICV_72 $T=979040 616525 1 0 $X=978610 $Y=611970
X2983 44 74 216 32455 32439 ICV_72 $T=1004240 538125 0 0 $X=1003810 $Y=537735
X2984 44 74 31148 30582 32630 ICV_72 $T=1010960 593005 1 0 $X=1010530 $Y=588450
X2985 44 74 303 32833 32588 ICV_72 $T=1017120 522445 0 0 $X=1016690 $Y=522055
X2986 44 74 32794 273 32848 ICV_72 $T=1018240 593005 0 0 $X=1017810 $Y=592615
X2987 44 74 31148 33243 33187 ICV_72 $T=1032240 585165 1 0 $X=1031810 $Y=580610
X2988 44 74 159 33273 33384 ICV_72 $T=1042320 553805 1 0 $X=1041890 $Y=549250
X2989 44 74 33324 33447 33436 ICV_72 $T=1042880 545965 0 0 $X=1042450 $Y=545575
X2990 44 74 185 32455 33519 ICV_72 $T=1047920 569485 0 0 $X=1047490 $Y=569095
X2991 44 74 185 33370 33564 ICV_72 $T=1050160 569485 1 0 $X=1049730 $Y=564930
X2992 44 74 175 33315 411 ICV_72 $T=1052400 498925 0 0 $X=1051970 $Y=498535
X2993 44 74 290 33436 33700 ICV_72 $T=1056880 553805 1 0 $X=1056450 $Y=549250
X2994 44 74 33819 432 374 ICV_72 $T=1064160 491085 1 0 $X=1063730 $Y=486530
X2995 44 74 33820 184 33883 ICV_72 $T=1066960 553805 1 0 $X=1066530 $Y=549250
X2996 44 74 33875 216 33866 ICV_72 $T=1068080 577325 1 0 $X=1067650 $Y=572770
X2997 44 74 244 32619 34302 ICV_72 $T=1084320 506765 0 0 $X=1083890 $Y=506375
X2998 44 74 33920 34398 34383 ICV_72 $T=1087120 655725 0 0 $X=1086690 $Y=655335
X2999 44 74 34083 184 34450 ICV_72 $T=1089920 498925 0 0 $X=1089490 $Y=498535
X3000 44 74 217 410 34457 ICV_72 $T=1092720 514605 1 0 $X=1092290 $Y=510050
X3001 44 74 90 35389 35570 ICV_72 $T=1132480 702765 1 0 $X=1132050 $Y=698210
X3002 44 74 36664 37261 37245 ICV_72 $T=1198000 522445 0 0 $X=1197570 $Y=522055
X3003 44 74 37242 37279 37259 ICV_72 $T=1198560 577325 1 0 $X=1198130 $Y=572770
X3004 44 74 84 37885 496 ICV_72 $T=1226560 702765 1 0 $X=1226130 $Y=698210
X3005 44 74 78 499 37800 ICV_72 $T=1229920 702765 0 0 $X=1229490 $Y=702375
X3006 44 74 39424 38764 39628 ICV_72 $T=1283680 624365 0 0 $X=1283250 $Y=623975
X3007 24144 24532 44 74 24547 AND2X1 $T=708000 600845 0 0 $X=707570 $Y=600455
X3008 24777 24701 44 74 24588 AND2X1 $T=717520 600845 1 180 $X=713730 $Y=600455
X3009 24841 24794 44 74 24753 AND2X1 $T=719200 647885 0 180 $X=715410 $Y=643330
X3010 24814 24040 44 74 24154 AND2X1 $T=721440 616525 1 180 $X=717650 $Y=616135
X3011 24674 24999 44 74 25138 AND2X1 $T=724240 647885 0 0 $X=723810 $Y=647495
X3012 24144 24531 44 74 24674 AND2X1 $T=728160 640045 1 180 $X=724370 $Y=639655
X3013 25081 24144 44 74 25192 AND2X1 $T=725920 647885 1 0 $X=725490 $Y=643330
X3014 25155 24979 44 74 25339 AND2X1 $T=730400 600845 0 0 $X=729970 $Y=600455
X3015 27994 28074 44 74 28068 AND2X1 $T=840720 718445 0 0 $X=840290 $Y=718055
X3016 29564 29589 44 74 29617 AND2X1 $T=895040 553805 0 0 $X=894610 $Y=553415
X3017 211 213 44 74 29939 AND2X1 $T=908480 491085 0 0 $X=908050 $Y=490695
X3018 30107 30081 44 74 30157 AND2X1 $T=918000 522445 0 0 $X=917570 $Y=522055
X3019 30150 30165 44 74 30187 AND2X1 $T=919680 593005 1 0 $X=919250 $Y=588450
X3020 30212 30141 44 74 30226 AND2X1 $T=923040 538125 0 0 $X=922610 $Y=537735
X3021 30234 30256 44 74 30273 AND2X1 $T=924160 593005 1 0 $X=923730 $Y=588450
X3022 30337 237 44 74 30379 AND2X1 $T=929200 585165 1 0 $X=928770 $Y=580610
X3023 30571 30543 44 74 30413 AND2X1 $T=941520 585165 0 180 $X=937730 $Y=580610
X3024 30552 30530 44 74 30574 AND2X1 $T=943760 538125 0 180 $X=939970 $Y=533570
X3025 30678 30649 44 74 30509 AND2X1 $T=946000 506765 1 180 $X=942210 $Y=506375
X3026 30736 30733 44 74 30632 AND2X1 $T=949920 593005 1 180 $X=946130 $Y=592615
X3027 300 30698 44 74 30760 AND2X1 $T=952160 514605 1 180 $X=948370 $Y=514215
X3028 309 319 44 74 329 AND2X1 $T=970640 726285 0 180 $X=966850 $Y=721730
X3029 31029 31400 44 74 31287 AND2X1 $T=980720 655725 1 180 $X=976930 $Y=655335
X3030 31617 31578 44 74 31490 AND2X1 $T=980720 663565 1 180 $X=976930 $Y=663175
X3031 31271 31659 44 74 31835 AND2X1 $T=983520 718445 0 0 $X=983090 $Y=718055
X3032 31539 31400 44 74 31810 AND2X1 $T=988560 640045 0 180 $X=984770 $Y=635490
X3033 31539 30545 44 74 31864 AND2X1 $T=988000 624365 0 0 $X=987570 $Y=623975
X3034 325 338 44 74 30894 AND2X1 $T=993600 498925 0 0 $X=993170 $Y=498535
X3035 32521 32385 44 74 32458 AND2X1 $T=1009280 585165 1 180 $X=1005490 $Y=584775
X3036 32846 216 44 74 32727 AND2X1 $T=1021600 538125 0 180 $X=1017810 $Y=533570
X3037 32828 32966 44 74 32947 AND2X1 $T=1021600 545965 1 0 $X=1021170 $Y=541410
X3038 32986 32848 44 74 33042 AND2X1 $T=1023280 593005 0 0 $X=1022850 $Y=592615
X3039 32980 33046 44 74 33075 AND2X1 $T=1024400 530285 1 0 $X=1023970 $Y=525730
X3040 33077 33044 44 74 32880 AND2X1 $T=1028320 506765 1 180 $X=1024530 $Y=506375
X3041 33079 32969 44 74 33127 AND2X1 $T=1026640 593005 1 0 $X=1026210 $Y=588450
X3042 33103 33141 44 74 33048 AND2X1 $T=1032240 640045 0 180 $X=1028450 $Y=635490
X3043 33157 33168 44 74 33045 AND2X1 $T=1033360 514605 0 180 $X=1029570 $Y=510050
X3044 33215 33240 44 74 33256 AND2X1 $T=1032240 593005 0 0 $X=1031810 $Y=592615
X3045 33324 33338 44 74 399 AND2X1 $T=1037840 553805 1 0 $X=1037410 $Y=549250
X3046 33198 237 44 74 33474 AND2X1 $T=1043440 569485 1 0 $X=1043010 $Y=564930
X3047 33241 33477 44 74 33275 AND2X1 $T=1048480 624365 1 180 $X=1044690 $Y=623975
X3048 33465 33141 44 74 33444 AND2X1 $T=1050160 632205 1 180 $X=1046370 $Y=631815
X3049 33394 33386 44 74 366 AND2X1 $T=1051280 538125 1 180 $X=1047490 $Y=537735
X3050 33582 33362 44 74 33627 AND2X1 $T=1051280 632205 1 0 $X=1050850 $Y=627650
X3051 33465 33477 44 74 33539 AND2X1 $T=1052400 663565 0 0 $X=1051970 $Y=663175
X3052 412 33639 44 74 33658 AND2X1 $T=1052960 538125 0 0 $X=1052530 $Y=537735
X3053 33651 33477 44 74 33189 AND2X1 $T=1055760 663565 0 0 $X=1055330 $Y=663175
X3054 33220 33174 44 74 33630 AND2X1 $T=1059680 655725 1 180 $X=1055890 $Y=655335
X3055 33868 33869 44 74 33005 AND2X1 $T=1072000 585165 1 180 $X=1068210 $Y=584775
X3056 34160 391 44 74 34115 AND2X1 $T=1082080 491085 1 180 $X=1078290 $Y=490695
X3057 34179 34142 44 74 34084 AND2X1 $T=1082080 506765 1 180 $X=1078290 $Y=506375
X3058 34603 34290 44 74 34743 AND2X1 $T=1098320 569485 1 0 $X=1097890 $Y=564930
X3059 38190 38153 44 74 497 AND2X1 $T=1239440 585165 0 0 $X=1239010 $Y=584775
X3060 38312 38449 44 74 81 AND2X1 $T=1247280 569485 1 0 $X=1246850 $Y=564930
X3061 38418 38453 44 74 38480 AND2X1 $T=1247280 655725 1 0 $X=1246850 $Y=651170
X3062 38547 38519 44 74 38487 AND2X1 $T=1253440 640045 0 180 $X=1249650 $Y=635490
X3063 38757 38609 44 74 38566 AND2X1 $T=1260720 647885 0 180 $X=1256930 $Y=643330
X3064 39149 39191 44 74 39166 AND2X1 $T=1271360 624365 1 0 $X=1270930 $Y=619810
X3065 38791 39234 44 74 39096 AND2X1 $T=1276400 632205 1 180 $X=1272610 $Y=631815
X3066 39396 39069 44 74 39624 AND2X1 $T=1282000 671405 1 0 $X=1281570 $Y=666850
X3067 39216 34348 44 74 39707 AND2X1 $T=1284240 640045 0 0 $X=1283810 $Y=639655
X3068 24039 44 74 24348 INVX2 $T=704080 655725 0 0 $X=703650 $Y=655335
X3069 24330 44 74 24126 INVX2 $T=704640 624365 1 0 $X=704210 $Y=619810
X3070 24078 44 74 24473 INVX2 $T=707440 663565 1 0 $X=707010 $Y=659010
X3071 24261 44 74 24482 INVX2 $T=710800 640045 1 180 $X=708690 $Y=639655
X3072 24589 44 74 24532 INVX2 $T=712480 600845 0 0 $X=712050 $Y=600455
X3073 24645 44 74 24565 INVX2 $T=714160 608685 1 180 $X=712050 $Y=608295
X3074 24701 44 74 24418 INVX2 $T=715280 624365 1 180 $X=713170 $Y=623975
X3075 24331 44 74 24622 INVX2 $T=715840 640045 1 180 $X=713730 $Y=639655
X3076 24548 44 74 25032 INVX2 $T=722560 600845 1 0 $X=722130 $Y=596290
X3077 24352 44 74 25062 INVX2 $T=723680 593005 0 0 $X=723250 $Y=592615
X3078 24752 44 74 24285 INVX2 $T=724240 616525 1 0 $X=723810 $Y=611970
X3079 24862 44 74 24040 INVX2 $T=725920 616525 0 0 $X=725490 $Y=616135
X3080 24265 44 74 24797 INVX2 $T=728160 608685 0 180 $X=726050 $Y=604130
X3081 24883 44 74 24999 INVX2 $T=726480 632205 0 0 $X=726050 $Y=631815
X3082 24531 44 74 24196 INVX2 $T=737120 632205 0 180 $X=735010 $Y=627650
X3083 25252 44 74 25652 INVX2 $T=741600 616525 1 0 $X=741170 $Y=611970
X3084 120 44 74 27580 INVX2 $T=822240 718445 1 180 $X=820130 $Y=718055
X3085 27802 44 74 27765 INVX2 $T=830640 694925 1 180 $X=828530 $Y=694535
X3086 128 44 74 27655 INVX2 $T=830640 702765 0 180 $X=828530 $Y=698210
X3087 27860 44 74 27605 INVX2 $T=832880 718445 0 180 $X=830770 $Y=713890
X3088 127 44 74 27766 INVX2 $T=835120 718445 0 180 $X=833010 $Y=713890
X3089 27892 44 74 118 INVX2 $T=837920 694925 1 180 $X=835810 $Y=694535
X3090 27918 44 74 134 INVX2 $T=839040 726285 0 180 $X=836930 $Y=721730
X3091 28079 44 74 28098 INVX2 $T=842400 702765 1 0 $X=841970 $Y=698210
X3092 28134 44 74 27712 INVX2 $T=845760 702765 0 180 $X=843650 $Y=698210
X3093 28182 44 74 28198 INVX2 $T=846880 687085 1 0 $X=846450 $Y=682530
X3094 140 44 74 27840 INVX2 $T=848560 726285 0 180 $X=846450 $Y=721730
X3095 28175 44 74 27919 INVX2 $T=849120 726285 1 180 $X=847010 $Y=725895
X3096 143 44 74 27946 INVX2 $T=850240 718445 0 180 $X=848130 $Y=713890
X3097 144 44 74 28155 INVX2 $T=851360 726285 0 180 $X=849250 $Y=721730
X3098 28232 44 74 27625 INVX2 $T=852480 694925 1 180 $X=850370 $Y=694535
X3099 27752 44 74 137 INVX2 $T=858080 687085 1 180 $X=855970 $Y=686695
X3100 27821 44 74 123 INVX2 $T=862560 710605 0 0 $X=862130 $Y=710215
X3101 29598 44 74 29535 INVX2 $T=897840 538125 0 180 $X=895730 $Y=533570
X3102 281 44 74 30684 INVX2 $T=944320 710605 0 0 $X=943890 $Y=710215
X3103 30999 44 74 31001 INVX2 $T=960000 585165 1 0 $X=959570 $Y=580610
X3104 319 44 74 321 INVX2 $T=961120 726285 0 0 $X=960690 $Y=725895
X3105 31010 44 74 31100 INVX2 $T=961680 506765 1 0 $X=961250 $Y=502210
X3106 30893 44 74 31030 INVX2 $T=962240 632205 0 0 $X=961810 $Y=631815
X3107 31059 44 74 31090 INVX2 $T=962800 561645 0 0 $X=962370 $Y=561255
X3108 31066 44 74 31114 INVX2 $T=962800 655725 1 0 $X=962370 $Y=651170
X3109 31118 44 74 31075 INVX2 $T=963360 647885 1 0 $X=962930 $Y=643330
X3110 31221 44 74 31203 INVX2 $T=967840 663565 0 180 $X=965730 $Y=659010
X3111 30930 44 74 31227 INVX2 $T=968960 608685 1 180 $X=966850 $Y=608295
X3112 30545 44 74 31207 INVX2 $T=969520 616525 1 180 $X=967410 $Y=616135
X3113 30743 44 74 31451 INVX2 $T=973440 632205 1 0 $X=973010 $Y=627650
X3114 31415 44 74 31240 INVX2 $T=973440 655725 0 0 $X=973010 $Y=655335
X3115 30821 44 74 312 INVX2 $T=977920 726285 0 180 $X=975810 $Y=721730
X3116 29251 44 74 31290 INVX2 $T=979040 632205 1 180 $X=976930 $Y=631815
X3117 31328 44 74 31167 INVX2 $T=983520 640045 1 0 $X=983090 $Y=635490
X3118 30816 44 74 31400 INVX2 $T=986320 647885 0 180 $X=984210 $Y=643330
X3119 346 44 74 31194 INVX2 $T=986880 506765 1 0 $X=986450 $Y=502210
X3120 200 44 74 31092 INVX2 $T=991360 498925 1 180 $X=989250 $Y=498535
X3121 32333 44 74 32283 INVX2 $T=1002560 553805 1 180 $X=1000450 $Y=553415
X3122 184 44 74 32385 INVX2 $T=1003680 577325 0 0 $X=1003250 $Y=576935
X3123 362 44 74 32697 INVX2 $T=1013760 553805 1 0 $X=1013330 $Y=549250
X3124 363 44 74 32903 INVX2 $T=1024400 530285 1 180 $X=1022290 $Y=529895
X3125 32865 44 74 301 INVX2 $T=1027200 491085 1 180 $X=1025090 $Y=490695
X3126 218 44 74 33113 INVX2 $T=1027760 530285 0 0 $X=1027330 $Y=529895
X3127 33049 44 74 33114 INVX2 $T=1027760 663565 0 0 $X=1027330 $Y=663175
X3128 33220 44 74 33115 INVX2 $T=1033920 632205 1 180 $X=1031810 $Y=631815
X3129 33103 44 74 33299 INVX2 $T=1035600 647885 1 0 $X=1035170 $Y=643330
X3130 395 44 74 33306 INVX2 $T=1038400 491085 0 180 $X=1036290 $Y=486530
X3131 33361 44 74 33379 INVX2 $T=1042320 647885 1 180 $X=1040210 $Y=647495
X3132 33441 44 74 33408 INVX2 $T=1045120 679245 1 180 $X=1043010 $Y=678855
X3133 33241 44 74 33579 INVX2 $T=1051280 624365 1 0 $X=1050850 $Y=619810
X3134 33387 44 74 33174 INVX2 $T=1057440 655725 1 0 $X=1057010 $Y=651170
X3135 33202 44 74 33329 INVX2 $T=1060800 647885 1 0 $X=1060370 $Y=643330
X3136 33141 44 74 33735 INVX2 $T=1063040 632205 0 180 $X=1060930 $Y=627650
X3137 33092 44 74 33651 INVX2 $T=1064720 663565 1 180 $X=1062610 $Y=663175
X3138 33228 44 74 33313 INVX2 $T=1069200 655725 0 180 $X=1067090 $Y=651170
X3139 83 44 74 464 INVX2 $T=1138640 624365 0 0 $X=1138210 $Y=623975
X3140 97 44 74 26248 INVX2 $T=1139760 655725 0 0 $X=1139330 $Y=655335
X3141 37945 44 74 38004 INVX2 $T=1232720 553805 1 0 $X=1232290 $Y=549250
X3142 38069 44 74 38064 INVX2 $T=1240000 545965 0 0 $X=1239570 $Y=545575
X3143 25419 44 74 38190 INVX2 $T=1243920 577325 1 180 $X=1241810 $Y=576935
X3144 38298 44 74 38326 INVX2 $T=1243360 577325 1 0 $X=1242930 $Y=572770
X3145 497 44 74 38449 INVX2 $T=1248400 561645 1 0 $X=1247970 $Y=557090
X3146 38463 44 74 38421 INVX2 $T=1250080 616525 0 180 $X=1247970 $Y=611970
X3147 38310 44 74 38479 INVX2 $T=1248960 530285 0 0 $X=1248530 $Y=529895
X3148 81 44 74 38498 INVX2 $T=1250080 545965 0 0 $X=1249650 $Y=545575
X3149 38506 44 74 38526 INVX2 $T=1250640 655725 0 0 $X=1250210 $Y=655335
X3150 38518 44 74 38412 INVX2 $T=1252880 569485 1 180 $X=1250770 $Y=569095
X3151 38556 44 74 38519 INVX2 $T=1253440 647885 0 180 $X=1251330 $Y=643330
X3152 36950 44 74 38601 INVX2 $T=1253440 608685 0 0 $X=1253010 $Y=608295
X3153 38609 44 74 38521 INVX2 $T=1255680 640045 1 180 $X=1253570 $Y=639655
X3154 38564 44 74 38558 INVX2 $T=1255120 553805 1 0 $X=1254690 $Y=549250
X3155 38645 44 74 38530 INVX2 $T=1256800 671405 0 180 $X=1254690 $Y=666850
X3156 38573 44 74 38680 INVX2 $T=1256240 616525 1 0 $X=1255810 $Y=611970
X3157 38716 44 74 38689 INVX2 $T=1259040 655725 0 180 $X=1256930 $Y=651170
X3158 34481 44 74 38667 INVX2 $T=1258480 616525 0 0 $X=1258050 $Y=616135
X3159 36565 44 74 38764 INVX2 $T=1263520 624365 0 180 $X=1261410 $Y=619810
X3160 38702 44 74 38812 INVX2 $T=1262400 545965 1 0 $X=1261970 $Y=541410
X3161 38547 44 74 38848 INVX2 $T=1264080 647885 1 180 $X=1261970 $Y=647495
X3162 38892 44 74 38734 INVX2 $T=1265200 608685 0 180 $X=1263090 $Y=604130
X3163 38722 44 74 38914 INVX2 $T=1264080 632205 1 0 $X=1263650 $Y=627650
X3164 38946 44 74 38262 INVX2 $T=1266880 624365 1 180 $X=1264770 $Y=623975
X3165 39216 44 74 39222 INVX2 $T=1275280 647885 1 180 $X=1273170 $Y=647495
X3166 39303 44 74 39276 INVX2 $T=1280320 608685 0 180 $X=1278210 $Y=604130
X3167 39396 44 74 39381 INVX2 $T=1280320 647885 1 180 $X=1278210 $Y=647495
X3168 39494 44 74 39235 INVX2 $T=1282000 655725 0 180 $X=1279890 $Y=651170
X3169 39193 44 74 39424 INVX2 $T=1280880 624365 0 0 $X=1280450 $Y=623975
X3170 34119 44 74 39629 INVX2 $T=1285920 663565 1 0 $X=1285490 $Y=659010
X3171 32914 44 74 39651 INVX2 $T=1291520 647885 0 0 $X=1291090 $Y=647495
X3272 26515 44 74 26480 BUFX1 $T=775760 569485 1 180 $X=772530 $Y=569095
X3273 26515 44 74 103 BUFX1 $T=784160 522445 0 180 $X=780930 $Y=517890
X3274 27248 44 74 27182 BUFX1 $T=808800 687085 0 180 $X=805570 $Y=682530
X3275 27248 44 74 27325 BUFX1 $T=813280 671405 0 180 $X=810050 $Y=666850
X3276 26515 44 74 27617 BUFX1 $T=820560 561645 0 0 $X=820130 $Y=561255
X3277 26515 44 74 27647 BUFX1 $T=821680 538125 0 0 $X=821250 $Y=537735
X3278 26515 44 74 130 BUFX1 $T=831200 522445 0 0 $X=830770 $Y=522055
X3279 28421 44 74 26515 BUFX1 $T=858640 569485 0 180 $X=855410 $Y=564930
X3280 26515 44 74 28698 BUFX1 $T=863680 569485 0 0 $X=863250 $Y=569095
X3281 27248 44 74 29115 BUFX1 $T=876000 679245 0 0 $X=875570 $Y=678855
X3282 155 44 74 29141 BUFX1 $T=881600 671405 0 180 $X=878370 $Y=666850
X3283 253 44 74 28421 BUFX1 $T=930320 569485 0 180 $X=927090 $Y=564930
X3284 27248 44 74 30452 BUFX1 $T=932560 687085 0 0 $X=932130 $Y=686695
X3285 253 44 74 279 BUFX1 $T=938720 679245 0 0 $X=938290 $Y=678855
X3286 279 44 74 27248 BUFX1 $T=942640 679245 0 0 $X=942210 $Y=678855
X3287 279 44 74 155 BUFX1 $T=945440 702765 0 0 $X=945010 $Y=702375
X3288 155 44 74 308 BUFX1 $T=952720 702765 1 0 $X=952290 $Y=698210
X3289 28421 44 74 355 BUFX1 $T=1006480 569485 1 0 $X=1006050 $Y=564930
X3290 27248 44 74 359 BUFX1 $T=1010960 679245 0 0 $X=1010530 $Y=678855
X3291 355 44 74 33622 BUFX1 $T=1056320 608685 0 180 $X=1053090 $Y=604130
X3292 279 44 74 448 BUFX1 $T=1081520 710605 0 0 $X=1081090 $Y=710215
X3293 448 44 74 449 BUFX1 $T=1085440 710605 0 0 $X=1085010 $Y=710215
X3294 448 44 74 35562 BUFX1 $T=1132480 702765 0 180 $X=1129250 $Y=698210
X3295 28421 44 74 35774 BUFX1 $T=1142000 577325 0 180 $X=1138770 $Y=572770
X3296 35774 44 74 35822 BUFX1 $T=1139200 600845 0 0 $X=1138770 $Y=600455
X3297 35774 44 74 467 BUFX1 $T=1147040 569485 0 0 $X=1146610 $Y=569095
X3298 448 44 74 469 BUFX1 $T=1153200 726285 0 180 $X=1149970 $Y=721730
X3299 28421 44 74 36422 BUFX1 $T=1165520 569485 1 0 $X=1165090 $Y=564930
X3300 36422 44 74 36395 BUFX1 $T=1168320 577325 1 180 $X=1165090 $Y=576935
X3301 36422 44 74 36707 BUFX1 $T=1179520 553805 0 0 $X=1179090 $Y=553415
X3302 36422 44 74 479 BUFX1 $T=1189040 491085 0 180 $X=1185810 $Y=486530
X3303 36422 44 74 486 BUFX1 $T=1199120 506765 0 0 $X=1198690 $Y=506375
X3304 36422 44 74 37292 BUFX1 $T=1203600 569485 0 180 $X=1200370 $Y=564930
X3305 35774 44 74 37414 BUFX1 $T=1204160 593005 0 0 $X=1203730 $Y=592615
X3306 36422 44 74 492 BUFX1 $T=1212560 538125 1 0 $X=1212130 $Y=533570
X3307 35774 44 74 37745 BUFX1 $T=1219840 577325 0 0 $X=1219410 $Y=576935
X3308 44 74 53802 pad_in $T=74960 621325 0 270 $X=74960 $Y=530425
X3399 44 74 23985 24039 24014 ICV_77 $T=692880 608685 0 0 $X=692450 $Y=608295
X3400 44 74 23986 24040 24010 ICV_77 $T=692880 616525 0 0 $X=692450 $Y=616135
X3401 44 74 81 26085 26187 ICV_77 $T=755600 538125 0 0 $X=755170 $Y=537735
X3402 44 74 27638 120 27502 ICV_77 $T=820000 710605 1 0 $X=819570 $Y=706050
X3403 44 74 83 165 29296 ICV_77 $T=885520 726285 1 0 $X=885090 $Y=721730
X3404 44 74 29895 216 29749 ICV_77 $T=906240 561645 0 0 $X=905810 $Y=561255
X3405 44 74 30631 260 30543 ICV_77 $T=939840 585165 0 0 $X=939410 $Y=584775
X3406 44 74 30633 286 30634 ICV_77 $T=939840 718445 0 0 $X=939410 $Y=718055
X3407 44 74 185 30142 30874 ICV_77 $T=951040 553805 1 0 $X=950610 $Y=549250
X3408 44 74 31028 31066 30924 ICV_77 $T=956640 624365 0 0 $X=956210 $Y=623975
X3409 44 74 31058 31092 30917 ICV_77 $T=957760 498925 0 0 $X=957330 $Y=498535
X3410 44 74 32437 32487 32472 ICV_77 $T=1002560 553805 0 0 $X=1002130 $Y=553415
X3411 44 74 33555 332 33669 ICV_77 $T=1051840 506765 1 0 $X=1051410 $Y=502210
X3412 44 74 33503 221 33855 ICV_77 $T=1067520 569485 1 0 $X=1067090 $Y=564930
X3413 44 74 81 36831 36841 ICV_77 $T=1187920 593005 0 0 $X=1187490 $Y=592615
X3414 44 74 84 37300 37468 ICV_77 $T=1204160 726285 1 0 $X=1203730 $Y=721730
X3415 44 74 38764 39651 38716 ICV_77 $T=1285360 647885 1 0 $X=1284930 $Y=643330
X3520 44 24011 24058 24034 74 24039 24126 24011 ICV_112 $T=696240 640045 1 0 $X=695810 $Y=635490
X3521 44 24306 24356 24124 74 24459 24352 24191 ICV_112 $T=703520 608685 1 0 $X=703090 $Y=604130
X3522 44 25867 25916 25901 74 81 25477 25916 ICV_112 $T=748320 561645 1 0 $X=747890 $Y=557090
X3523 44 25951 25995 25968 74 81 25992 25995 ICV_112 $T=750560 514605 1 0 $X=750130 $Y=510050
X3524 44 81 26976 26869 74 79 26650 26838 ICV_112 $T=796480 585165 0 0 $X=796050 $Y=584775
X3525 44 81 26991 27195 74 27261 27195 27283 ICV_112 $T=805440 514605 1 0 $X=805010 $Y=510050
X3526 44 97 121 27525 74 83 119 27555 ICV_112 $T=821120 671405 0 0 $X=820690 $Y=671015
X3527 44 27808 27919 27530 74 27808 27892 27957 ICV_112 $T=832880 710605 1 0 $X=832450 $Y=706050
X3528 44 175 181 29589 74 186 177 29657 ICV_112 $T=895600 545965 0 0 $X=895170 $Y=545575
X3529 44 29619 199 30221 74 29846 163 250 ICV_112 $T=923040 491085 0 0 $X=922610 $Y=490695
X3530 44 30313 207 30289 74 197 30233 30346 ICV_112 $T=929200 561645 1 0 $X=928770 $Y=557090
X3531 44 166 30415 265 74 278 228 30442 ICV_112 $T=935360 506765 1 0 $X=934930 $Y=502210
X3532 44 259 272 269 74 200 228 30581 ICV_112 $T=937040 491085 1 0 $X=936610 $Y=486530
X3533 44 30542 260 30844 74 30919 260 30544 ICV_112 $T=951040 585165 0 0 $X=950610 $Y=584775
X3534 44 31148 28751 32226 74 32284 207 32302 ICV_112 $T=996960 569485 1 0 $X=996530 $Y=564930
X3535 44 31148 32500 32585 74 32680 32585 32661 ICV_112 $T=1009280 569485 1 0 $X=1008850 $Y=564930
X3536 44 371 206 32808 74 32979 237 32968 ICV_112 $T=1019360 569485 1 0 $X=1018930 $Y=564930
X3537 44 31148 33119 33091 74 166 30582 33170 ICV_112 $T=1027200 577325 1 0 $X=1026770 $Y=572770
X3538 44 33131 33213 381 74 33272 33131 393 ICV_112 $T=1031120 522445 0 0 $X=1030690 $Y=522055
X3539 44 33030 33280 33152 74 166 33274 33328 ICV_112 $T=1037840 530285 0 0 $X=1037410 $Y=529895
X3540 44 33336 33362 33301 74 33406 33092 33336 ICV_112 $T=1037840 640045 0 0 $X=1037410 $Y=639655
X3541 44 166 32793 33454 74 186 405 33516 ICV_112 $T=1044560 561645 1 0 $X=1044130 $Y=557090
X3542 44 33586 33635 33608 74 186 410 33670 ICV_112 $T=1052400 553805 0 0 $X=1051970 $Y=553415
X3543 44 432 438 33616 74 197 32696 33975 ICV_112 $T=1069200 506765 1 0 $X=1068770 $Y=502210
X3544 44 34056 207 34366 74 34158 207 34420 ICV_112 $T=1086000 538125 0 0 $X=1085570 $Y=537735
X3545 44 83 37604 37479 74 97 29940 37646 ICV_112 $T=1212000 647885 1 0 $X=1211570 $Y=643330
X3546 24078 24039 74 44 23988 XOR2X1 $T=702400 655725 1 180 $X=695810 $Y=655335
X3547 24330 24701 74 44 25252 XOR2X1 $T=746640 616525 1 180 $X=740050 $Y=616135
X3548 25585 25478 74 44 25969 XOR2X1 $T=746080 663565 1 0 $X=745650 $Y=659010
X3549 25714 25548 74 44 26098 XOR2X1 $T=750560 647885 1 0 $X=750130 $Y=643330
X3550 25420 26207 74 44 26278 XOR2X1 $T=758960 640045 0 0 $X=758530 $Y=639655
X3551 24567 26609 74 44 26662 XOR2X1 $T=779120 647885 0 0 $X=778690 $Y=647495
X3552 26741 26363 74 44 26642 XOR2X1 $T=788080 694925 0 180 $X=781490 $Y=690370
X3553 26862 26840 74 44 24330 XOR2X1 $T=793680 616525 0 180 $X=787090 $Y=611970
X3554 26961 26792 74 44 26859 XOR2X1 $T=798720 671405 0 180 $X=792130 $Y=666850
X3555 122 119 74 44 27441 XOR2X1 $T=822800 687085 0 180 $X=816210 $Y=682530
X3556 124 121 74 44 24265 XOR2X1 $T=826160 600845 1 180 $X=819570 $Y=600455
X3557 127 123 74 44 128 XOR2X1 $T=837360 726285 0 180 $X=830770 $Y=721730
X3558 28036 126 74 44 27934 XOR2X1 $T=841840 647885 1 180 $X=835250 $Y=647495
X3559 27860 27625 74 44 28182 XOR2X1 $T=848560 687085 0 0 $X=848130 $Y=686695
X3560 28182 137 74 44 28456 XOR2X1 $T=853600 687085 1 0 $X=853170 $Y=682530
X3561 28524 113 74 44 27752 XOR2X1 $T=862000 679245 0 180 $X=855410 $Y=674690
X3562 152 151 74 44 24701 XOR2X1 $T=878240 640045 0 180 $X=871650 $Y=635490
X3563 154 26486 74 44 29251 XOR2X1 $T=877120 616525 0 0 $X=876690 $Y=616135
X3564 157 158 74 44 127 XOR2X1 $T=886080 679245 0 180 $X=879490 $Y=674690
X3565 168 171 74 44 28232 XOR2X1 $T=896720 694925 1 180 $X=890130 $Y=694535
X3566 29591 164 74 44 29468 XOR2X1 $T=897840 726285 0 180 $X=891250 $Y=721730
X3567 198 195 74 44 27860 XOR2X1 $T=906800 710605 1 180 $X=900210 $Y=710215
X3568 29847 165 74 44 29737 XOR2X1 $T=908480 718445 0 180 $X=901890 $Y=713890
X3569 29958 29940 74 44 24531 XOR2X1 $T=912960 624365 1 180 $X=906370 $Y=623975
X3570 30445 30501 74 44 27821 XOR2X1 $T=938720 632205 1 180 $X=932130 $Y=631815
X3571 266 26840 74 44 30545 XOR2X1 $T=933680 616525 0 0 $X=933250 $Y=616135
X3572 276 271 74 44 24752 XOR2X1 $T=940400 632205 0 180 $X=933810 $Y=627650
X3573 30532 195 74 44 281 XOR2X1 $T=935920 710605 1 0 $X=935490 $Y=706050
X3574 30555 113 74 44 286 XOR2X1 $T=939280 702765 0 0 $X=938850 $Y=702375
X3575 30636 158 74 44 30743 XOR2X1 $T=942640 624365 0 0 $X=942210 $Y=623975
X3576 30476 30501 74 44 30816 XOR2X1 $T=946000 632205 0 0 $X=945570 $Y=631815
X3577 30815 30843 74 44 24862 XOR2X1 $T=953840 608685 1 180 $X=947250 $Y=608295
X3578 30881 30922 74 44 28134 XOR2X1 $T=957200 679245 0 180 $X=950610 $Y=674690
X3579 30743 30816 74 44 30893 XOR2X1 $T=952160 640045 1 0 $X=951730 $Y=635490
X3580 304 307 74 44 314 XOR2X1 $T=953280 702765 0 0 $X=952850 $Y=702375
X3581 30978 26468 74 44 293 XOR2X1 $T=955520 702765 1 0 $X=955090 $Y=698210
X3582 315 121 74 44 31118 XOR2X1 $T=957760 608685 1 0 $X=957330 $Y=604130
X3583 31241 26468 74 44 333 XOR2X1 $T=963920 702765 1 0 $X=963490 $Y=698210
X3584 30816 31118 74 44 31493 XOR2X1 $T=971760 624365 0 0 $X=971330 $Y=623975
X3585 339 342 74 44 30821 XOR2X1 $T=976800 702765 0 0 $X=976370 $Y=702375
X3586 345 31803 74 44 31328 XOR2X1 $T=986880 608685 1 180 $X=980290 $Y=608295
X3587 32582 98 74 44 360 XOR2X1 $T=1007600 726285 1 0 $X=1007170 $Y=721730
X3588 32807 26555 74 44 32914 XOR2X1 $T=1016000 624365 1 0 $X=1015570 $Y=619810
X3589 32866 108 74 44 33241 XOR2X1 $T=1028320 624365 1 0 $X=1027890 $Y=619810
X3590 33579 33651 74 44 33441 XOR2X1 $T=1058000 671405 1 180 $X=1051410 $Y=671015
X3591 33710 419 74 44 33477 XOR2X1 $T=1059680 624365 0 180 $X=1053090 $Y=619810
X3592 435 33913 74 44 33092 XOR2X1 $T=1071440 632205 0 180 $X=1064850 $Y=627650
X3593 436 148 74 44 33228 XOR2X1 $T=1071440 640045 0 180 $X=1064850 $Y=635490
X3594 33660 33913 74 44 445 XOR2X1 $T=1073120 632205 1 0 $X=1072690 $Y=627650
X3595 441 271 74 44 34119 XOR2X1 $T=1073120 640045 1 0 $X=1072690 $Y=635490
X3596 34101 446 74 44 33387 XOR2X1 $T=1081520 647885 0 180 $X=1074930 $Y=643330
X3597 33959 148 74 44 34348 XOR2X1 $T=1081520 632205 1 0 $X=1081090 $Y=627650
X3598 34368 34369 74 44 33202 XOR2X1 $T=1089360 640045 1 180 $X=1082770 $Y=639655
X3599 34353 108 74 44 34481 XOR2X1 $T=1086560 608685 0 0 $X=1086130 $Y=608295
X3600 455 34369 74 44 456 XOR2X1 $T=1092160 671405 0 0 $X=1091730 $Y=671015
X3601 31542 458 74 44 34570 XOR2X1 $T=1101680 718445 1 180 $X=1095090 $Y=718055
X3602 33947 465 74 44 35984 XOR2X1 $T=1142560 655725 1 0 $X=1142130 $Y=651170
X3603 32344 35985 74 44 35829 XOR2X1 $T=1149840 671405 1 180 $X=1143250 $Y=671015
X3604 36159 470 74 44 35839 XOR2X1 $T=1156560 694925 1 180 $X=1149970 $Y=694535
X3605 33640 472 74 44 36351 XOR2X1 $T=1158240 694925 0 0 $X=1157810 $Y=694535
X3606 32261 36541 74 44 36383 XOR2X1 $T=1175600 624365 1 180 $X=1169010 $Y=623975
X3607 34743 36059 74 44 36565 XOR2X1 $T=1169440 655725 0 0 $X=1169010 $Y=655335
X3608 32245 36579 74 44 36675 XOR2X1 $T=1174480 647885 0 0 $X=1174050 $Y=647495
X3609 34251 30843 74 44 36950 XOR2X1 $T=1185120 608685 0 0 $X=1184690 $Y=608295
X3610 37982 37884 74 44 37799 XOR2X1 $T=1233840 624365 1 180 $X=1227250 $Y=623975
X3611 38024 37604 74 44 36660 XOR2X1 $T=1235520 640045 1 180 $X=1228930 $Y=639655
X3612 38025 37822 74 44 37766 XOR2X1 $T=1235520 647885 1 180 $X=1228930 $Y=647495
X3613 34481 38764 74 44 38892 XOR2X1 $T=1261840 616525 1 0 $X=1261410 $Y=611970
X3614 44 74 24192 24146 23986 ICV_96 $T=702400 624365 1 180 $X=699170 $Y=623975
X3615 44 74 83 25548 26049 ICV_96 $T=756160 655725 1 180 $X=752930 $Y=655335
X3616 44 74 27441 97 27426 ICV_96 $T=816080 671405 1 180 $X=812850 $Y=671015
X3617 44 74 27840 27766 27687 ICV_96 $T=832320 718445 1 180 $X=829090 $Y=718055
X3618 44 74 28175 140 27627 ICV_96 $T=848000 718445 1 180 $X=844770 $Y=718055
X3619 44 74 29619 29508 179 ICV_96 $T=898960 491085 0 180 $X=895730 $Y=486530
X3620 44 74 197 29879 30141 ICV_96 $T=921920 545965 0 180 $X=918690 $Y=541410
X3621 44 74 185 29689 30300 ICV_96 $T=929760 577325 0 180 $X=926530 $Y=572770
X3622 44 74 186 269 30717 ICV_96 $T=951040 545965 1 180 $X=947810 $Y=545575
X3623 44 74 370 354 368 ICV_96 $T=1021040 491085 0 180 $X=1017810 $Y=486530
X3624 44 74 33114 33103 33173 ICV_96 $T=1032800 663565 0 180 $X=1029570 $Y=659010
X3625 44 74 33272 33132 32628 ICV_96 $T=1037280 538125 1 180 $X=1034050 $Y=537735
X3626 44 74 166 28768 33338 ICV_96 $T=1041760 545965 1 180 $X=1038530 $Y=545575
X3627 44 74 159 28768 33394 ICV_96 $T=1043440 545965 0 180 $X=1040210 $Y=541410
X3628 44 74 33444 33275 33397 ICV_96 $T=1045680 632205 1 180 $X=1042450 $Y=631815
X3629 44 74 159 32500 33476 ICV_96 $T=1047920 538125 0 180 $X=1044690 $Y=533570
X3630 44 74 200 33370 33609 ICV_96 $T=1055200 577325 0 180 $X=1051970 $Y=572770
X3631 44 74 33682 33447 417 ICV_96 $T=1058000 514605 1 180 $X=1054770 $Y=514215
X3632 44 74 33681 31092 33680 ICV_96 $T=1058560 498925 0 180 $X=1055330 $Y=494370
X3633 44 74 33750 33579 33749 ICV_96 $T=1063040 640045 1 180 $X=1059810 $Y=639655
X3634 44 74 159 31557 429 ICV_96 $T=1065840 506765 1 180 $X=1062610 $Y=506375
X3635 44 74 33831 33486 32833 ICV_96 $T=1066400 514605 0 180 $X=1063170 $Y=510050
X3636 44 74 433 33823 33523 ICV_96 $T=1070320 514605 0 180 $X=1067090 $Y=510050
X3637 44 74 166 28267 33900 ICV_96 $T=1070880 491085 1 180 $X=1067650 $Y=490695
X3638 44 74 34041 221 33999 ICV_96 $T=1077040 561645 1 180 $X=1073810 $Y=561255
X3639 44 74 34056 184 34317 ICV_96 $T=1088240 553805 0 180 $X=1085010 $Y=549250
X3640 44 74 35829 97 35813 ICV_96 $T=1142560 671405 1 180 $X=1139330 $Y=671015
X3641 44 74 38637 34119 38591 ICV_96 $T=1256800 655725 1 180 $X=1253570 $Y=655335
X3642 44 74 39028 38914 38967 ICV_96 $T=1269680 624365 1 180 $X=1266450 $Y=623975
X3643 44 74 36950 34481 39423 ICV_96 $T=1280880 616525 1 180 $X=1277650 $Y=616135
X3644 44 74 24196 24418 24352 ICV_94 $T=706880 624365 0 0 $X=706450 $Y=623975
X3645 44 74 24961 24777 25322 ICV_94 $T=729280 608685 0 0 $X=728850 $Y=608295
X3646 44 74 87 26177 26157 ICV_94 $T=755600 726285 0 0 $X=755170 $Y=725895
X3647 44 74 83 98 26357 ICV_94 $T=773520 663565 1 0 $X=773090 $Y=659010
X3648 44 74 28139 27802 28088 ICV_94 $T=844080 694925 0 0 $X=843650 $Y=694535
X3649 44 74 159 28827 29426 ICV_94 $T=887200 514605 0 0 $X=886770 $Y=514215
X3650 44 74 29323 30000 219 ICV_94 $T=910160 498925 0 0 $X=909730 $Y=498535
X3651 44 74 218 196 29985 ICV_94 $T=910160 522445 1 0 $X=909730 $Y=517890
X3652 44 74 30412 284 30570 ICV_94 $T=939840 491085 0 0 $X=939410 $Y=490695
X3653 44 74 30958 30936 30778 ICV_94 $T=954960 514605 0 0 $X=954530 $Y=514215
X3654 44 74 311 286 31180 ICV_94 $T=962240 710605 1 0 $X=961810 $Y=706050
X3655 44 74 31328 31075 31747 ICV_94 $T=980720 647885 0 0 $X=980290 $Y=647495
X3656 44 74 33030 33158 33066 ICV_94 $T=1032240 569485 1 0 $X=1031810 $Y=564930
X3657 44 74 318 33348 33254 ICV_94 $T=1035600 498925 1 0 $X=1035170 $Y=494370
X3658 44 74 33465 33092 33582 ICV_94 $T=1049600 640045 1 0 $X=1049170 $Y=635490
X3659 44 74 33455 34354 34335 ICV_94 $T=1083760 687085 1 0 $X=1083330 $Y=682530
X3660 44 74 81 33978 34370 ICV_94 $T=1088800 687085 0 0 $X=1088370 $Y=686695
X3661 44 74 83 465 36089 ICV_94 $T=1149840 671405 0 0 $X=1149410 $Y=671015
X3662 44 74 34348 39629 39494 ICV_94 $T=1282000 655725 1 0 $X=1281570 $Y=651170
X3663 44 74 24752 24265 24386 ICV_101 $T=711920 632205 1 0 $X=711490 $Y=627650
X3664 44 74 24777 25062 24962 ICV_101 $T=725360 593005 0 0 $X=724930 $Y=592615
X3665 44 74 25385 25101 25386 ICV_101 $T=730960 632205 0 0 $X=730530 $Y=631815
X3666 44 74 90 26218 26232 ICV_101 $T=757840 647885 0 0 $X=757410 $Y=647495
X3667 44 74 90 27903 146 ICV_101 $T=849680 655725 1 0 $X=849250 $Y=651170
X3668 44 74 159 28354 29423 ICV_101 $T=886640 530285 0 0 $X=886210 $Y=529895
X3669 44 74 159 29294 29712 ICV_101 $T=897840 569485 0 0 $X=897410 $Y=569095
X3670 44 74 286 30684 297 ICV_101 $T=946000 710605 0 0 $X=945570 $Y=710215
X3671 44 74 217 288 30837 ICV_101 $T=948800 538125 0 0 $X=948370 $Y=537735
X3672 44 74 31359 293 31509 ICV_101 $T=972880 710605 1 0 $X=972450 $Y=706050
X3673 44 74 31888 31493 31993 ICV_101 $T=988000 616525 1 0 $X=987570 $Y=611970
X3674 44 74 32629 29347 32303 ICV_101 $T=1008160 569485 0 0 $X=1007730 $Y=569095
X3675 44 74 32829 32792 32807 ICV_101 $T=1014880 553805 0 0 $X=1014450 $Y=553415
X3676 44 74 33128 33055 32999 ICV_101 $T=1025520 498925 0 0 $X=1025090 $Y=498535
X3677 44 74 166 31859 33132 ICV_101 $T=1026080 545965 0 0 $X=1025650 $Y=545575
X3678 44 74 33228 33202 33063 ICV_101 $T=1029440 655725 1 0 $X=1029010 $Y=651170
X3679 44 74 33519 33517 33524 ICV_101 $T=1045680 577325 0 0 $X=1045250 $Y=576935
X3680 44 74 159 33672 33682 ICV_101 $T=1066400 522445 0 0 $X=1065970 $Y=522055
X3681 44 74 34615 34547 34686 ICV_101 $T=1096080 608685 0 0 $X=1095650 $Y=608295
X3682 44 74 79 33978 34683 ICV_101 $T=1096080 679245 1 0 $X=1095650 $Y=674690
X3683 44 74 38298 38449 38721 ICV_101 $T=1255120 585165 1 0 $X=1254690 $Y=580610
X3684 44 74 38695 38564 38991 ICV_101 $T=1264080 545965 0 0 $X=1263650 $Y=545575
X3685 44 74 38991 38789 39031 ICV_101 $T=1265200 553805 1 0 $X=1264770 $Y=549250
X3717 44 74 24674 24473 24632 ICV_79 $T=714720 663565 0 180 $X=711490 $Y=659010
X3718 44 74 78 75 25784 ICV_79 $T=748320 718445 0 180 $X=745090 $Y=713890
X3719 44 74 78 76 25902 ICV_79 $T=751120 718445 1 180 $X=747890 $Y=718055
X3720 44 74 84 25828 85 ICV_79 $T=756160 718445 1 180 $X=752930 $Y=718055
X3721 44 74 83 26363 26392 ICV_79 $T=770160 679245 0 180 $X=766930 $Y=674690
X3722 44 74 83 26609 26788 ICV_79 $T=790880 663565 1 180 $X=787650 $Y=663175
X3723 44 74 97 26840 26780 ICV_79 $T=797040 655725 0 180 $X=793810 $Y=651170
X3724 44 74 79 27659 28166 ICV_79 $T=848000 616525 0 180 $X=844770 $Y=611970
X3725 44 74 81 27714 28304 ICV_79 $T=854720 608685 0 180 $X=851490 $Y=604130
X3726 44 74 97 153 29105 ICV_79 $T=879360 726285 0 180 $X=876130 $Y=721730
X3727 44 74 29335 29457 167 ICV_79 $T=893360 506765 1 180 $X=890130 $Y=506375
X3728 44 74 166 28784 169 ICV_79 $T=895600 522445 1 180 $X=892370 $Y=522055
X3729 44 74 81 28573 29739 ICV_79 $T=904000 624365 0 180 $X=900770 $Y=619810
X3730 44 74 29879 200 29743 ICV_79 $T=910160 553805 0 180 $X=906930 $Y=549250
X3731 44 74 30070 216 30049 ICV_79 $T=918000 585165 1 180 $X=914770 $Y=584775
X3732 44 74 197 228 30120 ICV_79 $T=920800 538125 1 180 $X=917570 $Y=537735
X3733 44 74 90 29845 238 ICV_79 $T=921920 718445 1 180 $X=918690 $Y=718055
X3734 44 74 30164 221 29658 ICV_79 $T=922480 577325 1 180 $X=919250 $Y=576935
X3735 44 74 244 30094 30137 ICV_79 $T=924720 553805 0 180 $X=921490 $Y=549250
X3736 44 74 79 30099 30128 ICV_79 $T=924720 663565 1 180 $X=921490 $Y=663175
X3737 44 74 244 29656 30230 ICV_79 $T=926400 506765 1 180 $X=923170 $Y=506375
X3738 44 74 185 30098 30248 ICV_79 $T=926960 561645 0 180 $X=923730 $Y=557090
X3739 44 74 172 169 30188 ICV_79 $T=928080 514605 1 180 $X=924850 $Y=514215
X3740 44 74 166 29859 30232 ICV_79 $T=928640 514605 0 180 $X=925410 $Y=510050
X3741 44 74 217 30053 30459 ICV_79 $T=936480 530285 1 180 $X=933250 $Y=529895
X3742 44 74 30529 29878 30400 ICV_79 $T=939840 522445 1 180 $X=936610 $Y=522055
X3743 44 74 217 275 30552 ICV_79 $T=941520 530285 1 180 $X=938290 $Y=529895
X3744 44 74 30624 237 30600 ICV_79 $T=943760 577325 1 180 $X=940530 $Y=576935
X3745 44 74 31067 30893 31053 ICV_79 $T=962800 640045 1 180 $X=959570 $Y=639655
X3746 44 74 31165 31119 31150 ICV_79 $T=966160 616525 0 180 $X=962930 $Y=611970
X3747 44 74 31996 32118 32115 ICV_79 $T=997520 671405 0 180 $X=994290 $Y=666850
X3748 44 74 352 335 32435 ICV_79 $T=1007040 514605 0 180 $X=1003810 $Y=510050
X3749 44 74 81 31196 32286 ICV_79 $T=1007040 679245 1 180 $X=1003810 $Y=678855
X3750 44 74 32629 28125 32649 ICV_79 $T=1014320 577325 1 180 $X=1011090 $Y=576935
X3751 44 74 33105 33047 33094 ICV_79 $T=1031120 553805 0 180 $X=1027890 $Y=549250
X3752 44 74 33199 33174 33188 ICV_79 $T=1033360 679245 0 180 $X=1030130 $Y=674690
X3753 44 74 33226 33170 33348 ICV_79 $T=1041200 538125 1 180 $X=1037970 $Y=537735
X3754 44 74 425 33729 424 ICV_79 $T=1061920 491085 0 180 $X=1058690 $Y=486530
X3755 44 74 33386 33214 428 ICV_79 $T=1064720 553805 0 180 $X=1061490 $Y=549250
X3756 44 74 33832 273 33734 ICV_79 $T=1066400 585165 1 180 $X=1063170 $Y=584775
X3757 44 74 33865 260 33869 ICV_79 $T=1068640 585165 0 180 $X=1065410 $Y=580610
X3758 44 74 33954 221 33719 ICV_79 $T=1074240 577325 1 180 $X=1071010 $Y=576935
X3759 44 74 33819 33900 33996 ICV_79 $T=1075920 498925 0 180 $X=1072690 $Y=494370
X3760 44 74 34041 216 34042 ICV_79 $T=1077600 569485 0 180 $X=1074370 $Y=564930
X3761 44 74 218 447 34142 ICV_79 $T=1083200 491085 0 180 $X=1079970 $Y=486530
X3762 44 74 244 34175 34347 ICV_79 $T=1088800 545965 0 180 $X=1085570 $Y=541410
X3763 44 74 33520 184 34460 ICV_79 $T=1093280 561645 0 180 $X=1090050 $Y=557090
X3764 44 74 81 34641 35238 ICV_79 $T=1118480 687085 1 180 $X=1115250 $Y=686695
X3765 44 74 90 37257 37361 ICV_79 $T=1205840 616525 1 180 $X=1202610 $Y=616135
X3766 44 74 37580 37481 37555 ICV_79 $T=1213680 710605 0 180 $X=1210450 $Y=706050
X3767 44 74 81 36275 37686 ICV_79 $T=1219840 585165 1 180 $X=1216610 $Y=584775
X3768 44 74 37800 37616 37785 ICV_79 $T=1226000 710605 0 180 $X=1222770 $Y=706050
X3769 44 74 79 36759 37784 ICV_79 $T=1226560 545965 1 180 $X=1223330 $Y=545575
X3770 44 74 81 37797 38023 ICV_79 $T=1236080 514605 0 180 $X=1232850 $Y=510050
X3771 44 74 38292 38007 38351 ICV_79 $T=1247280 538125 0 180 $X=1244050 $Y=533570
X3772 44 74 38392 38007 38280 ICV_79 $T=1247840 530285 0 180 $X=1244610 $Y=525730
X3773 44 74 38361 38190 38298 ICV_79 $T=1248960 585165 0 180 $X=1245730 $Y=580610
X3774 44 74 38733 38517 38822 ICV_79 $T=1263520 561645 1 180 $X=1260290 $Y=561255
X3775 44 74 39276 39089 39262 ICV_79 $T=1276400 608685 0 180 $X=1273170 $Y=604130
X3776 44 74 24154 24777 24751 ICV_109 $T=715840 593005 0 0 $X=715410 $Y=592615
X3777 44 74 25967 26011 25994 ICV_109 $T=751120 498925 0 0 $X=750690 $Y=498535
X3778 44 74 26815 26843 26832 ICV_109 $T=790320 561645 1 0 $X=789890 $Y=557090
X3779 44 74 83 158 29442 ICV_109 $T=889440 710605 0 0 $X=889010 $Y=710215
X3780 44 74 29572 29508 29678 ICV_109 $T=898960 498925 0 0 $X=898530 $Y=498535
X3781 44 74 81 29791 29663 ICV_109 $T=902880 624365 0 0 $X=902450 $Y=623975
X3782 44 74 186 192 29803 ICV_109 $T=903440 553805 1 0 $X=903010 $Y=549250
X3783 44 74 29710 30039 224 ICV_109 $T=913520 491085 0 0 $X=913090 $Y=490695
X3784 44 74 218 30053 180 ICV_109 $T=914080 522445 0 0 $X=913650 $Y=522055
X3785 44 74 30276 237 30347 ICV_109 $T=930880 577325 0 0 $X=930450 $Y=576935
X3786 44 74 30448 30546 30609 ICV_109 $T=940960 679245 1 0 $X=940530 $Y=674690
X3787 44 74 197 30606 30650 ICV_109 $T=944880 553805 0 0 $X=944450 $Y=553415
X3788 44 74 185 30335 30753 ICV_109 $T=948800 553805 0 0 $X=948370 $Y=553415
X3789 44 74 219 30894 302 ICV_109 $T=952720 498925 1 0 $X=952290 $Y=494370
X3790 44 74 30920 31029 31012 ICV_109 $T=958320 616525 0 0 $X=957890 $Y=616135
X3791 44 74 31306 334 31190 ICV_109 $T=969520 491085 0 0 $X=969090 $Y=490695
X3792 44 74 31066 31400 31379 ICV_109 $T=971200 647885 0 0 $X=970770 $Y=647495
X3793 44 74 32378 28033 32521 ICV_109 $T=1007600 577325 0 0 $X=1007170 $Y=576935
X3794 44 74 244 32846 32828 ICV_109 $T=1017680 545965 1 0 $X=1017250 $Y=541410
X3795 44 74 33031 221 33079 ICV_109 $T=1028320 585165 1 0 $X=1027890 $Y=580610
X3796 44 74 217 384 33169 ICV_109 $T=1030000 514605 0 0 $X=1029570 $Y=514215
X3797 44 74 33226 33132 387 ICV_109 $T=1032800 538125 1 0 $X=1032370 $Y=533570
X3798 44 74 32378 33243 33345 ICV_109 $T=1037280 577325 1 0 $X=1036850 $Y=572770
X3799 44 74 33328 33344 369 ICV_109 $T=1037840 530285 1 0 $X=1037410 $Y=525730
X3800 44 74 33306 32865 33360 ICV_109 $T=1038400 491085 1 0 $X=1037970 $Y=486530
X3801 44 74 33344 33369 377 ICV_109 $T=1038400 522445 0 0 $X=1037970 $Y=522055
X3802 44 74 33228 33092 33361 ICV_109 $T=1038400 640045 1 0 $X=1037970 $Y=635490
X3803 44 74 159 33416 33226 ICV_109 $T=1041200 538125 1 0 $X=1040770 $Y=533570
X3804 44 74 159 33316 33213 ICV_109 $T=1041760 530285 1 0 $X=1041330 $Y=525730
X3805 44 74 318 403 33435 ICV_109 $T=1042320 491085 1 0 $X=1041890 $Y=486530
X3806 44 74 33465 33489 33317 ICV_109 $T=1045120 671405 0 0 $X=1044690 $Y=671015
X3807 44 74 33227 260 33521 ICV_109 $T=1047920 585165 0 0 $X=1047490 $Y=584775
X3808 44 74 166 33273 33542 ICV_109 $T=1050160 553805 1 0 $X=1049730 $Y=549250
X3809 44 74 33577 33602 33591 ICV_109 $T=1051280 522445 0 0 $X=1050850 $Y=522055
X3810 44 74 185 408 33671 ICV_109 $T=1054640 561645 0 0 $X=1054210 $Y=561255
X3811 44 74 33683 33386 33785 ICV_109 $T=1063040 545965 1 0 $X=1062610 $Y=541410
X3812 44 74 33770 33313 33857 ICV_109 $T=1065280 679245 0 0 $X=1064850 $Y=678855
X3813 44 74 34025 33997 444 ICV_109 $T=1074800 491085 0 0 $X=1074370 $Y=490695
X3814 44 74 186 33693 34057 ICV_109 $T=1075360 545965 1 0 $X=1074930 $Y=541410
X3815 44 74 33832 184 34116 ICV_109 $T=1077600 538125 1 0 $X=1077170 $Y=533570
X3816 44 74 34099 34231 34220 ICV_109 $T=1081520 522445 0 0 $X=1081090 $Y=522055
X3817 44 74 90 37710 37674 ICV_109 $T=1219840 616525 0 0 $X=1219410 $Y=616135
X3818 44 74 37784 37820 37798 ICV_109 $T=1223760 514605 1 0 $X=1223330 $Y=510050
X3819 44 74 24196 24701 24589 ICV_105 $T=716400 616525 1 0 $X=715970 $Y=611970
X3820 44 74 24862 24531 25643 ICV_105 $T=737680 624365 0 0 $X=737250 $Y=623975
X3821 44 74 90 26217 26146 ICV_105 $T=756720 608685 0 0 $X=756290 $Y=608295
X3822 44 74 81 26454 26717 ICV_105 $T=783040 538125 1 0 $X=782610 $Y=533570
X3823 44 74 81 27000 26843 ICV_105 $T=796480 561645 0 0 $X=796050 $Y=561255
X3824 44 74 90 27425 27445 ICV_105 $T=810480 640045 1 0 $X=810050 $Y=635490
X3825 44 74 159 161 29335 ICV_105 $T=881600 506765 1 0 $X=881170 $Y=502210
X3826 44 74 166 161 29422 ICV_105 $T=885520 514605 1 0 $X=885090 $Y=510050
X3827 44 74 29549 29520 26862 ICV_105 $T=890000 538125 0 0 $X=889570 $Y=537735
X3828 44 74 30159 221 30150 ICV_105 $T=916320 577325 1 0 $X=915890 $Y=572770
X3829 44 74 159 251 29619 ICV_105 $T=923600 498925 1 0 $X=923170 $Y=494370
X3830 44 74 309 321 31418 ICV_105 $T=968960 726285 0 0 $X=968530 $Y=725895
X3831 44 74 31507 31418 31495 ICV_105 $T=971200 718445 0 0 $X=970770 $Y=718055
X3832 44 74 33254 32865 33128 ICV_105 $T=1029440 498925 1 0 $X=1029010 $Y=494370
X3833 44 74 166 32795 401 ICV_105 $T=1038960 506765 0 0 $X=1038530 $Y=506375
X3834 44 74 186 403 33767 ICV_105 $T=1057440 491085 0 0 $X=1057010 $Y=490695
X3835 44 74 166 31557 432 ICV_105 $T=1061360 506765 1 0 $X=1060930 $Y=502210
X3836 44 74 79 35295 36218 ICV_105 $T=1153200 624365 1 0 $X=1152770 $Y=619810
X3837 44 74 37388 37278 488 ICV_105 $T=1200240 491085 0 0 $X=1199810 $Y=490695
X3838 44 74 38082 37992 38245 ICV_105 $T=1237200 710605 0 0 $X=1236770 $Y=710215
X3839 44 74 38452 36565 38418 ICV_105 $T=1243920 647885 1 0 $X=1243490 $Y=643330
X3840 44 74 81 37883 38485 ICV_105 $T=1245600 593005 0 0 $X=1245170 $Y=592615
X3841 44 74 38666 38485 38655 ICV_105 $T=1251760 593005 0 0 $X=1251330 $Y=592615
X3862 44 74 25829 25783 579 578 ICV_111 $T=723120 702765 1 0 $X=722690 $Y=698210
X3863 44 74 26484 26464 579 103 ICV_111 $T=762320 498925 0 0 $X=761890 $Y=498535
X3864 44 74 27696 27671 579 27325 ICV_111 $T=813840 632205 0 0 $X=813410 $Y=631815
X3865 44 74 27763 27670 579 27647 ICV_111 $T=815520 522445 1 0 $X=815090 $Y=517890
X3866 44 74 28124 28034 579 27617 ICV_111 $T=830640 561645 0 0 $X=830210 $Y=561255
X3867 44 74 28868 28725 579 28698 ICV_111 $T=864800 561645 0 0 $X=864370 $Y=561255
X3868 44 74 29347 29249 579 28698 ICV_111 $T=873200 600845 1 0 $X=872770 $Y=596290
X3869 44 74 29929 29843 579 28698 ICV_111 $T=897280 593005 0 0 $X=896850 $Y=592615
X3870 44 74 30246 30222 579 581 ICV_111 $T=912960 718445 1 0 $X=912530 $Y=713890
X3871 44 74 33978 34349 579 449 ICV_111 $T=1087120 694925 1 0 $X=1086690 $Y=690370
X3872 44 74 35309 35193 579 35822 ICV_111 $T=1111760 640045 1 0 $X=1111330 $Y=635490
X3873 44 74 30922 35764 579 35562 ICV_111 $T=1128000 694925 1 0 $X=1127570 $Y=690370
X3874 44 74 476 36637 579 469 ICV_111 $T=1166640 726285 1 0 $X=1166210 $Y=721730
X3875 44 74 30501 36714 579 35562 ICV_111 $T=1167200 647885 1 0 $X=1166770 $Y=643330
X3876 44 74 477 36665 579 469 ICV_111 $T=1167200 718445 0 0 $X=1166770 $Y=718055
X3877 44 74 37676 37555 579 37414 ICV_111 $T=1201360 718445 0 0 $X=1200930 $Y=718055
X3878 44 74 37710 37696 579 36707 ICV_111 $T=1209200 530285 0 0 $X=1208770 $Y=529895
X3879 44 74 37945 38008 579 37292 ICV_111 $T=1220400 561645 0 0 $X=1219970 $Y=561255
X3880 44 74 77 26157 579 578 ICV_113 $T=748320 726285 0 180 $X=722690 $Y=721730
X3881 44 74 26444 26739 579 27647 ICV_113 $T=799840 522445 1 180 $X=774210 $Y=522055
X3882 44 74 26947 27674 579 27617 ICV_113 $T=822240 561645 0 180 $X=796610 $Y=557090
X3883 44 74 28245 28681 579 29115 ICV_113 $T=875440 663565 1 180 $X=849810 $Y=663175
X3884 44 74 30299 31323 579 308 ICV_113 $T=970640 694925 1 180 $X=945010 $Y=694535
X3885 44 74 31196 32304 579 359 ICV_113 $T=1012640 679245 0 180 $X=987010 $Y=674690
X3886 44 74 33672 33987 579 33622 ICV_113 $T=1081520 593005 1 180 $X=1055890 $Y=592615
X3887 44 74 34641 35371 579 35562 ICV_113 $T=1131360 694925 1 180 $X=1105730 $Y=694535
X3888 44 74 31195 35451 579 36395 ICV_113 $T=1134160 593005 1 180 $X=1108530 $Y=592615
X3889 44 74 457 35661 579 467 ICV_113 $T=1143680 561645 1 180 $X=1118050 $Y=561255
X3890 44 74 31327 35801 579 467 ICV_113 $T=1149840 553805 0 180 $X=1124210 $Y=549250
X3891 44 74 35811 36407 579 36707 ICV_113 $T=1181200 530285 0 180 $X=1155570 $Y=525730
X3892 44 74 35591 36602 579 37292 ICV_113 $T=1187920 608685 0 180 $X=1162290 $Y=604130
X3893 44 74 35431 37026 579 37292 ICV_113 $T=1192400 585165 1 180 $X=1166770 $Y=584775
X3894 44 74 34369 37062 579 37414 ICV_113 $T=1202480 663565 1 180 $X=1176850 $Y=663175
X3895 44 74 36759 37259 579 37292 ICV_113 $T=1208640 561645 1 180 $X=1183010 $Y=561255
X3896 44 74 36447 37392 579 492 ICV_113 $T=1219840 553805 0 180 $X=1194210 $Y=549250
X3897 44 74 37436 37711 579 37414 ICV_113 $T=1232160 608685 1 180 $X=1206530 $Y=608295
X4039 44 74 25253 25084 25323 25339 ICV_97 $T=729280 624365 0 0 $X=728850 $Y=623975
X4040 44 74 25460 25652 25661 25643 ICV_97 $T=739920 624365 1 0 $X=739490 $Y=619810
X4041 44 74 26392 26588 26605 26604 ICV_97 $T=776880 671405 0 0 $X=776450 $Y=671015
X4042 44 74 128 27892 27944 27752 ICV_97 $T=834560 702765 1 0 $X=834130 $Y=698210
X4043 44 74 28377 26248 147 28611 ICV_97 $T=859200 671405 1 0 $X=858770 $Y=666850
X4044 44 74 29834 220 30028 30036 ICV_97 $T=911280 545965 0 0 $X=910850 $Y=545575
X4045 44 74 31166 31206 31061 31239 ICV_97 $T=963920 632205 0 0 $X=963490 $Y=631815
X4046 44 74 31470 31307 31542 31469 ICV_97 $T=974000 671405 0 0 $X=973570 $Y=671015
X4047 44 74 31578 31207 31944 31400 ICV_97 $T=986320 647885 1 0 $X=985890 $Y=643330
X4048 44 74 31909 31952 31973 31798 ICV_97 $T=987440 655725 0 0 $X=987010 $Y=655335
X4049 44 74 32414 32587 32613 32627 ICV_97 $T=1008160 522445 1 0 $X=1007730 $Y=517890
X4050 44 74 33513 33475 33556 33566 ICV_97 $T=1047360 506765 1 0 $X=1046930 $Y=502210
X4051 44 74 33387 33329 33362 33228 ICV_97 $T=1047360 640045 0 0 $X=1046930 $Y=639655
X4052 44 74 290 33554 33639 33649 ICV_97 $T=1051280 530285 0 0 $X=1050850 $Y=529895
X4053 44 74 33911 33712 33947 33921 ICV_97 $T=1068640 647885 0 0 $X=1068210 $Y=647495
X4054 44 74 33883 33945 33976 33887 ICV_97 $T=1069760 545965 1 0 $X=1069330 $Y=541410
X4055 44 74 39357 39408 39234 39423 ICV_97 $T=1276400 632205 0 0 $X=1275970 $Y=631815
X4056 44 74 25156 24039 25366 ICV_99 $T=729280 655725 0 0 $X=728850 $Y=655335
X4057 44 74 90 26484 26475 ICV_99 $T=768480 616525 1 0 $X=768050 $Y=611970
X4058 44 74 26665 26683 26673 ICV_99 $T=779120 585165 1 0 $X=778690 $Y=580610
X4059 44 74 83 108 26866 ICV_99 $T=788640 624365 0 0 $X=788210 $Y=623975
X4060 44 74 79 27000 26665 ICV_99 $T=794240 585165 1 0 $X=793810 $Y=580610
X4061 44 74 79 112 27439 ICV_99 $T=810480 538125 0 0 $X=810050 $Y=537735
X4062 44 74 83 121 27416 ICV_99 $T=816640 640045 1 0 $X=816210 $Y=635490
X4063 44 74 159 28123 29323 ICV_99 $T=881040 498925 1 0 $X=880610 $Y=494370
X4064 44 74 90 30061 225 ICV_99 $T=911280 726285 1 0 $X=910850 $Y=721730
X4065 44 74 90 30191 243 ICV_99 $T=917440 726285 1 0 $X=917010 $Y=721730
X4066 44 74 287 267 30854 ICV_99 $T=948240 498925 0 0 $X=947810 $Y=498535
X4067 44 74 306 312 30791 ICV_99 $T=950480 726285 1 0 $X=950050 $Y=721730
X4068 44 74 31066 31207 31206 ICV_99 $T=962240 624365 0 0 $X=961810 $Y=623975
X4069 44 74 30052 335 31322 ICV_99 $T=967280 506765 0 0 $X=966850 $Y=506375
X4070 44 74 33747 33313 33673 ICV_99 $T=1057440 687085 1 0 $X=1057010 $Y=682530
X4071 44 74 78 505 38191 ICV_99 $T=1241120 718445 0 0 $X=1240690 $Y=718055
X4072 44 74 79 506 38666 ICV_99 $T=1257920 593005 0 0 $X=1257490 $Y=592615
X4073 44 74 39090 38521 39105 ICV_99 $T=1266320 663565 0 0 $X=1265890 $Y=663175
X4074 44 74 25494 25541 25567 25438 ICV_100 $T=734880 647885 1 0 $X=734450 $Y=643330
X4075 44 74 26049 26110 26123 26146 ICV_100 $T=752240 663565 1 0 $X=751810 $Y=659010
X4076 44 74 27546 27579 27423 27604 ICV_100 $T=816640 702765 0 0 $X=816210 $Y=702375
X4077 44 74 29617 29743 29761 29657 ICV_100 $T=898400 553805 0 0 $X=897970 $Y=553415
X4078 44 74 30027 30226 30245 246 ICV_100 $T=920240 538125 1 0 $X=919810 $Y=533570
X4079 44 74 30289 252 30338 30346 ICV_100 $T=924720 553805 0 0 $X=924290 $Y=553415
X4080 44 74 30347 30187 30398 30413 ICV_100 $T=927520 593005 1 0 $X=927090 $Y=588450
X4081 44 74 31240 31328 31439 31400 ICV_100 $T=970080 655725 1 0 $X=969650 $Y=651170
X4082 44 74 31639 31451 31833 29251 ICV_100 $T=981840 624365 0 0 $X=981410 $Y=623975
X4083 44 74 31287 31951 31952 31782 ICV_100 $T=985760 655725 1 0 $X=985330 $Y=651170
X4084 44 74 32047 31944 32081 32076 ICV_100 $T=990800 647885 1 0 $X=990370 $Y=643330
X4085 44 74 32319 32458 32487 32520 ICV_100 $T=1002560 585165 1 0 $X=1002130 $Y=580610
X4086 44 74 33276 33310 33325 33173 ICV_100 $T=1032800 663565 0 0 $X=1032370 $Y=663175
X4087 44 74 33141 33115 33346 33228 ICV_100 $T=1033920 632205 0 0 $X=1033490 $Y=631815
X4088 44 74 33611 33617 33660 33504 ICV_100 $T=1050720 593005 1 0 $X=1050290 $Y=588450
X4089 44 74 33690 33521 33610 33734 ICV_100 $T=1054640 585165 0 0 $X=1054210 $Y=584775
X4090 44 74 38892 38601 39089 32914 ICV_100 $T=1265200 608685 1 0 $X=1264770 $Y=604130
X4091 44 74 24701 24265 24330 25384 ICV_107 $T=736000 608685 0 0 $X=735570 $Y=608295
X4092 44 74 94 26066 26619 26617 ICV_107 $T=779120 561645 1 0 $X=778690 $Y=557090
X4093 44 74 94 27764 27044 27672 ICV_107 $T=822800 640045 1 0 $X=822370 $Y=635490
X4094 44 74 94 28201 28137 28107 ICV_107 $T=842400 655725 1 0 $X=841970 $Y=651170
X4095 44 74 94 28726 28245 28681 ICV_107 $T=863680 655725 1 0 $X=863250 $Y=651170
X4096 44 74 135 29348 29281 29250 ICV_107 $T=881040 608685 0 0 $X=880610 $Y=608295
X4097 44 74 86 29281 28573 29307 ICV_107 $T=883280 616525 0 0 $X=882850 $Y=616135
X4098 44 74 94 29467 29003 29374 ICV_107 $T=886080 679245 1 0 $X=885650 $Y=674690
X4099 44 74 135 29825 29679 30143 ICV_107 $T=918560 616525 0 0 $X=918130 $Y=616135
X4100 44 74 212 232 30201 30070 ICV_107 $T=920240 569485 1 0 $X=919810 $Y=564930
X4101 44 74 212 29711 30094 30508 ICV_107 $T=939840 545965 1 0 $X=939410 $Y=541410
X4102 44 74 86 32285 31031 32155 ICV_107 $T=994720 687085 1 0 $X=994290 $Y=682530
X4103 44 74 212 396 377 32438 ICV_107 $T=1034480 498925 0 0 $X=1034050 $Y=498535
X4104 44 74 212 34175 34053 33875 ICV_107 $T=1075360 553805 1 0 $X=1074930 $Y=549250
X4105 44 74 94 35773 36205 36175 ICV_107 $T=1154320 561645 1 0 $X=1153890 $Y=557090
X4106 44 74 80 36059 474 36308 ICV_107 $T=1159920 718445 0 0 $X=1159490 $Y=718055
X4107 44 74 80 34369 477 36665 ICV_107 $T=1177840 710605 0 0 $X=1177410 $Y=710215
X4108 44 74 80 31803 478 36676 ICV_107 $T=1178400 694925 0 0 $X=1177970 $Y=694535
X4109 44 74 80 36541 37243 37210 ICV_107 $T=1196320 663565 1 0 $X=1195890 $Y=659010
X4110 44 74 37945 79 81 38008 ICV_107 $T=1232160 553805 0 0 $X=1231730 $Y=553415
X4189 44 74 25915 25994 579 103 ICV_80 $T=753360 491085 0 0 $X=752930 $Y=490695
X4190 44 74 25992 25968 579 103 ICV_80 $T=753360 506765 0 0 $X=752930 $Y=506375
X4191 44 74 26066 25952 579 103 ICV_80 $T=753360 514605 0 0 $X=752930 $Y=514215
X4192 44 74 26085 26282 579 26480 ICV_80 $T=753360 530285 0 0 $X=752930 $Y=529895
X4193 44 74 26285 26256 579 26480 ICV_80 $T=753360 577325 1 0 $X=752930 $Y=572770
X4194 44 74 26217 26362 579 26480 ICV_80 $T=753360 577325 0 0 $X=752930 $Y=576935
X4195 44 74 26067 25953 579 26480 ICV_80 $T=753360 585165 1 0 $X=752930 $Y=580610
X4196 44 74 26174 26147 579 27182 ICV_80 $T=753360 687085 1 0 $X=752930 $Y=682530
X4197 44 74 26327 26516 579 27182 ICV_80 $T=758960 694925 0 0 $X=758530 $Y=694535
X4198 44 74 26699 26625 579 27617 ICV_80 $T=771280 608685 1 0 $X=770850 $Y=604130
X4199 44 74 28267 28190 579 130 ICV_80 $T=833440 506765 0 0 $X=833010 $Y=506375
X4200 44 74 28784 28646 579 28698 ICV_80 $T=860880 553805 0 0 $X=860450 $Y=553415
X4201 44 74 29281 29307 579 28698 ICV_80 $T=872640 632205 1 0 $X=872210 $Y=627650
X4202 44 74 31859 31729 579 33622 ICV_80 $T=975680 600845 0 0 $X=975250 $Y=600455
X4203 44 74 31840 31911 579 308 ICV_80 $T=986320 694925 0 0 $X=985890 $Y=694535
X4204 44 74 348 32417 579 308 ICV_80 $T=989120 718445 1 0 $X=988690 $Y=713890
X4205 44 74 33106 32810 579 359 ICV_80 $T=1019920 687085 1 0 $X=1019490 $Y=682530
X4206 44 74 35207 35125 579 449 ICV_80 $T=1103920 702765 0 0 $X=1103490 $Y=702375
X4207 44 74 35276 35310 579 449 ICV_80 $T=1103920 718445 1 0 $X=1103490 $Y=713890
X4208 44 74 35295 35294 579 35822 ICV_80 $T=1106720 647885 1 0 $X=1106290 $Y=643330
X4209 44 74 35913 35936 579 35562 ICV_80 $T=1141440 647885 1 0 $X=1141010 $Y=643330
X4210 44 74 37258 37225 579 37292 ICV_80 $T=1198000 561645 1 0 $X=1197570 $Y=557090
X4211 44 74 37300 37277 579 37414 ICV_80 $T=1198000 679245 0 0 $X=1197570 $Y=678855
X4212 44 74 35763 37603 579 37292 ICV_80 $T=1199120 585165 1 0 $X=1198690 $Y=580610
X4213 44 74 37604 37418 579 37414 ICV_80 $T=1199120 655725 1 0 $X=1198690 $Y=651170
X4214 44 74 37822 37689 579 37414 ICV_80 $T=1211440 663565 0 0 $X=1211010 $Y=663175
X4215 44 74 37885 37882 579 590 ICV_80 $T=1218720 671405 0 0 $X=1218290 $Y=671015
X4216 44 74 81 25915 26011 ICV_103 $T=755040 498925 0 0 $X=754610 $Y=498535
X4217 44 74 90 26285 26315 ICV_103 $T=764000 616525 0 0 $X=763570 $Y=616135
X4218 44 74 90 26974 26975 ICV_103 $T=797600 616525 1 0 $X=797170 $Y=611970
X4219 44 74 27637 27675 27638 ICV_103 $T=822800 702765 0 0 $X=822370 $Y=702375
X4220 44 74 81 29310 29174 ICV_103 $T=883280 616525 1 0 $X=882850 $Y=611970
X4221 44 74 29737 97 29807 ICV_103 $T=904000 726285 1 0 $X=903570 $Y=721730
X4222 44 74 217 233 30081 ICV_103 $T=916320 498925 1 0 $X=915890 $Y=494370
X4223 44 74 227 30098 30079 ICV_103 $T=916320 514605 0 0 $X=915890 $Y=514215
X4224 44 74 31245 31821 31911 ICV_103 $T=987440 687085 1 0 $X=987010 $Y=682530
X4225 44 74 33103 33174 33083 ICV_103 $T=1030560 655725 0 0 $X=1030130 $Y=655335
X4226 44 74 33338 33384 32619 ICV_103 $T=1039520 514605 1 0 $X=1039090 $Y=510050
X4227 44 74 33361 33387 33405 ICV_103 $T=1042320 640045 1 0 $X=1041890 $Y=635490
X4228 44 74 33406 33275 33337 ICV_103 $T=1042880 655725 1 0 $X=1042450 $Y=651170
X4229 44 74 33220 33329 33722 ICV_103 $T=1058000 671405 1 0 $X=1057570 $Y=666850
X4230 44 74 166 33672 33823 ICV_103 $T=1067520 530285 1 0 $X=1067090 $Y=525730
X4231 44 74 240 34175 34219 ICV_103 $T=1081520 538125 1 0 $X=1081090 $Y=533570
X4232 44 74 240 33996 34231 ICV_103 $T=1082080 530285 1 0 $X=1081650 $Y=525730
X4233 44 74 83 36541 36935 ICV_103 $T=1189040 640045 1 0 $X=1188610 $Y=635490
X4234 44 74 36903 36963 36952 ICV_103 $T=1189600 538125 0 0 $X=1189170 $Y=537735
X4235 44 74 79 36831 37242 ICV_103 $T=1198560 593005 1 0 $X=1198130 $Y=588450
X4236 44 74 78 37676 37580 ICV_103 $T=1215920 710605 1 0 $X=1215490 $Y=706050
X4237 44 74 84 37466 495 ICV_103 $T=1219280 702765 1 0 $X=1218850 $Y=698210
X4238 44 74 38506 36565 38565 ICV_103 $T=1252880 624365 1 0 $X=1252450 $Y=619810
X4239 44 74 38609 38463 38547 ICV_103 $T=1255680 640045 0 0 $X=1255250 $Y=639655
X4240 44 74 83 26207 26446 ICV_71 $T=769040 647885 1 0 $X=768610 $Y=643330
X4241 44 74 28456 127 28569 ICV_71 $T=859760 687085 1 0 $X=859330 $Y=682530
X4242 44 74 159 28784 29391 ICV_71 $T=886080 522445 0 0 $X=885650 $Y=522055
X4243 44 74 166 28318 29455 ICV_71 $T=888880 498925 0 0 $X=888450 $Y=498535
X4244 44 74 185 29633 29564 ICV_71 $T=896720 561645 1 0 $X=896290 $Y=557090
X4245 44 74 200 29778 29835 ICV_71 $T=904560 553805 0 0 $X=904130 $Y=553415
X4246 44 74 166 30127 199 ICV_71 $T=923040 506765 1 0 $X=922610 $Y=502210
X4247 44 74 81 30235 30710 ICV_71 $T=944320 663565 0 0 $X=943890 $Y=663175
X4248 44 74 218 283 30769 ICV_71 $T=947120 545965 1 0 $X=946690 $Y=541410
X4249 44 74 30839 30710 30820 ICV_71 $T=949360 671405 1 0 $X=948930 $Y=666850
X4250 44 74 31148 29294 31133 ICV_71 $T=961680 585165 1 0 $X=961250 $Y=580610
X4251 44 74 32438 184 32409 ICV_71 $T=1002560 538125 1 0 $X=1002130 $Y=533570
X4252 44 74 33031 216 32986 ICV_71 $T=1022720 585165 0 0 $X=1022290 $Y=584775
X4253 44 74 159 31859 33105 ICV_71 $T=1026080 553805 0 0 $X=1025650 $Y=553415
X4254 44 74 217 381 33157 ICV_71 $T=1028320 506765 0 0 $X=1027890 $Y=506375
X4255 44 74 33680 33637 418 ICV_71 $T=1055200 491085 1 0 $X=1054770 $Y=486530
X4256 44 74 33568 33174 33769 ICV_71 $T=1059680 655725 0 0 $X=1059250 $Y=655335
X4257 44 74 33764 33675 33770 ICV_71 $T=1059680 679245 0 0 $X=1059250 $Y=678855
X4258 44 74 97 30501 37349 ICV_71 $T=1201360 647885 1 0 $X=1200930 $Y=643330
X4259 44 74 84 36960 37481 ICV_71 $T=1206400 702765 1 0 $X=1205970 $Y=698210
X4260 44 74 84 37260 37690 ICV_71 $T=1215920 702765 0 0 $X=1215490 $Y=702375
X4261 44 74 39118 39216 38783 ICV_71 $T=1274160 663565 1 0 $X=1273730 $Y=659010
X4262 44 74 26839 26816 579 27182 ICV_73 $T=779120 687085 1 0 $X=778690 $Y=682530
X4263 44 74 121 27389 579 27325 ICV_73 $T=802080 655725 1 0 $X=801650 $Y=651170
X4264 44 74 27444 27422 579 27617 ICV_73 $T=802640 600845 1 0 $X=802210 $Y=596290
X4265 44 74 27489 27467 579 27325 ICV_73 $T=804880 616525 1 0 $X=804450 $Y=611970
X4266 44 74 113 27838 579 29141 ICV_73 $T=818880 663565 1 0 $X=818450 $Y=659010
X4267 44 74 28751 28610 579 28698 ICV_73 $T=863120 538125 0 0 $X=862690 $Y=537735
X4268 44 74 29310 29150 579 28698 ICV_73 $T=870400 624365 0 0 $X=869970 $Y=623975
X4269 44 74 30147 30146 579 29115 ICV_73 $T=904000 671405 1 0 $X=903570 $Y=666850
X4270 44 74 33955 34490 579 35822 ICV_73 $T=1085440 624365 1 0 $X=1085010 $Y=619810
X4271 44 74 34411 34508 579 35822 ICV_73 $T=1085440 632205 0 0 $X=1085010 $Y=631815
X4272 44 74 34306 34492 579 35822 ICV_73 $T=1085440 655725 1 0 $X=1085010 $Y=651170
X4273 44 74 34409 34335 579 449 ICV_73 $T=1085440 679245 0 0 $X=1085010 $Y=678855
X4274 44 74 32793 34845 579 35822 ICV_73 $T=1087120 600845 0 0 $X=1086690 $Y=600455
X4275 44 74 35331 35361 579 449 ICV_73 $T=1105040 687085 1 0 $X=1104610 $Y=682530
X4276 44 74 35524 35504 579 35562 ICV_73 $T=1111200 663565 0 0 $X=1110770 $Y=663175
X4277 44 74 472 36236 579 469 ICV_73 $T=1145360 718445 1 0 $X=1144930 $Y=713890
X4278 44 74 37348 37245 579 486 ICV_73 $T=1196880 522445 1 0 $X=1196450 $Y=517890
X4279 44 74 37257 37224 579 36707 ICV_73 $T=1196880 538125 0 0 $X=1196450 $Y=537735
X4280 44 74 37086 37285 579 37292 ICV_73 $T=1196880 608685 1 0 $X=1196450 $Y=604130
X4281 44 79 26808 26769 74 79 26868 26379 ICV_108 $T=788640 498925 1 0 $X=788210 $Y=494370
X4282 44 159 176 29572 74 166 176 29644 ICV_108 $T=895040 498925 1 0 $X=894610 $Y=494370
X4283 44 29457 29647 29633 74 159 29348 29647 ICV_108 $T=897840 530285 1 0 $X=897410 $Y=525730
X4284 44 29335 29620 29711 74 166 29789 29620 ICV_108 $T=900080 514605 1 0 $X=899650 $Y=510050
X4285 44 29602 207 29834 74 175 210 29892 ICV_108 $T=905680 545965 0 0 $X=905250 $Y=545575
X4286 44 166 29929 29846 74 218 204 29998 ICV_108 $T=909040 514605 1 0 $X=908610 $Y=510050
X4287 44 29846 226 30052 74 159 29929 30035 ICV_108 $T=914640 514605 1 0 $X=914210 $Y=510050
X4288 44 29376 30168 231 74 239 30000 29879 ICV_108 $T=919680 498925 0 0 $X=919250 $Y=498535
X4289 44 159 29859 226 74 30035 30232 30098 ICV_108 $T=920240 514605 1 0 $X=919810 $Y=510050
X4290 44 194 30039 30335 74 159 30415 258 ICV_108 $T=928640 491085 0 0 $X=928210 $Y=490695
X4291 44 159 30182 254 74 159 30416 29857 ICV_108 $T=928640 506765 0 0 $X=928210 $Y=506375
X4292 44 197 30221 30345 74 29858 260 30297 ICV_108 $T=929200 538125 1 0 $X=928770 $Y=533570
X4293 44 30000 30412 30053 74 166 263 30039 ICV_108 $T=931440 498925 0 0 $X=931010 $Y=498535
X4294 44 29619 30039 262 74 159 263 30412 ICV_108 $T=934240 491085 0 0 $X=933810 $Y=490695
X4295 44 186 262 30443 74 244 30570 30567 ICV_108 $T=935920 553805 1 0 $X=935490 $Y=549250
X4296 44 244 30052 30469 74 159 30608 30529 ICV_108 $T=937600 530285 1 0 $X=937170 $Y=525730
X4297 44 278 30606 30649 74 264 30595 30678 ICV_108 $T=946000 506765 1 0 $X=945570 $Y=502210
X4298 44 30742 30768 30674 74 240 30838 30768 ICV_108 $T=947680 530285 1 0 $X=947250 $Y=525730
X4299 44 310 30744 30838 74 303 30052 30984 ICV_108 $T=954960 530285 1 0 $X=954530 $Y=525730
X4300 44 166 31195 272 74 159 31327 30477 ICV_108 $T=966720 530285 0 0 $X=966290 $Y=529895
X4301 44 217 33016 32770 74 197 33093 33046 ICV_108 $T=1023280 538125 1 0 $X=1022850 $Y=533570
X4302 44 244 33078 33006 74 166 27987 33131 ICV_108 $T=1025520 522445 0 0 $X=1025090 $Y=522055
X4303 44 159 32793 33255 74 159 33062 33324 ICV_108 $T=1034480 561645 0 0 $X=1034050 $Y=561255
X4304 44 31149 33316 33215 74 33227 273 33359 ICV_108 $T=1035600 585165 0 0 $X=1035170 $Y=584775
X4305 44 159 33243 33401 74 33683 33823 430 ICV_108 $T=1060240 530285 1 0 $X=1059810 $Y=525730
X4306 44 33476 33729 32455 74 33476 33823 422 ICV_108 $T=1061360 530285 0 0 $X=1060930 $Y=529895
X4307 44 33819 437 395 74 33831 33900 378 ICV_108 $T=1069200 491085 1 0 $X=1068770 $Y=486530
X4308 44 83 30843 36272 74 90 36342 36332 ICV_108 $T=1158800 624365 0 0 $X=1158370 $Y=623975
X4309 44 79 37855 37901 74 81 37855 37820 ICV_108 $T=1227680 514605 1 0 $X=1227250 $Y=510050
X4310 44 74 27423 27456 27442 ICV_93 $T=812160 702765 0 0 $X=811730 $Y=702375
X4311 44 74 27605 123 27531 ICV_93 $T=820000 726285 0 0 $X=819570 $Y=725895
X4312 44 74 27932 28006 26961 ICV_93 $T=836240 679245 0 0 $X=835810 $Y=678855
X4313 44 74 28134 27821 114 ICV_93 $T=853600 679245 0 0 $X=853170 $Y=678855
X4314 44 74 29723 29804 29806 ICV_93 $T=902880 577325 0 0 $X=902450 $Y=576935
X4315 44 74 29761 29956 29942 ICV_93 $T=908480 585165 0 0 $X=908050 $Y=584775
X4316 44 74 30735 30857 30801 ICV_93 $T=949360 561645 1 0 $X=948930 $Y=557090
X4317 44 74 170 32385 260 ICV_93 $T=1000320 585165 0 0 $X=999890 $Y=584775
X4318 44 74 32583 32584 32563 ICV_93 $T=1008160 530285 0 0 $X=1007730 $Y=529895
X4319 44 74 31194 32727 32595 ICV_93 $T=1012080 538125 0 0 $X=1011650 $Y=537735
X4320 44 74 32613 372 32847 ICV_93 $T=1017120 522445 1 0 $X=1016690 $Y=517890
X4321 44 74 33014 33050 32983 ICV_93 $T=1022720 671405 1 0 $X=1022290 $Y=666850
X4322 44 74 34176 33840 34290 ICV_93 $T=1082080 561645 0 0 $X=1081650 $Y=561255
X4323 44 74 34174 34303 34252 ICV_93 $T=1082640 530285 0 0 $X=1082210 $Y=529895
X4324 44 74 36565 38468 38450 ICV_93 $T=1246160 632205 1 0 $X=1245730 $Y=627650
X4325 44 74 38451 38487 38468 ICV_93 $T=1246720 632205 0 0 $X=1246290 $Y=631815
X4326 44 74 34119 38530 38506 ICV_93 $T=1248400 663565 0 0 $X=1247970 $Y=663175
X4327 44 74 32914 34348 38645 ICV_93 $T=1257360 663565 1 0 $X=1256930 $Y=659010
X4328 44 74 39277 39318 39215 ICV_93 $T=1273040 608685 0 0 $X=1272610 $Y=608295
X4329 44 74 38573 39483 39318 ICV_93 $T=1277520 608685 0 0 $X=1277090 $Y=608295
X4330 44 74 39651 38764 39216 ICV_93 $T=1287600 640045 1 0 $X=1287170 $Y=635490
X4331 44 27570 27512 27546 74 27510 114 27399 ICV_102 $T=818880 718445 0 180 $X=815650 $Y=713890
X4332 44 29773 29644 190 74 29620 29572 189 ICV_102 $T=903440 498925 0 180 $X=900210 $Y=494370
X4333 44 30168 163 241 74 29482 30035 235 ICV_102 $T=920240 491085 1 180 $X=917010 $Y=490695
X4334 44 218 30314 30530 74 218 210 30436 ICV_102 $T=937600 538125 0 180 $X=934370 $Y=533570
X4335 44 186 267 30777 74 287 269 30716 ICV_102 $T=948800 506765 1 180 $X=945570 $Y=506375
X4336 44 31810 31221 31909 74 31415 31747 31776 ICV_102 $T=989120 663565 0 180 $X=985890 $Y=659010
X4337 44 33214 33170 33093 74 159 28033 33172 ICV_102 $T=1032800 553805 1 180 $X=1029570 $Y=553415
X4338 44 33301 33220 33033 74 33242 33103 33180 ICV_102 $T=1035040 640045 1 180 $X=1031810 $Y=639655
X4339 44 33302 33229 33293 74 81 32631 33229 ICV_102 $T=1035040 694925 0 180 $X=1031810 $Y=690370
X4340 44 166 33316 33369 74 166 32500 33486 ICV_102 $T=1048480 530285 0 180 $X=1045250 $Y=525730
X4341 44 413 31092 33577 74 33424 33492 33513 ICV_102 $T=1052960 498925 0 180 $X=1049730 $Y=494370
X4342 44 33700 332 33721 74 33683 33542 414 ICV_102 $T=1058000 545965 1 180 $X=1054770 $Y=545575
X4343 44 166 29347 431 74 427 33401 396 ICV_102 $T=1063600 498925 1 180 $X=1060370 $Y=498535
X4344 44 33979 33912 33957 74 81 33466 33912 ICV_102 $T=1071440 694925 1 180 $X=1068210 $Y=694535
X4345 44 217 33693 34448 74 244 33996 34380 ICV_102 $T=1089920 530285 1 180 $X=1086690 $Y=529895
X4346 44 90 35671 35889 74 35839 97 35802 ICV_102 $T=1143120 694925 1 180 $X=1139890 $Y=694535
X4347 44 79 35752 36664 74 79 36447 36601 ICV_102 $T=1178400 585165 0 180 $X=1175170 $Y=580610
X4348 44 81 36416 36963 74 79 36416 37112 ICV_102 $T=1196880 545965 0 180 $X=1193650 $Y=541410
X4349 44 38695 38327 38824 74 38702 38449 38720 ICV_102 $T=1260720 538125 1 180 $X=1257490 $Y=537735
X4350 44 38824 38821 38836 74 38392 38310 38685 ICV_102 $T=1261280 530285 0 180 $X=1258050 $Y=525730
X4351 44 74 128 27605 125 27712 ICV_98 $T=824480 726285 0 0 $X=824050 $Y=725895
X4352 44 74 28246 28220 142 118 ICV_98 $T=845760 702765 0 0 $X=845330 $Y=702375
X4353 44 74 30163 30137 30048 30106 ICV_98 $T=916880 561645 0 0 $X=916450 $Y=561255
X4354 44 74 31221 31029 31234 31167 ICV_98 $T=964480 655725 1 0 $X=964050 $Y=651170
X4355 44 74 33188 33148 33050 33117 ICV_98 $T=1027200 671405 1 0 $X=1026770 $Y=666850
X4356 44 74 33427 33397 33014 33376 ICV_98 $T=1038960 663565 0 0 $X=1038530 $Y=663175
X4357 44 74 33387 33202 33428 33477 ICV_98 $T=1045120 655725 0 0 $X=1044690 $Y=655335
X4358 44 74 33919 33899 33901 33807 ICV_98 $T=1065840 561645 0 0 $X=1065410 $Y=561255
X4359 44 74 34336 34317 34304 34159 ICV_98 $T=1082640 561645 1 0 $X=1082210 $Y=557090
X4360 44 74 34451 450 34408 34309 ICV_98 $T=1087120 506765 1 0 $X=1086690 $Y=502210
X4361 44 74 34366 34448 34381 34380 ICV_98 $T=1088800 538125 1 0 $X=1088370 $Y=533570
X4362 44 74 38326 38412 38312 504 ICV_98 $T=1244480 569485 0 0 $X=1244050 $Y=569095
X4363 44 74 79 38812 38855 38703 ICV_98 $T=1259600 553805 1 0 $X=1259170 $Y=549250
X4364 44 74 39010 38967 38486 38913 ICV_98 $T=1263520 624365 1 0 $X=1263090 $Y=619810
X4365 44 74 39011 34119 38900 32914 ICV_98 $T=1263520 655725 0 0 $X=1263090 $Y=655335
X4366 44 74 39424 39064 39191 34481 ICV_98 $T=1274720 624365 1 0 $X=1274290 $Y=619810
X4367 44 74 81 26904 28108 ICV_82 $T=849120 577325 0 180 $X=845890 $Y=572770
X4368 44 74 28435 28304 28422 ICV_82 $T=859760 608685 0 180 $X=856530 $Y=604130
X4369 44 74 28569 28544 28541 ICV_82 $T=863680 687085 1 180 $X=860450 $Y=686695
X4370 44 74 29954 207 29983 ICV_82 $T=914640 530285 0 180 $X=911410 $Y=525730
X4371 44 74 30164 216 30165 ICV_82 $T=923040 585165 1 180 $X=919810 $Y=584775
X4372 44 74 81 30315 30447 ICV_82 $T=940400 671405 0 180 $X=937170 $Y=666850
X4373 44 74 30529 29455 294 ICV_82 $T=949360 491085 1 180 $X=946130 $Y=490695
X4374 44 74 31163 31255 31286 ICV_82 $T=971200 506765 0 180 $X=967970 $Y=502210
X4375 44 74 31028 31240 31340 ICV_82 $T=972880 640045 0 180 $X=969650 $Y=635490
X4376 44 74 32519 326 32453 ICV_82 $T=1009280 561645 0 180 $X=1006050 $Y=557090
X4377 44 74 33394 33454 380 ICV_82 $T=1047360 545965 0 180 $X=1044130 $Y=541410
X4378 44 74 33808 33764 33833 ICV_82 $T=1066960 640045 1 180 $X=1063730 $Y=639655
X4379 44 74 81 34461 35312 ICV_82 $T=1121840 616525 1 180 $X=1118610 $Y=616135
X4380 44 74 90 35524 35748 ICV_82 $T=1140320 671405 0 180 $X=1137090 $Y=666850
X4381 44 74 90 36599 36867 ICV_82 $T=1190720 616525 1 180 $X=1187490 $Y=616135
X4382 44 74 81 36334 37709 ICV_82 $T=1221520 514605 1 180 $X=1218290 $Y=514215
X4383 44 74 79 37883 37774 ICV_82 $T=1230480 585165 1 180 $X=1227250 $Y=584775
X4384 44 74 94 27763 27903 28340 ICV_110 $T=848000 632205 0 0 $X=847570 $Y=631815
X4385 44 74 86 29822 30147 30166 ICV_110 $T=914640 679245 0 0 $X=914210 $Y=678855
X4386 44 74 94 32285 348 32417 ICV_110 $T=998080 710605 1 0 $X=997650 $Y=706050
X4387 44 74 206 33780 33592 33954 ICV_110 $T=1066960 545965 0 0 $X=1066530 $Y=545575
X4388 44 74 212 32696 32535 34083 ICV_110 $T=1070880 498925 0 0 $X=1070450 $Y=498535
X4389 44 74 86 33578 34409 34428 ICV_110 $T=1083760 671405 0 0 $X=1083330 $Y=671015
X4390 44 74 86 33955 34461 34490 ICV_110 $T=1086000 624365 0 0 $X=1085570 $Y=623975
X4391 44 74 135 34685 35787 35812 ICV_110 $T=1134160 545965 0 0 $X=1133730 $Y=545575
X4392 44 74 135 30608 35811 35838 ICV_110 $T=1135280 522445 0 0 $X=1134850 $Y=522055
X4393 44 74 94 35614 35913 35936 ICV_110 $T=1139760 640045 0 0 $X=1139330 $Y=639655
X4394 44 74 86 35811 36334 36407 ICV_110 $T=1159920 530285 0 0 $X=1159490 $Y=529895
X4395 44 74 86 35602 35752 36426 ICV_110 $T=1161040 600845 0 0 $X=1160610 $Y=600455
X4396 44 74 94 35827 36174 36487 ICV_110 $T=1164400 538125 1 0 $X=1163970 $Y=533570
X4397 44 74 86 35431 36759 37026 ICV_110 $T=1186240 577325 0 0 $X=1185810 $Y=576935
X4398 44 74 86 35837 37797 37832 ICV_110 $T=1219280 506765 1 0 $X=1218850 $Y=502210
X4399 44 74 94 490 37821 37856 ICV_110 $T=1220400 593005 0 0 $X=1219970 $Y=592615
X4400 44 168 ANTENNA $T=893920 694925 1 0 $X=893490 $Y=690370
X4401 44 168 ANTENNA $T=896720 694925 0 0 $X=896290 $Y=694535
X4402 44 168 ANTENNA $T=897840 694925 0 0 $X=897410 $Y=694535
X4403 44 198 ANTENNA $T=906800 710605 0 0 $X=906370 $Y=710215
X4404 44 198 ANTENNA $T=907920 710605 0 0 $X=907490 $Y=710215
X4405 44 253 ANTENNA $T=933120 569485 1 0 $X=932690 $Y=564930
X4406 44 253 ANTENNA $T=934240 569485 1 0 $X=933810 $Y=564930
X4407 44 339 ANTENNA $T=975680 702765 0 0 $X=975250 $Y=702375
X4408 44 332 ANTENNA $T=988560 491085 0 0 $X=988130 $Y=490695
X4409 44 332 ANTENNA $T=992480 491085 0 0 $X=992050 $Y=490695
X4410 44 455 ANTENNA $T=1094960 679245 1 0 $X=1094530 $Y=674690
X4411 44 455 ANTENNA $T=1098320 671405 0 0 $X=1097890 $Y=671015
X4412 166 44 74 159 INVX4 $T=1100560 514605 1 180 $X=1097890 $Y=514215
X4413 468 44 74 90 INVX4 $T=1150400 600845 0 0 $X=1149970 $Y=600455
.ENDS
***************************************
.SUBCKT ICV_84 1 2 3 4 5 6
** N=8 EP=6 IP=13 FDC=40
X1 4 6 2 5 1 2 3 DFFQSRX1 $T=25760 0 1 180 $X=130 $Y=-390
.ENDS
***************************************
.SUBCKT ICV_83 1 2 3 4 5
** N=7 EP=5 IP=11 FDC=4
X1 3 4 1 2 5 NAND2X1 $T=0 0 0 0 $X=-430 $Y=-390
.ENDS
***************************************
.SUBCKT ICV_59
** N=4 EP=0 IP=8 FDC=0
.ENDS
***************************************
.SUBCKT ICV_85 18 45 46 47 48 49 50 51 52 53 54 55 56 57 58 59 60 61 62 63
+ 64 65 66 67 68 69 70 71 72 73 74 75 76 77 78 79 80 81 82 83
+ 84 85 86 87 88 89 90 91 92 93 94 95 96 97 98 99 100 101 102 103
+ 104 105 106 107 108 109 110 111 112 113 114 115 116 117 118 119 120 121 122 123
+ 124 125 126 127 128 129 130 131 132 133 134 135 136 137 138 139 140 141 142 143
+ 144 145 146 147 148 149 150 151 152 153 154 155 156 157 158 159 160 161 162 163
+ 164 165 166 167 168 169 170 171 172 173 174 175 176 177 178 179 180 181 182 183
+ 184 185 186 187 188 189 190 191 192 193 194 195 196 197 198 199 200 201 202 203
+ 204 205 206 207 208 275 278 284 285 288 296 298 303 304 306 307 310 313
** N=202402 EP=178 IP=13884 FDC=12383
X613 24867 54 45 181 18 45 24868 DFFQSRX1 $T=723120 741965 0 0 $X=722690 $Y=741575
X614 24987 54 45 181 18 45 24256 DFFQSRX1 $T=748320 757645 0 180 $X=722690 $Y=753090
X615 24964 26173 45 181 18 45 24257 DFFQSRX1 $T=748320 789005 1 180 $X=722690 $Y=788615
X616 25561 26173 45 181 18 45 24258 DFFQSRX1 $T=748320 804685 0 180 $X=722690 $Y=800130
X617 25068 26173 45 181 18 45 24437 DFFQSRX1 $T=752800 773325 1 180 $X=727170 $Y=772935
X618 25332 26173 45 181 18 45 24784 DFFQSRX1 $T=761760 781165 0 180 $X=736130 $Y=776610
X619 25433 54 45 181 18 45 25643 DFFQSRX1 $T=750000 765485 1 0 $X=749570 $Y=760930
X620 275 54 45 181 18 45 25227 DFFQSRX1 $T=753920 734125 0 0 $X=753490 $Y=733735
X621 25841 54 45 181 18 45 25371 DFFQSRX1 $T=753920 757645 1 0 $X=753490 $Y=753090
X622 25897 54 45 181 18 45 25937 DFFQSRX1 $T=757280 741965 1 0 $X=756850 $Y=737410
X623 26218 26173 45 181 18 45 26255 DFFQSRX1 $T=762880 773325 1 0 $X=762450 $Y=768770
X624 26112 28143 45 181 18 45 26023 DFFQSRX1 $T=764000 828205 1 0 $X=763570 $Y=823650
X625 26200 26173 45 181 18 45 26334 DFFQSRX1 $T=765680 812525 1 0 $X=765250 $Y=807970
X626 26470 26173 45 181 18 45 25916 DFFQSRX1 $T=793120 804685 1 180 $X=767490 $Y=804295
X627 26252 28143 45 181 18 45 26310 DFFQSRX1 $T=767920 843885 0 0 $X=767490 $Y=843495
X628 278 102 45 181 18 45 65 DFFQSRX1 $T=781920 734125 1 0 $X=781490 $Y=729570
X629 26520 28143 45 181 18 45 26777 DFFQSRX1 $T=782480 851725 0 0 $X=782050 $Y=851335
X630 26918 28178 45 181 18 45 26469 DFFQSRX1 $T=810480 773325 1 180 $X=784850 $Y=772935
X631 26812 26173 45 181 18 45 26966 DFFQSRX1 $T=786960 789005 0 0 $X=786530 $Y=788615
X632 26979 28178 45 181 18 45 26570 DFFQSRX1 $T=813840 781165 0 180 $X=788210 $Y=776610
X633 27072 28178 45 181 18 45 25970 DFFQSRX1 $T=813840 812525 1 180 $X=788210 $Y=812135
X634 26788 28143 45 181 18 45 27004 DFFQSRX1 $T=789200 828205 1 0 $X=788770 $Y=823650
X635 27128 28178 45 181 18 45 26809 DFFQSRX1 $T=821120 796845 1 180 $X=795490 $Y=796455
X636 27621 102 45 181 18 45 27113 DFFQSRX1 $T=831760 749805 0 180 $X=806130 $Y=745250
X637 27722 28178 45 181 18 45 27251 DFFQSRX1 $T=835120 765485 0 180 $X=809490 $Y=760930
X638 27721 28178 45 181 18 45 27272 DFFQSRX1 $T=835680 757645 1 180 $X=810050 $Y=757255
X639 27651 28143 45 181 18 45 27705 DFFQSRX1 $T=811040 828205 0 0 $X=810610 $Y=827815
X640 27828 28143 45 181 18 45 27327 DFFQSRX1 $T=837360 867405 1 180 $X=811730 $Y=867015
X641 27685 28178 45 181 18 45 27362 DFFQSRX1 $T=838480 812525 0 180 $X=812850 $Y=807970
X642 27786 28143 45 181 18 45 27363 DFFQSRX1 $T=838480 875245 1 180 $X=812850 $Y=874855
X643 28336 29574 45 181 18 45 27702 DFFQSRX1 $T=853040 812525 1 180 $X=827410 $Y=812135
X644 28317 28178 45 181 18 45 27602 DFFQSRX1 $T=854720 781165 1 180 $X=829090 $Y=780775
X645 28192 29574 45 181 18 45 27903 DFFQSRX1 $T=855280 828205 0 180 $X=829650 $Y=823650
X646 28271 28143 45 181 18 45 28304 DFFQSRX1 $T=830640 836045 0 0 $X=830210 $Y=835655
X647 28420 102 45 181 18 45 28005 DFFQSRX1 $T=858640 757645 0 180 $X=833010 $Y=753090
X648 28580 102 45 181 18 45 28442 DFFQSRX1 $T=834000 749805 0 0 $X=833570 $Y=749415
X649 28186 28178 45 181 18 45 28220 DFFQSRX1 $T=834000 789005 1 0 $X=833570 $Y=784450
X650 28443 28178 45 181 18 45 28478 DFFQSRX1 $T=834000 804685 1 0 $X=833570 $Y=800130
X651 28848 29574 45 181 18 45 28021 DFFQSRX1 $T=859200 836045 0 180 $X=833570 $Y=831490
X652 28849 30499 45 181 18 45 27236 DFFQSRX1 $T=864800 875245 1 180 $X=839170 $Y=874855
X653 28934 29574 45 181 18 45 28301 DFFQSRX1 $T=874880 773325 1 180 $X=849250 $Y=772935
X654 29209 29574 45 181 18 45 29172 DFFQSRX1 $T=864800 796845 1 0 $X=864370 $Y=792290
X655 29260 29574 45 181 18 45 29295 DFFQSRX1 $T=864800 804685 0 0 $X=864370 $Y=804295
X656 29225 29574 45 181 18 45 28665 DFFQSRX1 $T=864800 812525 0 0 $X=864370 $Y=812135
X657 28957 29574 45 181 18 45 29136 DFFQSRX1 $T=864800 836045 0 0 $X=864370 $Y=835655
X658 28975 30499 45 181 18 45 29446 DFFQSRX1 $T=864800 875245 0 0 $X=864370 $Y=874855
X659 29314 102 45 181 18 45 92 DFFQSRX1 $T=873200 749805 0 0 $X=872770 $Y=749415
X660 29674 30499 45 181 18 45 29333 DFFQSRX1 $T=899520 851725 0 180 $X=873890 $Y=847170
X661 284 102 45 181 18 45 104 DFFQSRX1 $T=875440 741965 1 0 $X=875010 $Y=737410
X662 285 102 45 181 18 45 105 DFFQSRX1 $T=876000 734125 1 0 $X=875570 $Y=729570
X663 29944 113 45 181 18 45 99 DFFQSRX1 $T=901760 741965 1 180 $X=876130 $Y=741575
X664 30114 113 45 181 18 45 101 DFFQSRX1 $T=902880 757645 1 180 $X=877250 $Y=757255
X665 29654 29574 45 181 18 45 30154 DFFQSRX1 $T=877680 773325 0 0 $X=877250 $Y=772935
X666 29928 29574 45 181 18 45 29492 DFFQSRX1 $T=905120 812525 0 180 $X=879490 $Y=807970
X667 29929 30499 45 181 18 45 29335 DFFQSRX1 $T=905120 828205 0 180 $X=879490 $Y=823650
X668 30030 29574 45 181 18 45 30032 DFFQSRX1 $T=884960 781165 0 0 $X=884530 $Y=780775
X669 30155 30499 45 181 18 45 30242 DFFQSRX1 $T=890000 843885 1 0 $X=889570 $Y=839330
X670 30637 30499 45 181 18 45 30690 DFFQSRX1 $T=906240 851725 1 0 $X=905810 $Y=847170
X671 288 113 45 181 18 45 100 DFFQSRX1 $T=909040 734125 1 0 $X=908610 $Y=729570
X672 30605 113 45 181 18 45 30770 DFFQSRX1 $T=909040 734125 0 0 $X=908610 $Y=733735
X673 30891 113 45 181 18 45 30289 DFFQSRX1 $T=934800 757645 1 180 $X=909170 $Y=757255
X674 30665 113 45 181 18 45 30754 DFFQSRX1 $T=910160 781165 1 0 $X=909730 $Y=776610
X675 30681 30499 45 181 18 45 30708 DFFQSRX1 $T=910720 820365 1 0 $X=910290 $Y=815810
X676 30946 31363 45 181 18 45 29745 DFFQSRX1 $T=935920 883085 0 180 $X=910290 $Y=878530
X677 30652 31363 45 181 18 45 30833 DFFQSRX1 $T=911840 890925 1 0 $X=911410 $Y=886370
X678 30782 30499 45 181 18 45 30930 DFFQSRX1 $T=912960 859565 1 0 $X=912530 $Y=855010
X679 30864 30499 45 181 18 45 30892 DFFQSRX1 $T=915200 828205 0 0 $X=914770 $Y=827815
X680 30844 30499 45 181 18 45 30998 DFFQSRX1 $T=915200 843885 1 0 $X=914770 $Y=839330
X681 31016 113 45 181 18 45 30980 DFFQSRX1 $T=916880 796845 1 0 $X=916450 $Y=792290
X682 31749 31363 45 181 18 45 29930 DFFQSRX1 $T=963360 883085 1 180 $X=937730 $Y=882695
X683 31417 31363 45 181 18 45 31735 DFFQSRX1 $T=942080 843885 0 0 $X=941650 $Y=843495
X684 31687 31363 45 181 18 45 31514 DFFQSRX1 $T=970640 851725 0 180 $X=945010 $Y=847170
X685 31586 31363 45 181 18 45 31515 DFFQSRX1 $T=970640 859565 1 180 $X=945010 $Y=859175
X686 32743 31363 45 181 18 45 31441 DFFQSRX1 $T=970640 875245 0 180 $X=945010 $Y=870690
X687 32995 31363 45 181 18 45 32742 DFFQSRX1 $T=979600 843885 0 0 $X=979170 $Y=843495
X688 33505 33784 45 181 18 45 32970 DFFQSRX1 $T=1017680 851725 1 180 $X=992050 $Y=851335
X689 33362 31363 45 181 18 45 33397 DFFQSRX1 $T=993600 836045 1 0 $X=993170 $Y=831490
X690 33599 34542 45 181 18 45 33148 DFFQSRX1 $T=1022720 773325 1 180 $X=997090 $Y=772935
X691 33600 33784 45 181 18 45 33247 DFFQSRX1 $T=1025520 843885 0 180 $X=999890 $Y=839330
X692 33718 296 45 181 18 45 33753 DFFQSRX1 $T=1005360 741965 0 0 $X=1004930 $Y=741575
X693 34201 33784 45 181 18 45 33153 DFFQSRX1 $T=1037280 883085 0 180 $X=1011650 $Y=878530
X694 34734 298 45 181 18 45 149 DFFQSRX1 $T=1037840 757645 0 180 $X=1012210 $Y=753090
X695 33949 33784 45 181 18 45 33983 DFFQSRX1 $T=1012640 804685 1 0 $X=1012210 $Y=800130
X696 33950 34542 45 181 18 45 33654 DFFQSRX1 $T=1037840 812525 0 180 $X=1012210 $Y=807970
X697 34151 34542 45 181 18 45 34071 DFFQSRX1 $T=1013760 765485 1 0 $X=1013330 $Y=760930
X698 34118 34542 45 181 18 45 33701 DFFQSRX1 $T=1039520 796845 0 180 $X=1013890 $Y=792290
X699 34397 34542 45 181 18 45 33719 DFFQSRX1 $T=1040080 789005 0 180 $X=1014450 $Y=784450
X700 34169 33784 45 181 18 45 34205 DFFQSRX1 $T=1018240 836045 0 0 $X=1017810 $Y=835655
X701 34324 33784 45 181 18 45 34258 DFFQSRX1 $T=1018800 851725 0 0 $X=1018370 $Y=851335
X702 34370 298 45 181 18 45 34373 DFFQSRX1 $T=1027200 734125 0 0 $X=1026770 $Y=733735
X703 34609 298 45 181 18 45 34577 DFFQSRX1 $T=1030000 749805 1 0 $X=1029570 $Y=745250
X704 34735 33784 45 181 18 45 32916 DFFQSRX1 $T=1059120 875245 0 180 $X=1033490 $Y=870690
X705 34355 34542 45 181 18 45 34323 DFFQSRX1 $T=1038960 804685 0 0 $X=1038530 $Y=804295
X706 34679 34542 45 181 18 45 34895 DFFQSRX1 $T=1041200 781165 0 0 $X=1040770 $Y=780775
X707 35009 34542 45 181 18 45 34514 DFFQSRX1 $T=1066400 789005 1 180 $X=1040770 $Y=788615
X708 35126 34542 45 181 18 45 34529 DFFQSRX1 $T=1066960 757645 1 180 $X=1041330 $Y=757255
X709 34830 34542 45 181 18 45 34862 DFFQSRX1 $T=1041760 804685 1 0 $X=1041330 $Y=800130
X710 34911 34542 45 181 18 45 34935 DFFQSRX1 $T=1041760 820365 1 0 $X=1041330 $Y=815810
X711 35196 36042 45 181 18 45 34374 DFFQSRX1 $T=1070880 883085 0 180 $X=1045250 $Y=878530
X712 35107 33784 45 181 18 45 35040 DFFQSRX1 $T=1050720 851725 0 0 $X=1050290 $Y=851335
X713 35681 36042 45 181 18 45 34955 DFFQSRX1 $T=1081520 828205 0 180 $X=1055890 $Y=823650
X714 36069 36042 45 181 18 45 35397 DFFQSRX1 $T=1097760 875245 1 180 $X=1072130 $Y=874855
X715 36070 36042 45 181 18 45 36265 DFFQSRX1 $T=1083200 867405 0 0 $X=1082770 $Y=867015
X716 36052 36042 45 181 18 45 36011 DFFQSRX1 $T=1087120 812525 0 0 $X=1086690 $Y=812135
X717 35964 36042 45 181 18 45 35982 DFFQSRX1 $T=1087120 828205 0 0 $X=1086690 $Y=827815
X718 35819 36042 45 181 18 45 35980 DFFQSRX1 $T=1087120 843885 0 0 $X=1086690 $Y=843495
X719 36586 36042 45 181 18 45 36618 DFFQSRX1 $T=1097200 812525 1 0 $X=1096770 $Y=807970
X720 36651 36042 45 181 18 45 36311 DFFQSRX1 $T=1122960 820365 1 180 $X=1097330 $Y=819975
X721 36832 37385 45 181 18 45 35778 DFFQSRX1 $T=1126880 859565 1 180 $X=1101250 $Y=859175
X722 37434 37803 45 181 18 45 36935 DFFQSRX1 $T=1143680 804685 0 180 $X=1118050 $Y=800130
X723 37375 36042 45 181 18 45 37401 DFFQSRX1 $T=1118480 812525 0 0 $X=1118050 $Y=812135
X724 37487 37385 45 181 18 45 35520 DFFQSRX1 $T=1144800 867405 1 180 $X=1119170 $Y=867015
X725 37400 37385 45 181 18 45 37639 DFFQSRX1 $T=1121280 859565 1 0 $X=1120850 $Y=855010
X726 306 307 45 181 18 45 187 DFFQSRX1 $T=1124640 734125 1 0 $X=1124210 $Y=729570
X727 37896 37803 45 181 18 45 37377 DFFQSRX1 $T=1158240 749805 0 180 $X=1132610 $Y=745250
X728 37778 37803 45 181 18 45 37813 DFFQSRX1 $T=1133600 757645 1 0 $X=1133170 $Y=753090
X729 38127 37803 45 181 18 45 38268 DFFQSRX1 $T=1140880 796845 0 0 $X=1140450 $Y=796455
X730 38106 37803 45 181 18 45 38129 DFFQSRX1 $T=1141440 820365 1 0 $X=1141010 $Y=815810
X731 38327 37803 45 181 18 45 38371 DFFQSRX1 $T=1151520 741965 1 0 $X=1151090 $Y=737410
X732 38408 37385 45 181 18 45 38050 DFFQSRX1 $T=1180080 851725 0 180 $X=1154450 $Y=847170
X733 38128 37385 45 181 18 45 38809 DFFQSRX1 $T=1162160 843885 1 0 $X=1161730 $Y=839330
X734 38860 39869 45 181 18 45 38462 DFFQSRX1 $T=1189600 765485 1 180 $X=1163970 $Y=765095
X735 38789 37803 45 181 18 45 38841 DFFQSRX1 $T=1164960 781165 0 0 $X=1164530 $Y=780775
X736 310 307 45 181 18 45 196 DFFQSRX1 $T=1167200 734125 0 0 $X=1166770 $Y=733735
X737 39488 37803 45 181 18 45 39364 DFFQSRX1 $T=1167200 757645 1 0 $X=1166770 $Y=753090
X738 38985 37803 45 181 18 45 39003 DFFQSRX1 $T=1167200 757645 0 0 $X=1166770 $Y=757255
X739 38806 37803 45 181 18 45 38913 DFFQSRX1 $T=1167200 796845 1 0 $X=1166770 $Y=792290
X740 38947 37385 45 181 18 45 39177 DFFQSRX1 $T=1167200 812525 0 0 $X=1166770 $Y=812135
X741 38826 37385 45 181 18 45 39041 DFFQSRX1 $T=1167200 828205 1 0 $X=1166770 $Y=823650
X742 39407 39869 45 181 18 45 38910 DFFQSRX1 $T=1203600 773325 1 180 $X=1177970 $Y=772935
X743 39511 39869 45 181 18 45 39057 DFFQSRX1 $T=1208080 781165 0 180 $X=1182450 $Y=776610
X744 39384 39869 45 181 18 45 39857 DFFQSRX1 $T=1199680 812525 1 0 $X=1199250 $Y=807970
X745 39534 39869 45 181 18 45 39761 DFFQSRX1 $T=1199680 812525 0 0 $X=1199250 $Y=812135
X746 40121 39869 45 181 18 45 39212 DFFQSRX1 $T=1200240 796845 1 0 $X=1199810 $Y=792290
X747 40004 201 45 181 18 45 40139 DFFQSRX1 $T=1201360 734125 0 0 $X=1200930 $Y=733735
X748 40510 201 45 181 18 45 39934 DFFQSRX1 $T=1232720 757645 0 180 $X=1207090 $Y=753090
X749 40196 39869 45 181 18 45 40413 DFFQSRX1 $T=1208640 765485 0 0 $X=1208210 $Y=765095
X750 41082 39869 45 181 18 45 40568 DFFQSRX1 $T=1251760 804685 0 180 $X=1226130 $Y=800130
X751 40777 201 45 181 18 45 41024 DFFQSRX1 $T=1228800 734125 0 0 $X=1228370 $Y=733735
X752 41300 201 45 181 18 45 41345 DFFQSRX1 $T=1234960 749805 0 0 $X=1234530 $Y=749415
X753 41124 201 45 181 18 45 41125 DFFQSRX1 $T=1234960 757645 1 0 $X=1234530 $Y=753090
X754 41301 39869 45 181 18 45 41247 DFFQSRX1 $T=1234960 773325 0 0 $X=1234530 $Y=772935
X885 60 61 25937 18 45 25897 MUX2X1 $T=772960 734125 0 180 $X=766930 $Y=729570
X886 66 61 26898 18 45 26860 MUX2X1 $T=803200 734125 1 180 $X=797170 $Y=733735
X887 68 61 27113 18 45 27621 MUX2X1 $T=816080 741965 1 0 $X=815650 $Y=737410
X888 70 61 27272 18 45 27721 MUX2X1 $T=819440 749805 0 0 $X=819010 $Y=749415
X889 71 61 27251 18 45 27722 MUX2X1 $T=819440 773325 1 0 $X=819010 $Y=768770
X890 28301 61 27852 18 45 28185 MUX2X1 $T=845200 765485 0 180 $X=839170 $Y=760930
X891 28005 61 28220 18 45 28186 MUX2X1 $T=845200 773325 1 180 $X=839170 $Y=772935
X892 28442 61 27602 18 45 28317 MUX2X1 $T=849680 781165 0 180 $X=843650 $Y=776610
X893 92 61 28478 18 45 28443 MUX2X1 $T=853600 796845 0 180 $X=847570 $Y=792290
X894 97 61 29059 18 45 29332 MUX2X1 $T=869280 765485 1 0 $X=868850 $Y=760930
X895 99 61 29172 18 45 29209 MUX2X1 $T=876000 789005 1 180 $X=869970 $Y=788615
X896 100 61 28665 18 45 29225 MUX2X1 $T=876560 812525 0 180 $X=870530 $Y=807970
X897 101 61 29295 18 45 29260 MUX2X1 $T=877680 804685 0 180 $X=871650 $Y=800130
X898 104 61 29492 18 45 29928 MUX2X1 $T=890000 804685 0 0 $X=889570 $Y=804295
X899 105 61 29335 18 45 29929 MUX2X1 $T=890000 820365 1 0 $X=889570 $Y=815810
X900 30032 61 30031 18 45 29992 MUX2X1 $T=902880 789005 0 180 $X=896850 $Y=784450
X901 111 61 30490 18 45 30460 MUX2X1 $T=917440 804685 0 180 $X=911410 $Y=800130
X902 30289 61 30708 18 45 30681 MUX2X1 $T=925280 812525 1 180 $X=919250 $Y=812135
X903 30154 61 30128 18 45 30831 MUX2X1 $T=920240 804685 1 0 $X=919810 $Y=800130
X904 117 61 30980 18 45 31016 MUX2X1 $T=926400 789005 1 0 $X=925970 $Y=784450
X905 30754 61 30892 18 45 30864 MUX2X1 $T=932000 812525 1 180 $X=925970 $Y=812135
X906 32184 32008 32145 18 45 32204 MUX2X1 $T=967840 789005 0 0 $X=967410 $Y=788615
X907 30770 61 33397 18 45 33362 MUX2X1 $T=1009280 828205 0 180 $X=1003250 $Y=823650
X908 33148 61 33075 18 45 33396 MUX2X1 $T=1010400 804685 1 180 $X=1004370 $Y=804295
X909 159 160 33753 18 45 33718 MUX2X1 $T=1020480 734125 1 180 $X=1014450 $Y=733735
X910 156 61 33983 18 45 33949 MUX2X1 $T=1028320 796845 1 180 $X=1022290 $Y=796455
X911 34071 61 33654 18 45 33950 MUX2X1 $T=1028320 804685 1 180 $X=1022290 $Y=804295
X912 149 61 34167 18 45 34133 MUX2X1 $T=1034480 820365 1 180 $X=1028450 $Y=819975
X913 33701 61 34323 18 45 34355 MUX2X1 $T=1031120 804685 0 0 $X=1030690 $Y=804295
X914 162 160 34373 18 45 34370 MUX2X1 $T=1042320 734125 0 180 $X=1036290 $Y=729570
X915 163 160 34577 18 45 34609 MUX2X1 $T=1039520 741965 1 0 $X=1039090 $Y=737410
X916 34529 61 34862 18 45 34830 MUX2X1 $T=1057440 796845 0 180 $X=1051410 $Y=792290
X917 34514 61 34935 18 45 34911 MUX2X1 $T=1060240 812525 1 180 $X=1054210 $Y=812135
X918 33719 61 34955 18 45 35681 MUX2X1 $T=1073120 820365 1 0 $X=1072690 $Y=815810
X919 34895 61 35757 18 45 35800 MUX2X1 $T=1076480 804685 1 0 $X=1076050 $Y=800130
X920 35874 35680 35696 18 45 35662 MUX2X1 $T=1085440 781165 0 180 $X=1079410 $Y=776610
X921 170 61 36011 18 45 36052 MUX2X1 $T=1084320 804685 1 0 $X=1083890 $Y=800130
X922 34913 61 36618 18 45 36586 MUX2X1 $T=1112880 796845 1 180 $X=1106850 $Y=796455
X923 184 61 36935 18 45 37434 MUX2X1 $T=1127440 796845 0 0 $X=1127010 $Y=796455
X924 187 61 37780 18 45 37747 MUX2X1 $T=1147600 781165 1 180 $X=1141570 $Y=780775
X925 188 61 37813 18 45 37778 MUX2X1 $T=1148720 749805 1 180 $X=1142690 $Y=749415
X926 189 61 37814 18 45 37779 MUX2X1 $T=1148720 773325 1 180 $X=1142690 $Y=772935
X927 37377 61 37949 18 45 37915 MUX2X1 $T=1153200 781165 1 180 $X=1147170 $Y=780775
X928 191 61 38351 18 45 38309 MUX2X1 $T=1165520 749805 0 180 $X=1159490 $Y=745250
X929 192 61 38371 18 45 38327 MUX2X1 $T=1166080 734125 1 180 $X=1160050 $Y=733735
X930 51 49 18 45 25006 NAND2X1 $T=750560 734125 1 180 $X=747330 $Y=733735
X931 46 24258 18 45 25294 NAND2X1 $T=752240 796845 0 180 $X=749010 $Y=792290
X932 46 25372 18 45 25314 NAND2X1 $T=751120 820365 1 0 $X=750690 $Y=815810
X933 53 25227 18 45 56 NAND2X1 $T=754480 734125 0 180 $X=751250 $Y=729570
X934 25452 57 18 45 25433 NAND2X1 $T=756160 757645 1 180 $X=752930 $Y=757255
X935 25643 49 18 45 25580 NAND2X1 $T=761200 773325 1 180 $X=757970 $Y=772935
X936 53 25643 18 45 25452 NAND2X1 $T=763440 757645 1 180 $X=760210 $Y=757255
X937 25822 25860 18 45 25841 NAND2X1 $T=764560 749805 1 0 $X=764130 $Y=745250
X938 59 25937 18 45 25860 NAND2X1 $T=767360 749805 1 0 $X=766930 $Y=745250
X939 53 25725 18 45 26115 NAND2X1 $T=775760 781165 1 180 $X=772530 $Y=780775
X940 46 25916 18 45 26271 NAND2X1 $T=778000 796845 0 0 $X=777570 $Y=796455
X941 59 62 18 45 26238 NAND2X1 $T=781920 749805 1 180 $X=778690 $Y=749415
X942 47 26334 18 45 26309 NAND2X1 $T=779120 812525 0 0 $X=778690 $Y=812135
X943 26436 49 18 45 26181 NAND2X1 $T=787520 796845 0 180 $X=784290 $Y=792290
X944 47 25916 18 45 26571 NAND2X1 $T=790320 820365 0 180 $X=787090 $Y=815810
X945 46 26777 18 45 26592 NAND2X1 $T=793120 843885 0 0 $X=792690 $Y=843495
X946 26826 26755 18 45 26812 NAND2X1 $T=797600 789005 0 180 $X=794370 $Y=784450
X947 53 26436 18 45 26808 NAND2X1 $T=798160 765485 0 180 $X=794930 $Y=760930
X948 53 26469 18 45 26882 NAND2X1 $T=799840 765485 1 180 $X=796610 $Y=765095
X949 46 25970 18 45 26883 NAND2X1 $T=799840 804685 1 180 $X=796610 $Y=804295
X950 47 26608 18 45 26957 NAND2X1 $T=804320 843885 1 180 $X=801090 $Y=843495
X951 53 26570 18 45 26946 NAND2X1 $T=802080 789005 1 0 $X=801650 $Y=784450
X952 59 27113 18 45 26845 NAND2X1 $T=803760 749805 0 0 $X=803330 $Y=749415
X953 27110 27142 18 45 27128 NAND2X1 $T=804880 789005 1 0 $X=804450 $Y=784450
X954 26809 49 18 45 27001 NAND2X1 $T=805440 804685 0 0 $X=805010 $Y=804295
X955 47 27004 18 45 27143 NAND2X1 $T=808240 836045 0 180 $X=805010 $Y=831490
X956 46 26608 18 45 27219 NAND2X1 $T=810480 851725 1 180 $X=807250 $Y=851335
X957 27362 49 18 45 27445 NAND2X1 $T=818320 812525 0 0 $X=817890 $Y=812135
X958 47 27409 18 45 27568 NAND2X1 $T=818320 851725 1 0 $X=817890 $Y=847170
X959 46 27327 18 45 27636 NAND2X1 $T=823360 859565 1 180 $X=820130 $Y=859175
X960 27702 49 18 45 27425 NAND2X1 $T=825040 820365 0 180 $X=821810 $Y=815810
X961 46 27363 18 45 27723 NAND2X1 $T=824480 851725 0 0 $X=824050 $Y=851335
X962 47 27363 18 45 27798 NAND2X1 $T=832880 859565 0 180 $X=829650 $Y=855010
X963 47 26777 18 45 27958 NAND2X1 $T=833440 851725 1 180 $X=830210 $Y=851335
X964 53 27702 18 45 28191 NAND2X1 $T=841280 812525 0 180 $X=838050 $Y=807970
X965 27903 49 18 45 27805 NAND2X1 $T=838480 843885 1 0 $X=838050 $Y=839330
X966 53 27903 18 45 28170 NAND2X1 $T=841280 820365 0 0 $X=840850 $Y=819975
X967 59 28220 18 45 28255 NAND2X1 $T=841840 796845 1 0 $X=841410 $Y=792290
X968 28300 83 18 45 28594 NAND2X1 $T=851920 741965 0 0 $X=851490 $Y=741575
X969 47 27705 18 45 28629 NAND2X1 $T=855840 851725 0 180 $X=852610 $Y=847170
X970 28304 49 18 45 28649 NAND2X1 $T=853600 843885 1 0 $X=853170 $Y=839330
X971 87 28442 18 45 28647 NAND2X1 $T=859200 749805 0 0 $X=858770 $Y=749415
X972 87 28301 18 45 28892 NAND2X1 $T=860320 749805 1 0 $X=859890 $Y=745250
X973 53 28021 18 45 28824 NAND2X1 $T=864800 828205 0 180 $X=861570 $Y=823650
X974 53 29136 18 45 28936 NAND2X1 $T=866480 843885 0 0 $X=866050 $Y=843495
X975 59 29335 18 45 28290 NAND2X1 $T=872640 828205 1 0 $X=872210 $Y=823650
X976 53 29333 18 45 29596 NAND2X1 $T=884960 851725 1 180 $X=881730 $Y=851335
X977 87 99 18 45 29776 NAND2X1 $T=888880 749805 1 0 $X=888450 $Y=745250
X978 47 29930 18 45 29644 NAND2X1 $T=893360 867405 0 0 $X=892930 $Y=867015
X979 30242 49 18 45 30206 NAND2X1 $T=906240 851725 1 180 $X=903010 $Y=851335
X980 53 30242 18 45 30167 NAND2X1 $T=904000 836045 1 0 $X=903570 $Y=831490
X981 47 30396 18 45 30254 NAND2X1 $T=907920 867405 0 0 $X=907490 $Y=867015
X982 87 100 18 45 112 NAND2X1 $T=908480 741965 1 0 $X=908050 $Y=737410
X983 30432 83 18 45 30431 NAND2X1 $T=912400 741965 1 180 $X=909170 $Y=741575
X984 46 30396 18 45 30304 NAND2X1 $T=913520 867405 1 180 $X=910290 $Y=867015
X985 47 30462 18 45 30540 NAND2X1 $T=913520 867405 0 0 $X=913090 $Y=867015
X986 30651 30556 18 45 30637 NAND2X1 $T=919680 836045 0 180 $X=916450 $Y=831490
X987 30690 49 18 45 30636 NAND2X1 $T=921360 859565 1 180 $X=918130 $Y=859175
X988 59 30128 18 45 30712 NAND2X1 $T=919680 836045 1 0 $X=919250 $Y=831490
X989 30799 30772 18 45 30782 NAND2X1 $T=925280 843885 1 180 $X=922050 $Y=843495
X990 30865 30712 18 45 30844 NAND2X1 $T=927520 836045 1 180 $X=924290 $Y=835655
X991 83 30770 18 45 30872 NAND2X1 $T=926400 741965 0 0 $X=925970 $Y=741575
X992 30930 49 18 45 30912 NAND2X1 $T=929760 859565 1 180 $X=926530 $Y=859175
X993 87 30289 18 45 30829 NAND2X1 $T=931440 749805 0 180 $X=928210 $Y=745250
X994 53 30930 18 45 30799 NAND2X1 $T=934240 851725 0 180 $X=931010 $Y=847170
X995 47 30833 18 45 31247 NAND2X1 $T=939840 867405 1 180 $X=936610 $Y=867015
X996 31376 31440 18 45 31416 NAND2X1 $T=941520 757645 0 0 $X=941090 $Y=757255
X997 31436 31184 18 45 31417 NAND2X1 $T=944320 836045 0 180 $X=941090 $Y=831490
X998 47 29446 18 45 31415 NAND2X1 $T=944320 867405 0 180 $X=941090 $Y=862850
X999 119 110 18 45 31318 NAND2X1 $T=944880 734125 0 0 $X=944450 $Y=733735
X1000 31684 128 18 45 31356 NAND2X1 $T=950480 749805 1 0 $X=950050 $Y=745250
X1001 31463 130 18 45 31701 NAND2X1 $T=950480 757645 1 0 $X=950050 $Y=753090
X1002 59 30892 18 45 31704 NAND2X1 $T=954960 836045 0 180 $X=951730 $Y=831490
X1003 53 31735 18 45 31436 NAND2X1 $T=954960 836045 1 180 $X=951730 $Y=835655
X1004 130 133 18 45 31780 NAND2X1 $T=953280 749805 0 0 $X=952850 $Y=749415
X1005 31748 135 18 45 31814 NAND2X1 $T=954960 796845 1 0 $X=954530 $Y=792290
X1006 53 31514 18 45 31669 NAND2X1 $T=954960 851725 0 0 $X=954530 $Y=851335
X1007 137 136 18 45 31270 NAND2X1 $T=959440 734125 0 180 $X=956210 $Y=729570
X1008 31741 31929 18 45 31784 NAND2X1 $T=957760 820365 1 0 $X=957330 $Y=815810
X1009 31955 31644 18 45 31938 NAND2X1 $T=961680 781165 0 180 $X=958450 $Y=776610
X1010 31912 31684 18 45 31954 NAND2X1 $T=962240 749805 1 180 $X=959010 $Y=749415
X1011 31918 31914 18 45 31988 NAND2X1 $T=963360 820365 0 180 $X=960130 $Y=815810
X1012 32011 31779 18 45 32007 NAND2X1 $T=963920 757645 0 180 $X=960690 $Y=753090
X1013 46 32055 18 45 31975 NAND2X1 $T=962240 867405 0 0 $X=961810 $Y=867015
X1014 31954 32007 18 45 32086 NAND2X1 $T=966720 757645 0 180 $X=963490 $Y=753090
X1015 32107 32106 18 45 31929 NAND2X1 $T=965040 812525 0 0 $X=964610 $Y=812135
X1016 32108 31882 18 45 32124 NAND2X1 $T=965040 820365 1 0 $X=964610 $Y=815810
X1017 32184 32229 18 45 32107 NAND2X1 $T=967840 820365 1 0 $X=967410 $Y=815810
X1018 32245 130 18 45 32317 NAND2X1 $T=971200 749805 0 0 $X=970770 $Y=749415
X1019 32352 32153 18 45 32297 NAND2X1 $T=974560 804685 1 180 $X=971330 $Y=804295
X1020 32178 123 18 45 32350 NAND2X1 $T=972320 765485 0 0 $X=971890 $Y=765095
X1021 32386 31862 18 45 32133 NAND2X1 $T=975680 773325 0 180 $X=972450 $Y=768770
X1022 32317 32105 18 45 32349 NAND2X1 $T=976800 749805 1 180 $X=973570 $Y=749415
X1023 31416 126 18 45 32424 NAND2X1 $T=977360 757645 0 180 $X=974130 $Y=753090
X1024 32515 32264 18 45 32404 NAND2X1 $T=979600 781165 1 180 $X=976370 $Y=780775
X1025 31826 31863 18 45 32497 NAND2X1 $T=976800 796845 0 0 $X=976370 $Y=796455
X1026 32371 135 18 45 32516 NAND2X1 $T=977360 789005 0 0 $X=976930 $Y=788615
X1027 32585 145 18 45 32564 NAND2X1 $T=981840 734125 1 180 $X=978610 $Y=733735
X1028 146 147 18 45 32585 NAND2X1 $T=980720 734125 1 0 $X=980290 $Y=729570
X1029 31826 32517 18 45 32709 NAND2X1 $T=986320 820365 0 180 $X=983090 $Y=815810
X1030 32108 135 18 45 32675 NAND2X1 $T=986880 820365 1 180 $X=983650 $Y=819975
X1031 32515 32089 18 45 32780 NAND2X1 $T=985760 781165 0 0 $X=985330 $Y=780775
X1032 32145 32756 18 45 32708 NAND2X1 $T=989680 796845 0 180 $X=986450 $Y=792290
X1033 32108 32089 18 45 32873 NAND2X1 $T=988560 781165 0 0 $X=988130 $Y=780775
X1034 46 32318 18 45 32996 NAND2X1 $T=994720 867405 0 180 $X=991490 $Y=862850
X1035 32914 32198 18 45 33074 NAND2X1 $T=996960 820365 0 180 $X=993730 $Y=815810
X1036 47 33153 18 45 32717 NAND2X1 $T=995840 875245 1 0 $X=995410 $Y=870690
X1037 152 153 18 45 33304 NAND2X1 $T=1002000 734125 0 0 $X=1001570 $Y=733735
X1038 33361 83 18 45 33339 NAND2X1 $T=1004800 765485 0 180 $X=1001570 $Y=760930
X1039 33264 33413 18 45 33505 NAND2X1 $T=1007040 836045 0 0 $X=1006610 $Y=835655
X1040 83 156 18 45 33545 NAND2X1 $T=1008160 765485 1 0 $X=1007730 $Y=760930
X1041 87 33148 18 45 33524 NAND2X1 $T=1011520 765485 1 180 $X=1008290 $Y=765095
X1042 33581 33620 18 45 33600 NAND2X1 $T=1009840 836045 0 0 $X=1009410 $Y=835655
X1043 152 157 18 45 33615 NAND2X1 $T=1010400 734125 0 0 $X=1009970 $Y=733735
X1044 53 33247 18 45 33581 NAND2X1 $T=1015440 836045 1 180 $X=1012210 $Y=835655
X1045 47 33773 18 45 33900 NAND2X1 $T=1019920 867405 1 0 $X=1019490 $Y=862850
X1046 33933 83 18 45 33918 NAND2X1 $T=1023280 773325 0 180 $X=1020050 $Y=768770
X1047 47 31515 18 45 34052 NAND2X1 $T=1027760 859565 1 180 $X=1024530 $Y=859175
X1048 87 34071 18 45 34127 NAND2X1 $T=1027760 773325 0 0 $X=1027330 $Y=772935
X1049 53 34205 18 45 34185 NAND2X1 $T=1029440 843885 0 0 $X=1029010 $Y=843495
X1050 53 34258 18 45 34240 NAND2X1 $T=1031120 851725 1 0 $X=1030690 $Y=847170
X1051 59 34167 18 45 34257 NAND2X1 $T=1031680 836045 1 0 $X=1031250 $Y=831490
X1052 34240 34257 18 45 34324 NAND2X1 $T=1036720 851725 0 180 $X=1033490 $Y=847170
X1053 34258 49 18 45 34480 NAND2X1 $T=1039520 867405 1 0 $X=1039090 $Y=862850
X1054 152 34577 18 45 34561 NAND2X1 $T=1041760 741965 0 0 $X=1041330 $Y=741575
X1055 87 149 18 45 34563 NAND2X1 $T=1044560 757645 0 180 $X=1041330 $Y=753090
X1056 34578 83 18 45 34322 NAND2X1 $T=1044560 773325 0 180 $X=1041330 $Y=768770
X1057 152 166 18 45 34713 NAND2X1 $T=1052400 734125 0 0 $X=1051970 $Y=733735
X1058 87 34514 18 45 34877 NAND2X1 $T=1055200 773325 0 180 $X=1051970 $Y=768770
X1059 59 34862 18 45 34914 NAND2X1 $T=1053520 828205 1 0 $X=1053090 $Y=823650
X1060 34892 34914 18 45 34912 NAND2X1 $T=1053520 828205 0 0 $X=1053090 $Y=827815
X1061 34936 49 18 45 34863 NAND2X1 $T=1056880 859565 0 180 $X=1053650 $Y=855010
X1062 87 34529 18 45 34958 NAND2X1 $T=1058000 749805 1 180 $X=1054770 $Y=749415
X1063 53 34530 18 45 34892 NAND2X1 $T=1059120 828205 1 180 $X=1055890 $Y=827815
X1064 59 34935 18 45 35059 NAND2X1 $T=1059120 828205 0 0 $X=1058690 $Y=827815
X1065 47 35397 18 45 35170 NAND2X1 $T=1068640 875245 0 0 $X=1068210 $Y=874855
X1066 47 34736 18 45 35559 NAND2X1 $T=1076480 875245 0 180 $X=1073250 $Y=870690
X1067 35569 35622 18 45 35542 NAND2X1 $T=1074800 765485 1 0 $X=1074370 $Y=760930
X1068 35662 35700 18 45 35570 NAND2X1 $T=1077040 781165 1 0 $X=1076610 $Y=776610
X1069 35595 35762 18 45 35661 NAND2X1 $T=1078720 773325 0 0 $X=1078290 $Y=772935
X1070 35756 35674 18 45 35738 NAND2X1 $T=1081520 789005 0 180 $X=1078290 $Y=784450
X1071 35755 35750 18 45 35762 NAND2X1 $T=1079840 773325 1 0 $X=1079410 $Y=768770
X1072 35843 35619 18 45 35819 NAND2X1 $T=1083760 843885 0 180 $X=1080530 $Y=839330
X1073 35855 35696 18 45 35735 NAND2X1 $T=1084320 789005 0 180 $X=1081090 $Y=784450
X1074 35875 35912 18 45 35543 NAND2X1 $T=1083200 789005 0 0 $X=1082770 $Y=788615
X1075 59 35757 18 45 35911 NAND2X1 $T=1083760 820365 0 0 $X=1083330 $Y=819975
X1076 35927 35963 18 45 35558 NAND2X1 $T=1084880 757645 1 0 $X=1084450 $Y=753090
X1077 35965 35911 18 45 35964 NAND2X1 $T=1088240 828205 0 180 $X=1085010 $Y=823650
X1078 36229 35958 18 45 36086 NAND2X1 $T=1096080 757645 1 180 $X=1092850 $Y=757255
X1079 35755 36067 18 45 36130 NAND2X1 $T=1097200 749805 1 180 $X=1093970 $Y=749415
X1080 36138 33544 18 45 35875 NAND2X1 $T=1096080 789005 0 0 $X=1095650 $Y=788615
X1081 59 36011 18 45 36484 NAND2X1 $T=1105040 820365 0 180 $X=1101810 $Y=815810
X1082 36312 49 18 45 36053 NAND2X1 $T=1102240 843885 1 0 $X=1101810 $Y=839330
X1083 36068 36567 18 45 36623 NAND2X1 $T=1107280 749805 1 0 $X=1106850 $Y=745250
X1084 36666 36484 18 45 36651 NAND2X1 $T=1111200 820365 0 180 $X=1107970 $Y=815810
X1085 36311 49 18 45 36654 NAND2X1 $T=1108400 843885 1 0 $X=1107970 $Y=839330
X1086 36350 35755 18 45 36696 NAND2X1 $T=1112880 749805 0 180 $X=1109650 $Y=745250
X1087 36728 36103 18 45 36593 NAND2X1 $T=1113440 773325 1 180 $X=1110210 $Y=772935
X1088 35750 36461 18 45 36697 NAND2X1 $T=1114000 781165 1 180 $X=1110770 $Y=780775
X1089 33544 35963 18 45 36744 NAND2X1 $T=1114560 789005 1 180 $X=1111330 $Y=788615
X1090 59 36618 18 45 36758 NAND2X1 $T=1112320 812525 0 0 $X=1111890 $Y=812135
X1091 53 36311 18 45 36666 NAND2X1 $T=1115120 828205 1 180 $X=1111890 $Y=827815
X1092 35750 36744 18 45 36614 NAND2X1 $T=1115680 796845 0 180 $X=1112450 $Y=792290
X1093 36177 36836 18 45 36815 NAND2X1 $T=1114000 781165 1 0 $X=1113570 $Y=776610
X1094 36652 36758 18 45 36861 NAND2X1 $T=1115120 828205 0 0 $X=1114690 $Y=827815
X1095 36859 36698 18 45 36860 NAND2X1 $T=1120720 757645 1 180 $X=1117490 $Y=757255
X1096 59 36935 18 45 37285 NAND2X1 $T=1129680 812525 0 180 $X=1126450 $Y=807970
X1097 53 37401 18 45 37358 NAND2X1 $T=1129680 820365 0 0 $X=1129250 $Y=819975
X1098 37401 49 18 45 37373 NAND2X1 $T=1133600 836045 1 180 $X=1130370 $Y=835655
X1099 83 187 18 45 37830 NAND2X1 $T=1143680 734125 0 0 $X=1143250 $Y=733735
X1100 47 37639 18 45 37850 NAND2X1 $T=1147040 851725 0 180 $X=1143810 $Y=847170
X1101 47 37932 18 45 36041 NAND2X1 $T=1146480 859565 1 0 $X=1146050 $Y=855010
X1102 59 37814 18 45 38037 NAND2X1 $T=1150400 789005 0 0 $X=1149970 $Y=788615
X1103 38107 37916 18 45 38106 NAND2X1 $T=1155440 812525 1 180 $X=1152210 $Y=812135
X1104 47 36498 18 45 38108 NAND2X1 $T=1155440 836045 0 180 $X=1152210 $Y=831490
X1105 38145 38037 18 45 38127 NAND2X1 $T=1156000 789005 1 180 $X=1152770 $Y=788615
X1106 38129 49 18 45 38109 NAND2X1 $T=1156000 828205 1 180 $X=1152770 $Y=827815
X1107 38159 38198 18 45 38182 NAND2X1 $T=1154880 804685 1 0 $X=1154450 $Y=800130
X1108 59 37949 18 45 38286 NAND2X1 $T=1161040 789005 0 180 $X=1157810 $Y=784450
X1109 38268 49 18 45 38312 NAND2X1 $T=1158800 828205 1 0 $X=1158370 $Y=823650
X1110 47 38330 18 45 36808 NAND2X1 $T=1158800 836045 1 0 $X=1158370 $Y=831490
X1111 46 38050 18 45 38328 NAND2X1 $T=1162160 843885 0 180 $X=1158930 $Y=839330
X1112 59 193 18 45 38198 NAND2X1 $T=1163280 765485 1 0 $X=1162850 $Y=760930
X1113 47 37971 18 45 38485 NAND2X1 $T=1166640 828205 1 180 $X=1163410 $Y=827815
X1114 59 38371 18 45 38788 NAND2X1 $T=1173360 749805 1 0 $X=1172930 $Y=745250
X1115 38841 49 18 45 38807 NAND2X1 $T=1177280 804685 0 180 $X=1174050 $Y=800130
X1116 47 38895 18 45 38438 NAND2X1 $T=1176160 836045 1 0 $X=1175730 $Y=831490
X1117 53 38913 18 45 38825 NAND2X1 $T=1176720 789005 0 0 $X=1176290 $Y=788615
X1118 53 38841 18 45 38805 NAND2X1 $T=1179520 789005 0 0 $X=1179090 $Y=788615
X1119 39003 49 18 45 38929 NAND2X1 $T=1182880 804685 0 180 $X=1179650 $Y=800130
X1120 59 195 18 45 39002 NAND2X1 $T=1180640 741965 0 0 $X=1180210 $Y=741575
X1121 59 197 18 45 39432 NAND2X1 $T=1192400 741965 1 0 $X=1191970 $Y=737410
X1122 39057 49 18 45 39512 NAND2X1 $T=1197440 796845 0 180 $X=1194210 $Y=792290
X1123 46 38895 18 45 39597 NAND2X1 $T=1199680 828205 0 180 $X=1196450 $Y=823650
X1124 47 39177 18 45 39738 NAND2X1 $T=1203600 804685 0 180 $X=1200370 $Y=800130
X1125 47 39761 18 45 39565 NAND2X1 $T=1200800 820365 1 0 $X=1200370 $Y=815810
X1126 46 39857 18 45 39469 NAND2X1 $T=1203600 804685 1 0 $X=1203170 $Y=800130
X1127 46 39761 18 45 39450 NAND2X1 $T=1206400 820365 0 180 $X=1203170 $Y=815810
X1128 46 39212 18 45 39915 NAND2X1 $T=1208640 789005 1 180 $X=1205410 $Y=788615
X1129 40139 49 18 45 40124 NAND2X1 $T=1214800 765485 0 180 $X=1211570 $Y=760930
X1130 53 40139 18 45 40026 NAND2X1 $T=1216480 741965 0 180 $X=1213250 $Y=737410
X1131 199 49 18 45 40161 NAND2X1 $T=1216480 749805 1 180 $X=1213250 $Y=749415
X1132 40176 40161 18 45 40177 NAND2X1 $T=1216480 781165 0 180 $X=1213250 $Y=776610
X1133 46 40178 18 45 40176 NAND2X1 $T=1217040 789005 1 180 $X=1213810 $Y=788615
X1134 39934 49 18 45 40228 NAND2X1 $T=1218160 773325 1 180 $X=1214930 $Y=772935
X1135 53 40552 18 45 40282 NAND2X1 $T=1224320 741965 1 0 $X=1223890 $Y=737410
X1136 47 40568 18 45 40089 NAND2X1 $T=1225440 796845 1 0 $X=1225010 $Y=792290
X1137 40552 49 18 45 40611 NAND2X1 $T=1227680 781165 1 0 $X=1227250 $Y=776610
X1138 46 40568 18 45 40864 NAND2X1 $T=1236080 781165 0 180 $X=1232850 $Y=776610
X1139 59 205 18 45 41043 NAND2X1 $T=1238320 734125 1 0 $X=1237890 $Y=729570
X1140 53 41125 18 45 41104 NAND2X1 $T=1240000 765485 1 0 $X=1239570 $Y=760930
X1141 41104 41043 18 45 41124 NAND2X1 $T=1243360 749805 0 180 $X=1240130 $Y=745250
X1142 41125 49 18 45 41166 NAND2X1 $T=1244480 781165 0 180 $X=1241250 $Y=776610
X1143 206 49 18 45 41207 NAND2X1 $T=1245600 765485 0 180 $X=1242370 $Y=760930
X1144 46 41247 18 45 41227 NAND2X1 $T=1243360 765485 0 0 $X=1242930 $Y=765095
X1145 207 49 18 45 41265 NAND2X1 $T=1247280 734125 0 180 $X=1244050 $Y=729570
X1146 46 41345 18 45 41344 NAND2X1 $T=1246720 741965 0 0 $X=1246290 $Y=741575
X1383 18 45 26469 49 26751 ICV_68 $T=792000 796845 0 0 $X=791570 $Y=796455
X1384 18 45 46 27004 26861 ICV_68 $T=799280 820365 0 0 $X=798850 $Y=819975
X1385 18 45 27669 73 27688 ICV_68 $T=821120 734125 0 0 $X=820690 $Y=733735
X1386 18 45 83 28301 28285 ICV_68 $T=840720 749805 1 0 $X=840290 $Y=745250
X1387 18 45 53 28221 28253 ICV_68 $T=844640 843885 0 0 $X=844210 $Y=843495
X1388 18 45 59 28478 28355 ICV_68 $T=846320 812525 1 0 $X=845890 $Y=807970
X1389 18 45 29136 49 29173 ICV_68 $T=867040 851725 1 0 $X=866610 $Y=847170
X1390 18 45 59 30980 31184 ICV_68 $T=934240 836045 1 0 $X=933810 $Y=831490
X1391 18 45 31817 32389 32352 ICV_68 $T=971760 812525 1 0 $X=971330 $Y=807970
X1392 18 45 31914 31882 32518 ICV_68 $T=976240 820365 0 0 $X=975810 $Y=819975
X1393 18 45 59 33075 33013 ICV_68 $T=994720 836045 0 0 $X=994290 $Y=835655
X1394 18 45 83 149 34500 ICV_68 $T=1038400 773325 0 0 $X=1037970 $Y=772935
X1395 18 45 36055 36051 36024 ICV_68 $T=1090480 781165 1 0 $X=1090050 $Y=776610
X1396 18 45 46 36265 36139 ICV_68 $T=1093280 859565 0 0 $X=1092850 $Y=859175
X1397 18 45 87 184 36989 ICV_68 $T=1122400 734125 0 0 $X=1121970 $Y=733735
X1398 18 45 53 38268 38145 ICV_68 $T=1156000 789005 0 0 $X=1155570 $Y=788615
X1399 18 45 46 208 41302 ICV_68 $T=1247840 781165 0 0 $X=1247410 $Y=780775
X1400 18 46 24868 24783 45 ICV_69 $T=735440 749805 1 0 $X=735010 $Y=745250
X1401 18 25602 58 25642 45 ICV_69 $T=757280 741965 0 0 $X=756850 $Y=741575
X1402 18 26115 26164 26147 45 ICV_69 $T=772400 773325 0 0 $X=771970 $Y=772935
X1403 18 25704 49 26234 45 ICV_69 $T=776880 796845 1 0 $X=776450 $Y=792290
X1404 18 59 63 26164 45 ICV_69 $T=781360 749805 1 0 $X=780930 $Y=745250
X1405 18 46 26310 26332 45 ICV_69 $T=781360 836045 1 0 $X=780930 $Y=831490
X1406 18 26570 49 26487 45 ICV_69 $T=787520 796845 0 0 $X=787090 $Y=796455
X1407 18 26808 26845 26828 45 ICV_69 $T=793680 749805 0 0 $X=793250 $Y=749415
X1408 18 53 26966 26826 45 ICV_69 $T=797600 789005 1 0 $X=797170 $Y=784450
X1409 18 26946 26983 26979 45 ICV_69 $T=798160 781165 0 0 $X=797730 $Y=780775
X1410 18 53 27384 27748 45 ICV_69 $T=822800 789005 1 0 $X=822370 $Y=784450
X1411 18 59 27852 27810 45 ICV_69 $T=825040 781165 1 0 $X=824610 $Y=776610
X1412 18 28170 28208 28192 45 ICV_69 $T=836800 820365 0 0 $X=836370 $Y=819975
X1413 18 59 28665 28208 45 ICV_69 $T=851920 820365 1 0 $X=851490 $Y=815810
X1414 18 28824 28871 28848 45 ICV_69 $T=857520 828205 1 0 $X=857090 $Y=823650
X1415 18 28936 28978 28957 45 ICV_69 $T=860320 836045 0 0 $X=859890 $Y=835655
X1416 18 59 29295 29427 45 ICV_69 $T=874880 820365 0 0 $X=874450 $Y=819975
X1417 18 59 30031 30096 45 ICV_69 $T=897840 820365 1 0 $X=897410 $Y=815810
X1418 18 53 30690 30651 45 ICV_69 $T=916880 836045 0 0 $X=916450 $Y=835655
X1419 18 46 30833 30709 45 ICV_69 $T=921920 867405 0 0 $X=921490 $Y=867015
X1420 18 53 30998 30865 45 ICV_69 $T=927520 836045 0 0 $X=927090 $Y=835655
X1421 18 31246 31296 31271 45 ICV_69 $T=935920 749805 1 0 $X=935490 $Y=745250
X1422 18 31270 31318 31295 45 ICV_69 $T=936480 734125 1 0 $X=936050 $Y=729570
X1423 18 47 31441 30255 45 ICV_69 $T=939840 875245 1 0 $X=939410 $Y=870690
X1424 18 30998 49 31571 45 ICV_69 $T=944320 851725 0 0 $X=943890 $Y=851335
X1425 18 31649 31686 31668 45 ICV_69 $T=947680 828205 1 0 $X=947250 $Y=823650
X1426 18 31741 31817 31783 45 ICV_69 $T=952160 812525 0 0 $X=951730 $Y=812135
X1427 18 135 31862 31782 45 ICV_69 $T=967280 781165 0 0 $X=966850 $Y=780775
X1428 18 32262 32297 32276 45 ICV_69 $T=968400 796845 1 0 $X=967970 $Y=792290
X1429 18 32153 31882 32145 45 ICV_69 $T=980720 796845 1 0 $X=980290 $Y=792290
X1430 18 32623 31882 32763 45 ICV_69 $T=983520 812525 1 0 $X=983090 $Y=807970
X1431 18 59 33397 33413 45 ICV_69 $T=1002560 836045 0 0 $X=1002130 $Y=835655
X1432 18 33247 49 33525 45 ICV_69 $T=1009280 859565 1 0 $X=1008850 $Y=855010
X1433 18 59 33983 34072 45 ICV_69 $T=1023840 836045 1 0 $X=1023410 $Y=831490
X1434 18 34530 49 34753 45 ICV_69 $T=1046240 851725 0 0 $X=1045810 $Y=851335
X1435 18 46 35061 34937 45 ICV_69 $T=1056880 859565 0 0 $X=1056450 $Y=859175
X1436 18 83 170 35103 45 ICV_69 $T=1059120 741965 0 0 $X=1058690 $Y=741575
X1437 18 35040 49 35178 45 ICV_69 $T=1061360 859565 0 0 $X=1060930 $Y=859175
X1438 18 35700 35755 36293 45 ICV_69 $T=1094400 796845 1 0 $X=1093970 $Y=792290
X1439 18 87 34913 179 45 ICV_69 $T=1102800 734125 0 0 $X=1102370 $Y=733735
X1440 18 36641 36691 36399 45 ICV_69 $T=1107280 749805 0 0 $X=1106850 $Y=749415
X1441 18 36757 36793 36601 45 ICV_69 $T=1114000 781165 0 0 $X=1113570 $Y=780775
X1442 18 47 38050 37463 45 ICV_69 $T=1148720 851725 0 0 $X=1148290 $Y=851335
X1443 18 53 38129 38107 45 ICV_69 $T=1150960 828205 1 0 $X=1150530 $Y=823650
X1444 18 38964 39002 38985 45 ICV_69 $T=1177840 749805 0 0 $X=1177410 $Y=749415
X1445 18 46 39041 38893 45 ICV_69 $T=1178960 820365 0 0 $X=1178530 $Y=819975
X1446 18 46 39177 39020 45 ICV_69 $T=1182880 804685 1 0 $X=1182450 $Y=800130
X1447 18 59 196 39325 45 ICV_69 $T=1187920 741965 0 0 $X=1187490 $Y=741575
X1448 18 38913 49 39344 45 ICV_69 $T=1188480 796845 0 0 $X=1188050 $Y=796455
X1449 18 46 40413 40267 45 ICV_69 $T=1218720 765485 1 0 $X=1218290 $Y=760930
X1450 18 46 41024 40863 45 ICV_69 $T=1235520 741965 1 0 $X=1235090 $Y=737410
X1451 18 47 41345 41320 45 ICV_69 $T=1244480 757645 0 0 $X=1244050 $Y=757255
X1452 18 47 41247 41258 45 ICV_69 $T=1244480 781165 1 0 $X=1244050 $Y=776610
X1453 27804 74 18 45 27830 NOR2X1 $T=826720 741965 1 0 $X=826290 $Y=737410
X1454 85 28334 18 45 28335 NOR2X1 $T=843520 734125 0 0 $X=843090 $Y=733735
X1455 31392 31435 18 45 30771 NOR2X1 $T=941520 789005 1 0 $X=941090 $Y=784450
X1456 31513 31545 18 45 31532 NOR2X1 $T=944880 765485 0 0 $X=944450 $Y=765095
X1457 31529 31555 18 45 30308 NOR2X1 $T=945440 781165 1 0 $X=945010 $Y=776610
X1458 31668 31715 18 45 29350 NOR2X1 $T=950480 773325 0 0 $X=950050 $Y=772935
X1459 31716 31748 18 45 31598 NOR2X1 $T=951600 789005 0 0 $X=951170 $Y=788615
X1460 123 31463 18 45 31779 NOR2X1 $T=956080 749805 0 180 $X=952850 $Y=745250
X1461 31667 31864 18 45 31850 NOR2X1 $T=955520 804685 0 0 $X=955090 $Y=804295
X1462 133 126 18 45 31804 NOR2X1 $T=958880 749805 0 180 $X=955650 $Y=745250
X1463 110 126 18 45 31733 NOR2X1 $T=959440 757645 1 180 $X=956210 $Y=757255
X1464 31882 31644 18 45 31864 NOR2X1 $T=957760 812525 0 0 $X=957330 $Y=812135
X1465 123 138 18 45 31684 NOR2X1 $T=958880 749805 1 0 $X=958450 $Y=745250
X1466 31882 31667 18 45 31825 NOR2X1 $T=959440 796845 1 0 $X=959010 $Y=792290
X1467 31684 31779 18 45 31973 NOR2X1 $T=960000 757645 0 0 $X=959570 $Y=757255
X1468 133 130 18 45 31912 NOR2X1 $T=965040 749805 1 180 $X=961810 $Y=749415
X1469 31988 31850 18 45 32038 NOR2X1 $T=962240 812525 0 0 $X=961810 $Y=812135
X1470 32106 32054 18 45 32009 NOR2X1 $T=966720 812525 0 180 $X=963490 $Y=807970
X1471 32087 32122 18 45 31974 NOR2X1 $T=964480 781165 1 0 $X=964050 $Y=776610
X1472 32089 32145 18 45 31716 NOR2X1 $T=965040 789005 0 0 $X=964610 $Y=788615
X1473 110 31973 18 45 32263 NOR2X1 $T=969520 757645 0 0 $X=969090 $Y=757255
X1474 32106 32275 18 45 32087 NOR2X1 $T=969520 781165 1 0 $X=969090 $Y=776610
X1475 31734 32315 18 45 32296 NOR2X1 $T=970640 765485 1 0 $X=970210 $Y=760930
X1476 31914 32316 18 45 32101 NOR2X1 $T=970640 820365 0 0 $X=970210 $Y=819975
X1477 144 125 18 45 32355 NOR2X1 $T=975120 734125 1 180 $X=971890 $Y=733735
X1478 32108 32264 18 45 31685 NOR2X1 $T=973440 820365 0 0 $X=973010 $Y=819975
X1479 32460 32496 18 45 32477 NOR2X1 $T=976240 757645 0 0 $X=975810 $Y=757255
X1480 31862 31667 18 45 32316 NOR2X1 $T=976240 804685 0 0 $X=975810 $Y=804295
X1481 32389 135 18 45 31914 NOR2X1 $T=976800 820365 1 0 $X=976370 $Y=815810
X1482 32472 147 18 45 32600 NOR2X1 $T=979600 749805 0 0 $X=979170 $Y=749415
X1483 32089 32153 18 45 31826 NOR2X1 $T=984080 796845 1 180 $X=980850 $Y=796455
X1484 31882 32153 18 45 32515 NOR2X1 $T=984640 789005 1 180 $X=981410 $Y=788615
X1485 32086 32724 18 45 148 NOR2X1 $T=985200 749805 0 0 $X=984770 $Y=749415
X1486 31862 32517 18 45 32264 NOR2X1 $T=986320 804685 0 0 $X=985890 $Y=804295
X1487 31882 32108 18 45 32198 NOR2X1 $T=986320 828205 1 0 $X=985890 $Y=823650
X1488 32038 33112 18 45 32994 NOR2X1 $T=997520 812525 1 0 $X=997090 $Y=807970
X1489 35437 35477 18 45 30997 NOR2X1 $T=1070880 773325 0 0 $X=1070450 $Y=772935
X1490 35558 35600 18 45 35584 NOR2X1 $T=1074240 749805 0 0 $X=1073810 $Y=749415
X1491 35585 35618 18 45 35219 NOR2X1 $T=1074800 796845 1 0 $X=1074370 $Y=792290
X1492 35696 35569 18 45 35600 NOR2X1 $T=1079840 749805 1 180 $X=1076610 $Y=749415
X1493 35584 35754 18 45 35753 NOR2X1 $T=1079840 749805 0 0 $X=1079410 $Y=749415
X1494 178 34714 18 45 35696 NOR2X1 $T=1083200 765485 1 180 $X=1079970 $Y=765095
X1495 174 35750 18 45 35884 NOR2X1 $T=1083760 741965 0 0 $X=1083330 $Y=741575
X1496 35958 35647 18 45 35700 NOR2X1 $T=1087680 757645 1 180 $X=1084450 $Y=757255
X1497 35979 36010 18 45 35842 NOR2X1 $T=1086560 796845 1 0 $X=1086130 $Y=792290
X1498 152 83 18 45 87 NOR2X1 $T=1087680 734125 1 0 $X=1087250 $Y=729570
X1499 36051 35912 18 45 35979 NOR2X1 $T=1090480 789005 1 180 $X=1087250 $Y=788615
X1500 35750 34714 18 45 35874 NOR2X1 $T=1089920 773325 1 0 $X=1089490 $Y=768770
X1501 178 36103 18 45 36050 NOR2X1 $T=1090480 765485 0 0 $X=1090050 $Y=765095
X1502 36177 36138 18 45 36158 NOR2X1 $T=1094400 789005 0 180 $X=1091170 $Y=784450
X1503 35700 36158 18 45 36010 NOR2X1 $T=1091600 796845 1 0 $X=1091170 $Y=792290
X1504 35963 36230 18 45 36055 NOR2X1 $T=1097200 781165 0 180 $X=1093970 $Y=776610
X1505 35756 36138 18 45 36248 NOR2X1 $T=1094400 789005 1 0 $X=1093970 $Y=784450
X1506 178 35680 18 45 36177 NOR2X1 $T=1096080 773325 0 0 $X=1095650 $Y=772935
X1507 36230 36328 18 45 36138 NOR2X1 $T=1096640 781165 0 0 $X=1096210 $Y=780775
X1508 36310 35518 18 45 35958 NOR2X1 $T=1100000 757645 0 0 $X=1099570 $Y=757255
X1509 33544 35518 18 45 36255 NOR2X1 $T=1102800 765485 1 180 $X=1099570 $Y=765095
X1510 178 36495 18 45 36344 NOR2X1 $T=1102240 741965 1 0 $X=1101810 $Y=737410
X1511 33544 36461 18 45 35647 NOR2X1 $T=1104480 749805 1 0 $X=1104050 $Y=745250
X1512 35963 36103 18 45 35755 NOR2X1 $T=1105040 757645 0 0 $X=1104610 $Y=757255
X1513 36461 36248 18 45 36589 NOR2X1 $T=1108960 781165 0 180 $X=1105730 $Y=776610
X1514 36461 174 18 45 36495 NOR2X1 $T=1110080 741965 0 180 $X=1106850 $Y=737410
X1515 35963 174 18 45 36229 NOR2X1 $T=1107840 757645 0 0 $X=1107410 $Y=757255
X1516 36797 36623 18 45 36782 NOR2X1 $T=1115680 749805 0 180 $X=1112450 $Y=745250
X1517 35750 36691 18 45 36797 NOR2X1 $T=1116240 757645 0 180 $X=1113010 $Y=753090
X1518 36589 36848 18 45 36818 NOR2X1 $T=1114000 773325 1 0 $X=1113570 $Y=768770
X1519 18 45 59 64 26453 ICV_81 $T=781920 749805 0 0 $X=781490 $Y=749415
X1520 18 45 59 26898 26917 ICV_81 $T=795920 749805 1 0 $X=795490 $Y=745250
X1521 18 45 28191 28355 28336 ICV_81 $T=841280 812525 1 0 $X=840850 $Y=807970
X1522 18 45 59 29059 28871 ICV_81 $T=862000 820365 0 0 $X=861570 $Y=819975
X1523 18 45 46 30462 30303 ICV_81 $T=907920 859565 1 0 $X=907490 $Y=855010
X1524 18 45 30830 83 30680 ICV_81 $T=922480 765485 0 0 $X=922050 $Y=765095
X1525 18 45 31295 120 31376 ICV_81 $T=938160 741965 1 0 $X=937730 $Y=737410
X1526 18 45 110 134 132 ICV_81 $T=951600 734125 1 0 $X=951170 $Y=729570
X1527 18 45 31814 31634 31838 ICV_81 $T=952720 796845 0 0 $X=952290 $Y=796455
X1528 18 45 31912 31943 31771 ICV_81 $T=956080 734125 0 0 $X=955650 $Y=733735
X1529 18 45 31587 31990 31955 ICV_81 $T=957760 781165 0 0 $X=957330 $Y=780775
X1530 18 45 32198 32153 32184 ICV_81 $T=966720 812525 1 0 $X=966290 $Y=807970
X1531 18 45 32198 32264 32023 ICV_81 $T=966720 828205 0 0 $X=966290 $Y=827815
X1532 18 45 47 32916 31726 ICV_81 $T=986880 867405 0 0 $X=986450 $Y=867015
X1533 18 45 32817 33013 32995 ICV_81 $T=989680 836045 0 0 $X=989250 $Y=835655
X1534 18 45 32970 49 33265 ICV_81 $T=997520 859565 0 0 $X=997090 $Y=859175
X1535 18 45 87 156 33356 ICV_81 $T=1005920 757645 1 0 $X=1005490 $Y=753090
X1536 18 45 83 34071 34051 ICV_81 $T=1022720 773325 0 0 $X=1022290 $Y=772935
X1537 18 45 53 34936 34817 ICV_81 $T=1052400 843885 1 0 $X=1051970 $Y=839330
X1538 18 45 152 175 35145 ICV_81 $T=1073120 734125 0 0 $X=1072690 $Y=733735
X1539 18 45 35661 35647 35436 ICV_81 $T=1074800 765485 0 0 $X=1074370 $Y=765095
X1540 18 45 53 35980 35843 ICV_81 $T=1083760 843885 1 0 $X=1083330 $Y=839330
X1541 18 45 36229 35647 36600 ICV_81 $T=1104480 773325 1 0 $X=1104050 $Y=768770
X1542 18 45 37256 49 37507 ICV_81 $T=1133600 836045 0 0 $X=1133170 $Y=835655
X1543 18 45 46 37639 37471 ICV_81 $T=1134720 851725 0 0 $X=1134290 $Y=851335
X1544 18 45 87 37377 37653 ICV_81 $T=1135840 741965 1 0 $X=1135410 $Y=737410
X1545 18 45 46 37971 37815 ICV_81 $T=1145360 836045 0 0 $X=1144930 $Y=835655
X1546 18 45 53 39364 39510 ICV_81 $T=1192400 757645 0 0 $X=1191970 $Y=757255
X1547 18 45 53 38910 39430 ICV_81 $T=1194640 765485 1 0 $X=1194210 $Y=760930
X1548 18 45 46 24257 24725 ICV_76 $T=733200 781165 1 0 $X=732770 $Y=776610
X1549 18 45 46 24256 24808 ICV_76 $T=735440 749805 0 0 $X=735010 $Y=749415
X1550 18 45 47 24256 24836 ICV_76 $T=739920 749805 1 0 $X=739490 $Y=745250
X1551 18 45 25413 49 25414 ICV_76 $T=752800 773325 0 0 $X=752370 $Y=772935
X1552 18 45 46 26023 26005 ICV_76 $T=769040 828205 0 0 $X=768610 $Y=827815
X1553 18 45 26199 26238 26218 ICV_76 $T=775760 757645 0 0 $X=775330 $Y=757255
X1554 18 45 47 26310 26229 ICV_76 $T=778000 820365 0 0 $X=777570 $Y=819975
X1555 18 45 47 26311 26140 ICV_76 $T=778000 836045 1 0 $X=777570 $Y=831490
X1556 18 45 26255 49 26416 ICV_76 $T=781920 812525 0 0 $X=781490 $Y=812135
X1557 18 45 59 65 26755 ICV_76 $T=792560 749805 1 0 $X=792130 $Y=745250
X1558 18 45 46 26311 26752 ICV_76 $T=792560 836045 1 0 $X=792130 $Y=831490
X1559 18 45 26966 49 27018 ICV_76 $T=800960 796845 1 0 $X=800530 $Y=792290
X1560 18 45 47 25372 27179 ICV_76 $T=805440 820365 1 0 $X=805010 $Y=815810
X1561 18 45 47 27236 26283 ICV_76 $T=807120 851725 1 0 $X=806690 $Y=847170
X1562 18 45 46 27409 27385 ICV_76 $T=812160 836045 0 0 $X=811730 $Y=835655
X1563 18 45 59 27251 27670 ICV_76 $T=821120 773325 0 0 $X=820690 $Y=772935
X1564 18 45 27748 27810 27785 ICV_76 $T=825040 781165 0 0 $X=824610 $Y=780775
X1565 18 45 53 28304 28286 ICV_76 $T=841280 843885 1 0 $X=840850 $Y=839330
X1566 18 45 83 92 28525 ICV_76 $T=848560 749805 1 0 $X=848130 $Y=745250
X1567 18 45 28021 49 28800 ICV_76 $T=857520 843885 0 0 $X=857090 $Y=843495
X1568 18 45 59 29172 28978 ICV_76 $T=867040 820365 0 0 $X=866610 $Y=819975
X1569 18 45 46 29446 29054 ICV_76 $T=876000 859565 1 0 $X=875570 $Y=855010
X1570 18 45 47 29745 28813 ICV_76 $T=886640 867405 0 0 $X=886210 $Y=867015
X1571 18 45 83 111 30506 ICV_76 $T=911840 773325 1 0 $X=911410 $Y=768770
X1572 18 45 59 30490 30556 ICV_76 $T=913520 836045 1 0 $X=913090 $Y=831490
X1573 18 45 119 120 31319 ICV_76 $T=938160 749805 0 0 $X=937730 $Y=749415
X1574 18 45 31826 31882 31634 ICV_76 $T=955520 804685 1 0 $X=955090 $Y=800130
X1575 18 45 46 31515 31650 ICV_76 $T=960000 859565 1 0 $X=959570 $Y=855010
X1576 18 45 32349 123 32370 ICV_76 $T=972320 757645 0 0 $X=971890 $Y=757255
X1577 18 45 32316 32517 31587 ICV_76 $T=977360 804685 1 0 $X=976930 $Y=800130
X1578 18 45 32708 31667 32725 ICV_76 $T=983520 789005 1 0 $X=983090 $Y=784450
X1579 18 45 32742 49 32764 ICV_76 $T=984640 851725 0 0 $X=984210 $Y=851335
X1580 18 45 32933 33076 33052 ICV_76 $T=993040 796845 0 0 $X=992610 $Y=796455
X1581 18 45 152 34373 34371 ICV_76 $T=1034480 741965 1 0 $X=1034050 $Y=737410
X1582 18 45 87 33719 34363 ICV_76 $T=1035040 773325 0 0 $X=1034610 $Y=772935
X1583 18 45 53 35040 35029 ICV_76 $T=1057440 843885 1 0 $X=1057010 $Y=839330
X1584 18 45 35622 36055 35912 ICV_76 $T=1087120 781165 1 0 $X=1086690 $Y=776610
X1585 18 45 36024 36027 35855 ICV_76 $T=1087680 781165 0 0 $X=1087250 $Y=780775
X1586 18 45 36179 36364 36350 ICV_76 $T=1097200 734125 0 0 $X=1096770 $Y=733735
X1587 18 45 35518 33544 36216 ICV_76 $T=1099440 749805 1 0 $X=1099010 $Y=745250
X1588 18 45 35647 34714 36698 ICV_76 $T=1109520 757645 1 0 $X=1109090 $Y=753090
X1589 18 45 37748 49 37725 ICV_76 $T=1147600 828205 1 0 $X=1147170 $Y=823650
X1590 18 45 46 38809 38195 ICV_76 $T=1172800 836045 1 0 $X=1172370 $Y=831490
X1591 18 45 38824 38859 38860 ICV_76 $T=1174480 765485 1 0 $X=1174050 $Y=760930
X1592 18 45 47 38809 38986 ICV_76 $T=1178960 836045 1 0 $X=1178530 $Y=831490
X1593 18 45 47 39212 38670 ICV_76 $T=1185120 820365 1 0 $X=1184690 $Y=815810
X1594 18 45 47 39041 39367 ICV_76 $T=1190160 820365 0 0 $X=1189730 $Y=819975
X1595 18 45 47 40178 40179 ICV_76 $T=1213120 804685 1 0 $X=1212690 $Y=800130
X1596 18 45 40491 202 40510 ICV_76 $T=1223200 749805 0 0 $X=1222770 $Y=749415
X1597 24783 24836 24885 18 45 24867 NAND3X1 $T=736000 734125 0 0 $X=735570 $Y=733735
X1598 24725 24888 24988 18 45 24964 NAND3X1 $T=738800 781165 0 0 $X=738370 $Y=780775
X1599 24808 24910 25006 18 45 24987 NAND3X1 $T=739360 749805 0 0 $X=738930 $Y=749415
X1600 24828 25034 25045 18 45 25068 NAND3X1 $T=741600 765485 1 0 $X=741170 $Y=760930
X1601 25109 25293 25351 18 45 25332 NAND3X1 $T=748880 781165 0 0 $X=748450 $Y=780775
X1602 25314 25047 25414 18 45 25391 NAND3X1 $T=750560 804685 0 0 $X=750130 $Y=804295
X1603 25294 25526 25580 18 45 25561 NAND3X1 $T=755040 796845 1 0 $X=754610 $Y=792290
X1604 26005 26140 26089 18 45 26112 NAND3X1 $T=777440 828205 1 180 $X=773090 $Y=827815
X1605 26272 26229 26181 18 45 26200 NAND3X1 $T=780240 820365 0 180 $X=775890 $Y=815810
X1606 26332 26283 26234 18 45 26252 NAND3X1 $T=781920 836045 1 180 $X=777570 $Y=835655
X1607 26271 26309 26487 18 45 26470 NAND3X1 $T=782480 804685 1 0 $X=782050 $Y=800130
X1608 26592 26551 26416 18 45 26520 NAND3X1 $T=790320 843885 0 180 $X=785970 $Y=839330
X1609 26861 26571 26751 18 45 26788 NAND3X1 $T=798720 820365 0 180 $X=794370 $Y=815810
X1610 26752 26957 27001 18 45 26980 NAND3X1 $T=798720 836045 1 0 $X=798290 $Y=831490
X1611 26883 27046 27018 18 45 27072 NAND3X1 $T=801520 804685 0 0 $X=801090 $Y=804295
X1612 27219 27374 27425 18 45 27406 NAND3X1 $T=811600 851725 0 0 $X=811170 $Y=851335
X1613 27385 27143 27445 18 45 27465 NAND3X1 $T=819440 836045 1 180 $X=815090 $Y=835655
X1614 27689 27179 27635 18 45 27651 NAND3X1 $T=825600 828205 0 180 $X=821250 $Y=823650
X1615 27723 27568 27805 18 45 27786 NAND3X1 $T=823920 851725 1 0 $X=823490 $Y=847170
X1616 27636 27798 27849 18 45 27828 NAND3X1 $T=825040 859565 0 0 $X=824610 $Y=859175
X1617 82 80 27946 18 45 28154 NAND3X1 $T=840720 734125 1 180 $X=836370 $Y=733735
X1618 67 81 79 18 45 28023 NAND3X1 $T=841280 734125 0 180 $X=836930 $Y=729570
X1619 27688 84 86 18 45 28334 NAND3X1 $T=841840 734125 1 0 $X=841410 $Y=729570
X1620 28354 28285 89 18 45 28420 NAND3X1 $T=844640 749805 1 0 $X=844210 $Y=745250
X1621 28578 93 91 18 45 28544 NAND3X1 $T=853600 734125 0 180 $X=849250 $Y=729570
X1622 28335 28444 28544 18 45 28579 NAND3X1 $T=849680 734125 0 0 $X=849250 $Y=733735
X1623 28647 28525 94 18 45 28580 NAND3X1 $T=855840 749805 0 180 $X=851490 $Y=745250
X1624 28595 28813 28800 18 45 28849 NAND3X1 $T=857520 859565 0 0 $X=857090 $Y=859175
X1625 28594 28892 96 18 45 28934 NAND3X1 $T=859760 741965 1 0 $X=859330 $Y=737410
X1626 29054 28629 28649 18 45 28975 NAND3X1 $T=867040 851725 0 180 $X=862690 $Y=847170
X1627 29262 27958 29173 18 45 29226 NAND3X1 $T=874320 851725 1 180 $X=869970 $Y=851335
X1628 29096 29644 29671 18 45 29672 NAND3X1 $T=883280 859565 0 0 $X=882850 $Y=859175
X1629 29715 29679 103 18 45 29654 NAND3X1 $T=888880 765485 0 180 $X=884530 $Y=760930
X1630 30012 29776 106 18 45 29944 NAND3X1 $T=898960 734125 1 180 $X=894610 $Y=733735
X1631 29959 29777 107 18 45 30030 NAND3X1 $T=895600 765485 0 0 $X=895170 $Y=765095
X1632 30013 29790 109 18 45 30114 NAND3X1 $T=898400 749805 0 0 $X=897970 $Y=749415
X1633 30303 30254 30206 18 45 30225 NAND3X1 $T=907920 859565 0 180 $X=903570 $Y=855010
X1634 30304 30255 30048 18 45 30226 NAND3X1 $T=907920 867405 1 180 $X=903570 $Y=867015
X1635 30431 30610 114 18 45 30605 NAND3X1 $T=915200 741965 0 0 $X=914770 $Y=741575
X1636 30709 30540 30636 18 45 30652 NAND3X1 $T=921920 867405 1 180 $X=917570 $Y=867015
X1637 30722 30506 115 18 45 30665 NAND3X1 $T=922480 765485 1 180 $X=918130 $Y=765095
X1638 30680 30558 116 18 45 30737 NAND3X1 $T=919120 749805 1 0 $X=918690 $Y=745250
X1639 30829 30872 118 18 45 30891 NAND3X1 $T=924720 749805 1 0 $X=924290 $Y=745250
X1640 30751 30918 30912 18 45 30946 NAND3X1 $T=926400 867405 0 0 $X=925970 $Y=867015
X1641 31357 31319 31463 18 45 31246 NAND3X1 $T=940400 749805 1 0 $X=939970 $Y=745250
X1642 31462 31271 31356 18 45 122 NAND3X1 $T=944880 734125 1 180 $X=940530 $Y=733735
X1643 31530 31503 31617 18 45 31555 NAND3X1 $T=945440 796845 1 0 $X=945010 $Y=792290
X1644 31647 31559 31569 18 45 31392 NAND3X1 $T=951040 781165 1 180 $X=946690 $Y=780775
X1645 31648 31613 31570 18 45 31435 NAND3X1 $T=951040 820365 1 180 $X=946690 $Y=819975
X1646 31650 31249 31571 18 45 31586 NAND3X1 $T=951040 859565 0 180 $X=946690 $Y=855010
X1647 31623 110 125 18 45 127 NAND3X1 $T=951600 734125 0 180 $X=947250 $Y=729570
X1648 31602 31644 31685 18 45 31570 NAND3X1 $T=947680 820365 1 0 $X=947250 $Y=815810
X1649 31701 119 124 18 45 31666 NAND3X1 $T=952720 757645 1 180 $X=948370 $Y=757255
X1650 31532 31709 31666 18 45 31734 NAND3X1 $T=949920 765485 0 0 $X=949490 $Y=765095
X1651 31547 31726 31736 18 45 31749 NAND3X1 $T=950480 867405 0 0 $X=950050 $Y=867015
X1652 131 31771 31812 18 45 31564 NAND3X1 $T=952160 734125 0 0 $X=951730 $Y=733735
X1653 31813 31584 31733 18 45 31709 NAND3X1 $T=956640 757645 1 180 $X=952290 $Y=757255
X1654 31584 31804 136 18 45 31812 NAND3X1 $T=953280 741965 1 0 $X=952850 $Y=737410
X1655 31781 31825 31862 18 45 31569 NAND3X1 $T=953840 781165 0 0 $X=953410 $Y=780775
X1656 31783 31826 135 18 45 31648 NAND3X1 $T=953840 820365 1 0 $X=953410 $Y=815810
X1657 31974 31938 31895 18 45 31715 NAND3X1 $T=962240 773325 1 180 $X=957890 $Y=772935
X1658 31913 31782 31667 18 45 31942 NAND3X1 $T=958320 796845 0 0 $X=957890 $Y=796455
X1659 31975 31247 31896 18 45 31915 NAND3X1 $T=962240 867405 1 180 $X=957890 $Y=867015
X1660 31989 31950 31914 18 45 31686 NAND3X1 $T=962800 828205 0 180 $X=958450 $Y=823650
X1661 32089 32054 31882 18 45 31585 NAND3X1 $T=966160 804685 0 180 $X=961810 $Y=800130
X1662 128 138 110 18 45 32105 NAND3X1 $T=962800 749805 1 0 $X=962370 $Y=745250
X1663 32109 32071 32023 18 45 31678 NAND3X1 $T=966720 828205 1 180 $X=962370 $Y=827815
X1664 32088 31942 32179 18 45 32122 NAND3X1 $T=964480 796845 1 0 $X=964050 $Y=792290
X1665 32021 32152 32144 18 45 32178 NAND3X1 $T=965040 765485 0 0 $X=964610 $Y=765095
X1666 31813 140 141 18 45 32246 NAND3X1 $T=967280 749805 0 0 $X=966850 $Y=749415
X1667 32198 32054 31862 18 45 32179 NAND3X1 $T=967840 804685 0 0 $X=967410 $Y=804295
X1668 32143 142 32331 18 45 32315 NAND3X1 $T=969520 741965 1 0 $X=969090 $Y=737410
X1669 32124 32153 32389 18 45 32229 NAND3X1 $T=971760 820365 1 0 $X=971330 $Y=815810
X1670 32371 31782 32108 18 45 32372 NAND3X1 $T=973440 789005 0 0 $X=973010 $Y=788615
X1671 32355 126 123 18 45 32331 NAND3X1 $T=977920 741965 0 180 $X=973570 $Y=737410
X1672 32355 145 141 18 45 32422 NAND3X1 $T=979040 734125 1 180 $X=974690 $Y=733735
X1673 32281 32473 32475 18 45 31529 NAND3X1 $T=975120 773325 0 0 $X=974690 $Y=772935
X1674 31661 31296 32355 18 45 32514 NAND3X1 $T=976240 741965 0 0 $X=975810 $Y=741575
X1675 32246 32555 32514 18 45 32460 NAND3X1 $T=982400 757645 0 180 $X=978050 $Y=753090
X1676 32477 32350 32424 18 45 32565 NAND3X1 $T=982400 773325 0 180 $X=978050 $Y=768770
X1677 32386 32457 32675 18 45 32639 NAND3X1 $T=980160 820365 0 0 $X=979730 $Y=819975
X1678 32296 32493 32564 18 45 32674 NAND3X1 $T=980720 765485 0 0 $X=980290 $Y=765095
X1679 32498 32717 32764 18 45 32743 NAND3X1 $T=982960 867405 0 0 $X=982530 $Y=867015
X1680 32765 32226 32422 18 45 32724 NAND3X1 $T=988560 741965 1 180 $X=984210 $Y=741575
X1681 32725 32780 32873 18 45 32874 NAND3X1 $T=986880 789005 0 0 $X=986450 $Y=788615
X1682 32832 32709 32835 18 45 32914 NAND3X1 $T=988000 820365 1 0 $X=987570 $Y=815810
X1683 32994 32351 33033 18 45 33073 NAND3X1 $T=992480 796845 1 0 $X=992050 $Y=792290
X1684 32264 32153 31863 18 45 33076 NAND3X1 $T=993040 789005 0 0 $X=992610 $Y=788615
X1685 32763 33074 33032 18 45 33112 NAND3X1 $T=993600 812525 1 0 $X=993170 $Y=807970
X1686 32996 33239 33265 18 45 33266 NAND3X1 $T=998080 867405 1 0 $X=997650 $Y=862850
X1687 33339 33356 33304 18 45 33320 NAND3X1 $T=1005920 757645 0 180 $X=1001570 $Y=753090
X1688 33524 33545 33615 18 45 33599 NAND3X1 $T=1008160 757645 0 0 $X=1007730 $Y=757255
X1689 33617 31415 33525 18 45 33546 NAND3X1 $T=1012640 867405 0 180 $X=1008290 $Y=862850
X1690 33919 34051 34004 18 45 34118 NAND3X1 $T=1025520 781165 1 0 $X=1025090 $Y=776610
X1691 33918 34127 34166 18 45 34151 NAND3X1 $T=1026640 773325 1 0 $X=1026210 $Y=768770
X1692 33986 34180 34206 18 45 34201 NAND3X1 $T=1028320 875245 1 0 $X=1027890 $Y=870690
X1693 34322 34363 34371 18 45 34397 NAND3X1 $T=1034480 773325 1 0 $X=1034050 $Y=768770
X1694 34562 32917 34480 18 45 34501 NAND3X1 $T=1044000 875245 1 180 $X=1039650 $Y=874855
X1695 34715 34500 34561 18 45 34679 NAND3X1 $T=1049040 773325 1 180 $X=1044690 $Y=772935
X1696 34610 34707 34753 18 45 34735 NAND3X1 $T=1045680 859565 0 0 $X=1045250 $Y=859175
X1697 34798 34563 34713 18 45 34734 NAND3X1 $T=1051840 749805 1 180 $X=1047490 $Y=749415
X1698 34937 33900 34863 18 45 34878 NAND3X1 $T=1056880 859565 1 180 $X=1052530 $Y=859175
X1699 34877 34988 35026 18 45 35009 NAND3X1 $T=1055760 765485 0 0 $X=1055330 $Y=765095
X1700 35008 168 35095 18 45 169 NAND3X1 $T=1058000 734125 0 0 $X=1057570 $Y=733735
X1701 34958 35103 35145 18 45 35126 NAND3X1 $T=1059680 749805 0 0 $X=1059250 $Y=749415
X1702 34999 35170 35178 18 45 35196 NAND3X1 $T=1061920 875245 1 0 $X=1061490 $Y=870690
X1703 35436 35490 35542 18 45 35477 NAND3X1 $T=1070880 765485 0 0 $X=1070450 $Y=765095
X1704 35519 35570 35617 18 45 35437 NAND3X1 $T=1073120 781165 1 0 $X=1072690 $Y=776610
X1705 35753 35714 35660 18 45 176 NAND3X1 $T=1081520 741965 1 180 $X=1077170 $Y=741575
X1706 35799 35750 177 18 45 35714 NAND3X1 $T=1082640 741965 0 180 $X=1078290 $Y=737410
X1707 35719 35766 35816 18 45 35754 NAND3X1 $T=1078720 765485 1 0 $X=1078290 $Y=760930
X1708 35842 35738 35735 18 45 35618 NAND3X1 $T=1083760 796845 0 180 $X=1079410 $Y=792290
X1709 35642 35831 35755 18 45 35766 NAND3X1 $T=1080400 757645 0 0 $X=1079970 $Y=757255
X1710 35928 35700 178 18 45 35719 NAND3X1 $T=1086560 773325 0 180 $X=1082210 $Y=768770
X1711 35930 36041 35959 18 45 36069 NAND3X1 $T=1087120 859565 1 0 $X=1086690 $Y=855010
X1712 35696 36064 177 18 45 36068 NAND3X1 $T=1092160 749805 1 180 $X=1087810 $Y=749415
X1713 36139 34052 36053 18 45 36070 NAND3X1 $T=1093280 859565 1 180 $X=1088930 $Y=859175
X1714 36176 36130 36086 18 45 35978 NAND3X1 $T=1094400 765485 0 180 $X=1090050 $Y=760930
X1715 35680 36255 34714 18 45 36176 NAND3X1 $T=1098320 773325 0 180 $X=1093970 $Y=768770
X1716 35874 36229 36310 18 45 35816 NAND3X1 $T=1095520 765485 0 0 $X=1095090 $Y=765095
X1717 36329 35559 36122 18 45 36294 NAND3X1 $T=1099440 851725 1 180 $X=1095090 $Y=851335
X1718 34714 178 35963 18 45 36328 NAND3X1 $T=1096080 757645 0 0 $X=1095650 $Y=757255
X1719 36276 36344 36216 18 45 36364 NAND3X1 $T=1096640 741965 1 0 $X=1096210 $Y=737410
X1720 36055 36103 35518 18 45 36389 NAND3X1 $T=1097200 781165 1 0 $X=1096770 $Y=776610
X1721 36399 34714 36310 18 45 35660 NAND3X1 $T=1101680 749805 1 180 $X=1097330 $Y=749415
X1722 35874 36229 36461 18 45 36483 NAND3X1 $T=1100560 773325 1 0 $X=1100130 $Y=768770
X1723 36410 35518 35963 18 45 36444 NAND3X1 $T=1100560 789005 0 0 $X=1100130 $Y=788615
X1724 36177 36518 36461 18 45 35617 NAND3X1 $T=1107280 773325 1 180 $X=1102930 $Y=772935
X1725 36601 35755 36431 18 45 36540 NAND3X1 $T=1108960 781165 1 180 $X=1104610 $Y=780775
X1726 36635 36593 36540 18 45 35585 NAND3X1 $T=1110080 789005 1 180 $X=1105730 $Y=788615
X1727 36432 36614 174 18 45 36635 NAND3X1 $T=1106160 796845 1 0 $X=1105730 $Y=792290
X1728 36255 174 35963 18 45 36691 NAND3X1 $T=1109520 765485 0 0 $X=1109090 $Y=765095
X1729 36697 36230 33544 18 45 36757 NAND3X1 $T=1110640 789005 1 0 $X=1110210 $Y=784450
X1730 36605 36808 36654 18 45 36832 NAND3X1 $T=1112880 843885 0 0 $X=1112450 $Y=843495
X1731 35958 36103 174 18 45 36859 NAND3X1 $T=1114000 757645 0 0 $X=1113570 $Y=757255
X1732 36696 36818 36782 18 45 36933 NAND3X1 $T=1115680 741965 0 0 $X=1115250 $Y=741575
X1733 36860 35750 35963 18 45 36934 NAND3X1 $T=1115680 765485 1 0 $X=1115250 $Y=760930
X1734 36815 36661 36934 18 45 36848 NAND3X1 $T=1116800 773325 1 0 $X=1116370 $Y=768770
X1735 36989 36710 182 18 45 183 NAND3X1 $T=1121280 734125 0 180 $X=1116930 $Y=729570
X1736 37471 36602 37373 18 45 37400 NAND3X1 $T=1134720 851725 1 180 $X=1130370 $Y=851335
X1737 37236 37463 37507 18 45 37487 NAND3X1 $T=1131360 851725 1 0 $X=1130930 $Y=847170
X1738 37815 36783 37725 18 45 37749 NAND3X1 $T=1145360 836045 1 180 $X=1141010 $Y=835655
X1739 37653 37830 190 18 45 37896 NAND3X1 $T=1144240 741965 1 0 $X=1143810 $Y=737410
X1740 38195 37850 38109 18 45 38128 NAND3X1 $T=1157680 836045 1 180 $X=1153330 $Y=835655
X1741 38328 38438 38312 18 45 38408 NAND3X1 $T=1166080 836045 0 180 $X=1161730 $Y=831490
X1742 38629 38670 38726 18 45 38703 NAND3X1 $T=1168880 836045 1 0 $X=1168450 $Y=831490
X1743 38893 38485 38807 18 45 38826 NAND3X1 $T=1178960 820365 1 180 $X=1174610 $Y=819975
X1744 39020 38108 38929 18 45 38947 NAND3X1 $T=1182880 804685 1 180 $X=1178530 $Y=804295
X1745 39469 38986 39344 18 45 39384 NAND3X1 $T=1195760 804685 1 180 $X=1191410 $Y=804295
X1746 39450 39367 39489 18 45 39534 NAND3X1 $T=1193520 812525 0 0 $X=1193090 $Y=812135
X1747 39597 39565 39512 18 45 39535 NAND3X1 $T=1199680 820365 1 180 $X=1195330 $Y=819975
X1748 39915 40089 40027 18 45 40121 NAND3X1 $T=1210320 789005 0 0 $X=1209890 $Y=788615
X1749 40102 40179 40228 18 45 40213 NAND3X1 $T=1214240 820365 1 0 $X=1213810 $Y=815810
X1750 40267 39738 40124 18 45 40196 NAND3X1 $T=1218720 765485 0 180 $X=1214370 $Y=760930
X1751 40716 40356 40611 18 45 40632 NAND3X1 $T=1231600 781165 1 180 $X=1227250 $Y=780775
X1752 40863 40802 203 18 45 40777 NAND3X1 $T=1235520 741965 0 180 $X=1231170 $Y=737410
X1753 40864 41055 41041 18 45 41082 NAND3X1 $T=1237760 781165 1 0 $X=1237330 $Y=776610
X1754 41302 41258 41166 18 45 41223 NAND3X1 $T=1247840 781165 1 180 $X=1243490 $Y=780775
X1755 41344 41147 41265 18 45 41300 NAND3X1 $T=1250080 741965 0 180 $X=1245730 $Y=737410
X1756 41227 41320 41207 18 45 41301 NAND3X1 $T=1250080 765485 1 180 $X=1245730 $Y=765095
X1757 67 69 18 45 27584 OR2X1 $T=817200 734125 1 0 $X=816770 $Y=729570
X1758 78 27830 18 45 27946 OR2X1 $T=834560 741965 0 180 $X=830770 $Y=737410
X1759 67 95 18 45 28578 OR2X1 $T=855280 734125 1 0 $X=854850 $Y=729570
X1760 120 31270 18 45 121 OR2X1 $T=944320 734125 0 180 $X=940530 $Y=729570
X1761 31585 31521 18 45 31503 OR2X1 $T=948240 804685 0 180 $X=944450 $Y=800130
X1762 31587 31598 18 45 31559 OR2X1 $T=949920 789005 1 180 $X=946130 $Y=788615
X1763 125 31584 18 45 31357 OR2X1 $T=950480 749805 0 180 $X=946690 $Y=745250
X1764 124 31661 18 45 31623 OR2X1 $T=952160 734125 1 180 $X=948370 $Y=733735
X1765 31671 31634 18 45 31617 OR2X1 $T=952720 796845 1 180 $X=948930 $Y=796455
X1766 31667 31634 18 45 31741 OR2X1 $T=950480 804685 0 0 $X=950050 $Y=804295
X1767 31782 31741 18 45 31530 OR2X1 $T=954960 796845 0 180 $X=951170 $Y=792290
X1768 31825 31913 18 45 31918 OR2X1 $T=962240 804685 0 180 $X=958450 $Y=800130
X1769 32009 31826 18 45 31644 OR2X1 $T=962800 804685 1 180 $X=959010 $Y=804295
X1770 31813 31809 18 45 32021 OR2X1 $T=960000 765485 0 0 $X=959570 $Y=765095
X1771 31952 31912 18 45 32053 OR2X1 $T=961120 741965 0 0 $X=960690 $Y=741575
X1772 31585 32101 18 45 32071 OR2X1 $T=963920 820365 0 0 $X=963490 $Y=819975
X1773 32145 32133 18 45 31895 OR2X1 $T=968400 773325 1 180 $X=964610 $Y=772935
X1774 31671 32184 18 45 32088 OR2X1 $T=970080 796845 1 180 $X=966290 $Y=796455
X1775 32108 31826 18 45 31950 OR2X1 $T=970640 820365 1 180 $X=966850 $Y=819975
X1776 32128 140 18 45 32160 OR2X1 $T=972320 734125 1 180 $X=968530 $Y=733735
X1777 32441 32386 18 45 32109 OR2X1 $T=976800 828205 1 180 $X=973010 $Y=827815
X1778 32089 32372 18 45 32475 OR2X1 $T=974560 781165 1 0 $X=974130 $Y=776610
X1779 32600 32263 18 45 32496 OR2X1 $T=982400 757645 1 180 $X=978610 $Y=757255
X1780 32355 32598 18 45 32636 OR2X1 $T=979600 741965 1 0 $X=979170 $Y=737410
X1781 31671 32145 18 45 32933 OR2X1 $T=988560 804685 1 0 $X=988130 $Y=800130
X1782 32106 31671 18 45 32832 OR2X1 $T=991920 812525 0 180 $X=988130 $Y=807970
X1783 35680 35622 18 45 35595 OR2X1 $T=1078720 773325 1 180 $X=1074930 $Y=772935
X1784 35647 35884 18 45 35831 OR2X1 $T=1086000 749805 1 180 $X=1082210 $Y=749415
X1785 35950 35992 18 45 35928 OR2X1 $T=1086000 773325 0 0 $X=1085570 $Y=772935
X1786 36050 35874 18 45 35622 OR2X1 $T=1089920 773325 0 180 $X=1086130 $Y=768770
X1787 35647 36067 18 45 36064 OR2X1 $T=1088240 749805 1 0 $X=1087810 $Y=745250
X1788 35647 36243 18 45 36276 OR2X1 $T=1099440 749805 0 180 $X=1095650 $Y=745250
X1789 35750 35874 18 45 36410 OR2X1 $T=1103920 781165 1 180 $X=1100130 $Y=780775
X1790 36496 36328 18 45 36567 OR2X1 $T=1103920 749805 0 0 $X=1103490 $Y=749415
X1791 18 45 47 24868 24888 ICV_74 $T=737680 773325 1 0 $X=737250 $Y=768770
X1792 18 45 47 24257 25047 ICV_74 $T=742160 796845 1 0 $X=741730 $Y=792290
X1793 18 45 53 25371 25822 ICV_74 $T=763440 757645 0 0 $X=763010 $Y=757255
X1794 18 45 53 25704 26291 ICV_74 $T=778000 789005 1 0 $X=777570 $Y=784450
X1795 18 45 59 27602 27142 ICV_74 $T=819440 789005 1 0 $X=819010 $Y=784450
X1796 18 45 28286 28255 28271 ICV_74 $T=840720 828205 0 0 $X=840290 $Y=827815
X1797 18 45 90 88 28444 ICV_74 $T=846320 734125 0 0 $X=845890 $Y=733735
X1798 18 45 29316 98 29314 ICV_74 $T=872080 757645 1 0 $X=871650 $Y=753090
X1799 18 45 29688 29427 29670 ICV_74 $T=884400 828205 0 0 $X=883970 $Y=827815
X1800 18 45 87 101 29790 ICV_74 $T=888880 757645 1 0 $X=888450 $Y=753090
X1801 18 45 87 30154 29715 ICV_74 $T=901760 773325 1 0 $X=901330 $Y=768770
X1802 18 45 47 29281 31249 ICV_74 $T=936480 859565 0 0 $X=936050 $Y=859175
X1803 18 45 31492 120 31463 ICV_74 $T=942640 757645 1 0 $X=942210 $Y=753090
X1804 18 45 31735 49 31736 ICV_74 $T=951040 859565 1 0 $X=950610 $Y=855010
X1805 18 45 32053 136 32121 ICV_74 $T=964480 741965 0 0 $X=964050 $Y=741575
X1806 18 45 32245 128 32226 ICV_74 $T=967840 741965 0 0 $X=967410 $Y=741575
X1807 18 45 32598 32472 32555 ICV_74 $T=979600 749805 1 0 $X=979170 $Y=745250
X1808 18 45 53 32742 32817 ICV_74 $T=986320 836045 0 0 $X=985890 $Y=835655
X1809 18 45 31914 32153 32835 ICV_74 $T=986880 820365 0 0 $X=986450 $Y=819975
X1810 18 45 87 33701 33919 ICV_74 $T=1019920 781165 1 0 $X=1019490 $Y=776610
X1811 18 45 34185 34072 34169 ICV_74 $T=1028320 836045 1 0 $X=1027890 $Y=831490
X1812 18 45 34205 49 34206 ICV_74 $T=1029440 867405 1 0 $X=1029010 $Y=862850
X1813 18 45 46 34374 34999 ICV_74 $T=1056320 875245 0 0 $X=1055890 $Y=874855
X1814 18 45 47 35520 33239 ICV_74 $T=1072560 859565 0 0 $X=1072130 $Y=859175
X1815 18 45 35980 49 35959 ICV_74 $T=1084880 851725 0 0 $X=1084450 $Y=851335
X1816 18 45 35958 177 36027 ICV_74 $T=1087120 765485 1 0 $X=1086690 $Y=760930
X1817 18 45 38825 38286 38806 ICV_74 $T=1173360 789005 0 0 $X=1172930 $Y=788615
X1818 18 45 39430 39325 39407 ICV_74 $T=1191280 765485 1 0 $X=1190850 $Y=760930
X1819 18 45 39514 38788 39511 ICV_74 $T=1194080 765485 0 0 $X=1193650 $Y=765095
X1820 18 45 46 38330 40102 ICV_74 $T=1210880 820365 1 0 $X=1210450 $Y=815810
X1821 18 45 53 39934 40491 ICV_74 $T=1223200 765485 1 0 $X=1222770 $Y=760930
X1822 18 45 47 40413 40802 ICV_74 $T=1231040 765485 1 0 $X=1230610 $Y=760930
X1823 18 46 24784 25109 45 ICV_78 $T=742720 781165 0 0 $X=742290 $Y=780775
X1824 18 25227 49 24988 45 ICV_78 $T=745520 765485 1 0 $X=745090 $Y=760930
X1825 18 53 25413 25602 45 ICV_78 $T=756160 757645 0 0 $X=755730 $Y=757255
X1826 18 46 26334 26272 45 ICV_78 $T=780240 820365 1 0 $X=779810 $Y=815810
X1827 18 87 28005 28354 45 ICV_78 $T=844080 741965 0 0 $X=843650 $Y=741575
X1828 18 30167 30096 30155 45 ICV_78 $T=899520 828205 0 0 $X=899090 $Y=827815
X1829 18 30525 83 30012 45 ICV_78 $T=910720 765485 0 0 $X=910290 $Y=765095
X1830 18 31584 124 31440 45 ICV_78 $T=944320 757645 0 0 $X=943890 $Y=757255
X1831 18 32123 32089 31647 45 ICV_78 $T=962800 781165 0 0 $X=962370 $Y=780775
X1832 18 32160 31943 32143 45 ICV_78 $T=963920 734125 0 0 $X=963490 $Y=733735
X1833 18 32874 32008 33033 45 ICV_78 $T=991360 789005 1 0 $X=990930 $Y=784450
X1834 18 46 33153 33986 45 ICV_78 $T=1021040 875245 1 0 $X=1020610 $Y=870690
X1835 18 34817 34771 34802 45 ICV_78 $T=1047920 843885 1 0 $X=1047490 $Y=839330
X1836 18 36444 36293 36432 45 ICV_78 $T=1098880 796845 1 0 $X=1098450 $Y=792290
X1837 18 46 35778 36605 45 ICV_78 $T=1105040 851725 0 0 $X=1104610 $Y=851335
X1838 18 36691 36600 36728 45 ICV_78 $T=1109520 773325 1 0 $X=1109090 $Y=768770
X1839 18 59 37813 37817 45 ICV_78 $T=1142560 796845 1 0 $X=1142130 $Y=792290
X1840 18 46 37932 38629 45 ICV_78 $T=1166640 836045 0 0 $X=1166210 $Y=835655
X1841 18 39364 49 39489 45 ICV_78 $T=1192400 789005 1 0 $X=1191970 $Y=784450
X1842 18 40282 200 40266 45 ICV_78 $T=1214800 741965 0 0 $X=1214370 $Y=741575
X1874 18 45 46 24437 24828 ICV_72 $T=736560 765485 1 0 $X=736130 $Y=760930
X1875 18 45 47 25970 25526 ICV_72 $T=767920 796845 0 0 $X=767490 $Y=796455
X1876 18 45 25725 49 26089 ICV_72 $T=772960 796845 0 0 $X=772530 $Y=796455
X1877 18 45 59 27272 26983 ICV_72 $T=816080 773325 0 0 $X=815650 $Y=772935
X1878 18 45 27584 72 27669 ICV_72 $T=822240 734125 1 0 $X=821810 $Y=729570
X1879 18 45 76 28023 77 ICV_72 $T=832320 734125 1 0 $X=831890 $Y=729570
X1880 18 45 46 29281 29262 ICV_72 $T=870960 859565 1 0 $X=870530 $Y=855010
X1881 18 45 59 29492 29656 ICV_72 $T=884960 820365 1 0 $X=884530 $Y=815810
X1882 18 45 87 30032 29959 ICV_72 $T=896720 781165 1 0 $X=896290 $Y=776610
X1883 18 45 29762 49 30048 ICV_72 $T=897280 859565 1 0 $X=896850 $Y=855010
X1884 18 45 87 30754 30722 ICV_72 $T=920800 773325 0 0 $X=920370 $Y=772935
X1885 18 45 87 30770 30610 ICV_72 $T=921360 741965 0 0 $X=920930 $Y=741575
X1886 18 45 31669 31704 31687 ICV_72 $T=949920 851725 0 0 $X=949490 $Y=851335
X1887 18 45 31784 135 31649 ICV_72 $T=953840 828205 1 0 $X=953410 $Y=823650
X1888 18 45 138 139 32011 ICV_72 $T=961120 734125 1 0 $X=960690 $Y=729570
X1889 18 45 31838 32316 32351 ICV_72 $T=971760 796845 0 0 $X=971330 $Y=796455
X1890 18 45 46 33773 33617 ICV_72 $T=1014880 867405 1 0 $X=1014450 $Y=862850
X1891 18 45 59 33654 33620 ICV_72 $T=1018800 836045 1 0 $X=1018370 $Y=831490
X1892 18 45 152 161 34166 ICV_72 $T=1029440 741965 1 0 $X=1029010 $Y=737410
X1893 18 45 47 34374 34180 ICV_72 $T=1035040 875245 0 0 $X=1034610 $Y=874855
X1894 18 45 59 34323 34771 ICV_72 $T=1048480 828205 1 0 $X=1048050 $Y=823650
X1895 18 45 87 34895 34715 ICV_72 $T=1052400 773325 0 0 $X=1051970 $Y=772935
X1896 18 45 35543 35518 35519 ICV_72 $T=1073680 789005 1 0 $X=1073250 $Y=784450
X1897 18 45 47 35778 34707 ICV_72 $T=1079280 859565 0 0 $X=1078850 $Y=859175
X1898 18 45 35982 49 36122 ICV_72 $T=1090480 851725 0 0 $X=1090050 $Y=851335
X1899 18 45 36006 178 36179 ICV_72 $T=1092160 734125 0 0 $X=1091730 $Y=733735
X1900 18 45 36496 36103 36518 ICV_72 $T=1104480 765485 0 0 $X=1104050 $Y=765095
X1901 18 45 37638 37817 37796 ICV_72 $T=1142560 828205 1 0 $X=1142130 $Y=823650
X1902 18 45 59 38351 38685 ICV_72 $T=1169440 765485 1 0 $X=1169010 $Y=760930
X1903 18 45 59 194 38859 ICV_72 $T=1175600 741965 0 0 $X=1175170 $Y=741575
X1904 18 45 53 39057 39514 ICV_72 $T=1194640 781165 0 0 $X=1194210 $Y=780775
X1905 18 45 46 40906 40716 ICV_72 $T=1233840 781165 0 0 $X=1233410 $Y=780775
X1906 18 45 204 49 41041 ICV_72 $T=1238320 765485 0 0 $X=1237890 $Y=765095
X1907 18 45 47 40906 41055 ICV_72 $T=1238880 781165 0 0 $X=1238450 $Y=780775
X1908 75 73 18 45 27804 AND2X1 $T=830640 734125 0 180 $X=826850 $Y=729570
X1909 31296 119 18 45 31513 AND2X1 $T=943200 765485 1 0 $X=942770 $Y=760930
X1910 31587 31546 18 45 31521 AND2X1 $T=948800 804685 1 180 $X=945010 $Y=804295
X1911 31684 31780 18 45 31545 AND2X1 $T=958320 765485 0 180 $X=954530 $Y=760930
X1912 126 133 18 45 31296 AND2X1 $T=956080 749805 0 0 $X=955650 $Y=749415
X1913 31644 31863 18 45 31748 AND2X1 $T=959440 789005 1 180 $X=955650 $Y=788615
X1914 31296 120 18 45 31952 AND2X1 $T=957760 741965 1 0 $X=957330 $Y=737410
X1915 128 137 18 45 32128 AND2X1 $T=969520 734125 0 180 $X=965730 $Y=729570
X1916 124 125 18 45 32245 AND2X1 $T=971760 749805 1 0 $X=971330 $Y=745250
X1917 32372 32404 18 45 32275 AND2X1 $T=973440 781165 0 0 $X=973010 $Y=780775
X1918 32121 32370 18 45 32493 AND2X1 $T=975120 765485 1 0 $X=974690 $Y=760930
X1919 32518 32519 18 45 32441 AND2X1 $T=980720 828205 1 180 $X=976930 $Y=827815
X1920 119 144 18 45 32598 AND2X1 $T=981840 734125 0 0 $X=981410 $Y=733735
X1921 35642 174 18 45 35569 AND2X1 $T=1078160 757645 1 180 $X=1074370 $Y=757255
X1922 35874 35950 18 45 35756 AND2X1 $T=1084320 781165 0 0 $X=1083890 $Y=780775
X1923 35874 36055 18 45 35992 AND2X1 $T=1092720 773325 0 0 $X=1092290 $Y=772935
X1924 36483 36389 18 45 36661 AND2X1 $T=1107280 773325 0 0 $X=1106850 $Y=772935
X1925 31564 18 45 31462 INVX2 $T=947680 734125 0 180 $X=945570 $Y=729570
X1926 126 18 45 31492 INVX2 $T=948800 749805 1 180 $X=946690 $Y=749415
X1927 31463 18 45 128 INVX2 $T=951040 741965 1 180 $X=948930 $Y=741575
X1928 31678 18 45 31613 INVX2 $T=951600 828205 1 180 $X=949490 $Y=827815
X1929 31584 18 45 31661 INVX2 $T=951040 741965 0 0 $X=950610 $Y=741575
X1930 31701 18 45 31809 INVX2 $T=954400 765485 0 0 $X=953970 $Y=765095
X1931 31644 18 45 31781 INVX2 $T=956640 781165 0 180 $X=954530 $Y=776610
X1932 134 18 45 125 INVX2 $T=959440 734125 1 0 $X=959010 $Y=729570
X1933 138 18 45 31943 INVX2 $T=962240 734125 0 0 $X=961810 $Y=733735
X1934 31782 18 45 32008 INVX2 $T=962800 796845 1 0 $X=962370 $Y=792290
X1935 31585 18 45 31913 INVX2 $T=963360 796845 0 0 $X=962930 $Y=796455
X1936 31850 18 45 31989 INVX2 $T=963360 820365 1 0 $X=962930 $Y=815810
X1937 32011 18 45 31813 INVX2 $T=965040 765485 1 0 $X=964610 $Y=760930
X1938 32153 18 45 32054 INVX2 $T=967840 804685 1 180 $X=965730 $Y=804295
X1939 32204 18 45 32123 INVX2 $T=969520 789005 0 180 $X=967410 $Y=784450
X1940 32198 18 45 31817 INVX2 $T=969520 812525 1 180 $X=967410 $Y=812135
X1941 123 18 45 141 INVX2 $T=973440 734125 1 0 $X=973010 $Y=729570
X1942 31862 18 45 32389 INVX2 $T=976240 804685 1 180 $X=974130 $Y=804295
X1943 31685 18 45 32457 INVX2 $T=975680 828205 1 0 $X=975250 $Y=823650
X1944 130 18 45 32472 INVX2 $T=978480 749805 1 180 $X=976370 $Y=749415
X1945 32145 18 45 32371 INVX2 $T=979040 789005 0 180 $X=976930 $Y=784450
X1946 31863 18 45 31882 INVX2 $T=985200 796845 1 0 $X=984770 $Y=792290
X1947 31826 18 45 32756 INVX2 $T=985200 804685 1 0 $X=984770 $Y=800130
X1948 135 18 45 32517 INVX2 $T=986320 820365 1 0 $X=985890 $Y=815810
X1949 32106 18 45 32089 INVX2 $T=988560 781165 1 0 $X=988130 $Y=776610
X1950 32108 18 45 31667 INVX2 $T=989120 804685 0 0 $X=988690 $Y=804295
X1951 35647 18 45 35674 INVX2 $T=1077040 781165 0 0 $X=1076610 $Y=780775
X1952 35700 18 45 35642 INVX2 $T=1080400 757645 0 180 $X=1078290 $Y=753090
X1953 178 18 45 35750 INVX2 $T=1087120 741965 0 180 $X=1085010 $Y=737410
X1954 35680 18 45 35950 INVX2 $T=1085440 781165 1 0 $X=1085010 $Y=776610
X1955 35799 18 45 36006 INVX2 $T=1087120 734125 0 0 $X=1086690 $Y=733735
X1956 177 18 45 35963 INVX2 $T=1089360 757645 0 180 $X=1087250 $Y=753090
X1957 36067 18 45 36243 INVX2 $T=1094400 741965 0 0 $X=1093970 $Y=741575
X1958 36216 18 45 36051 INVX2 $T=1094400 757645 1 0 $X=1093970 $Y=753090
X1959 35518 18 45 36461 INVX2 $T=1101680 749805 0 0 $X=1101250 $Y=749415
X1960 33544 18 45 36310 INVX2 $T=1104480 757645 1 180 $X=1102370 $Y=757255
X1961 35958 18 45 36496 INVX2 $T=1103360 757645 1 0 $X=1102930 $Y=753090
X1962 36177 18 45 36641 INVX2 $T=1110640 781165 0 180 $X=1108530 $Y=776610
X1963 180 18 45 181 INVX2 $T=1109520 883085 0 0 $X=1109090 $Y=882695
X1964 174 18 45 36230 INVX2 $T=1111760 789005 1 180 $X=1109650 $Y=788615
X1965 34714 18 45 36103 INVX2 $T=1112320 757645 1 180 $X=1110210 $Y=757255
X1966 36255 18 45 36793 INVX2 $T=1113440 773325 0 0 $X=1113010 $Y=772935
X2027 55 18 45 54 BUFX1 $T=752800 741965 0 180 $X=749570 $Y=737410
X2028 55 18 45 26173 BUFX1 $T=774080 765485 0 0 $X=773650 $Y=765095
X2029 28187 18 45 28143 BUFX1 $T=840720 820365 0 180 $X=837490 $Y=815810
X2030 28187 18 45 28178 BUFX1 $T=841840 796845 0 180 $X=838610 $Y=792290
X2031 55 18 45 102 BUFX1 $T=874880 734125 0 0 $X=874450 $Y=733735
X2032 28187 18 45 29574 BUFX1 $T=884960 781165 1 180 $X=881730 $Y=780775
X2033 28187 18 45 113 BUFX1 $T=914080 765485 0 180 $X=910850 $Y=760930
X2034 28187 18 45 30499 BUFX1 $T=915760 812525 0 180 $X=912530 $Y=807970
X2035 28187 18 45 31363 BUFX1 $T=939280 843885 0 0 $X=938850 $Y=843495
X2036 129 18 45 28187 BUFX1 $T=951040 765485 0 180 $X=947810 $Y=760930
X2037 129 18 45 31889 BUFX1 $T=956080 765485 0 0 $X=955650 $Y=765095
X2038 31889 18 45 33086 BUFX1 $T=993600 812525 0 0 $X=993170 $Y=812135
X2039 33086 18 45 33784 BUFX1 $T=1014880 812525 0 0 $X=1014450 $Y=812135
X2040 33086 18 45 34542 BUFX1 $T=1040080 812525 0 0 $X=1039650 $Y=812135
X2041 33086 18 45 36042 BUFX1 $T=1087120 820365 0 0 $X=1086690 $Y=819975
X2042 33086 18 45 37385 BUFX1 $T=1129120 828205 0 0 $X=1128690 $Y=827815
X2043 186 18 45 37803 BUFX1 $T=1146480 757645 1 180 $X=1143250 $Y=757255
X2044 186 18 45 39869 BUFX1 $T=1203600 773325 0 0 $X=1203170 $Y=772935
X2045 186 18 45 201 BUFX1 $T=1219280 741965 0 0 $X=1218850 $Y=741575
X2062 18 45 48 49 24885 ICV_77 $T=737680 734125 1 0 $X=737250 $Y=729570
X2063 18 45 50 49 25045 ICV_77 $T=739920 734125 0 0 $X=739490 $Y=733735
X2064 18 45 47 24784 25034 ICV_77 $T=741040 773325 1 0 $X=740610 $Y=768770
X2065 18 45 46 27705 27689 ICV_77 $T=819440 836045 0 0 $X=819010 $Y=835655
X2066 18 45 31514 49 31896 ICV_77 $T=954400 859565 1 0 $X=953970 $Y=855010
X2067 18 45 31943 110 32144 ICV_77 $T=962800 757645 0 0 $X=962370 $Y=757255
X2068 18 45 32264 32153 32519 ICV_77 $T=980720 828205 0 0 $X=980290 $Y=827815
X2069 18 45 152 33753 34004 ICV_77 $T=1020480 734125 0 0 $X=1020050 $Y=733735
X2070 18 45 46 34736 34562 ICV_77 $T=1044000 875245 0 0 $X=1043570 $Y=874855
X2071 18 45 152 171 35095 ICV_77 $T=1061920 734125 0 0 $X=1061490 $Y=733735
X2072 18 45 152 173 35026 ICV_77 $T=1067520 734125 0 0 $X=1067090 $Y=733735
X2073 18 45 36103 33544 36102 ICV_77 $T=1087680 757645 0 0 $X=1087250 $Y=757255
X2074 18 45 46 36498 36329 ICV_77 $T=1099440 851725 0 0 $X=1099010 $Y=851335
X2075 18 45 59 37780 37916 ICV_77 $T=1143680 812525 0 0 $X=1143250 $Y=812135
X2076 18 45 38910 49 40027 ICV_77 $T=1206400 773325 0 0 $X=1205970 $Y=772935
X2077 18 45 47 39857 40356 ICV_77 $T=1216480 804685 1 0 $X=1216050 $Y=800130
X2103 28154 28005 45 18 28300 XOR2X1 $T=837920 741965 0 0 $X=837490 $Y=741575
X2104 29350 28442 45 18 29331 XOR2X1 $T=870960 773325 1 0 $X=870530 $Y=768770
X2105 108 28301 45 18 110 XOR2X1 $T=900640 734125 0 0 $X=900210 $Y=733735
X2106 30308 30032 45 18 30029 XOR2X1 $T=907920 781165 0 180 $X=901330 $Y=776610
X2107 28579 30289 45 18 30432 XOR2X1 $T=905120 749805 1 0 $X=904690 $Y=745250
X2108 30771 30154 45 18 30525 XOR2X1 $T=924160 789005 0 180 $X=917570 $Y=784450
X2109 30997 30754 45 18 30830 XOR2X1 $T=932000 773325 1 180 $X=925410 $Y=772935
X2110 123 120 45 18 31584 XOR2X1 $T=944320 741965 1 0 $X=943890 $Y=737410
X2111 32386 135 45 18 32617 XOR2X1 $T=979600 781165 0 0 $X=979170 $Y=780775
X2112 32106 31667 45 18 32386 XOR2X1 $T=986320 804685 1 180 $X=979730 $Y=804295
X2113 150 149 45 18 31862 XOR2X1 $T=989120 773325 1 180 $X=982530 $Y=772935
X2114 151 100 45 18 32108 XOR2X1 $T=993040 757645 1 180 $X=986450 $Y=757255
X2115 155 30770 45 18 32153 XOR2X1 $T=1005360 781165 0 180 $X=998770 $Y=776610
X2116 32565 33148 45 18 33361 XOR2X1 $T=999760 765485 0 0 $X=999330 $Y=765095
X2117 154 30770 45 18 33544 XOR2X1 $T=1003680 741965 1 0 $X=1003250 $Y=737410
X2118 158 33719 45 18 31863 XOR2X1 $T=1018800 781165 0 180 $X=1012210 $Y=776610
X2119 33073 33701 45 18 33933 XOR2X1 $T=1018240 781165 0 0 $X=1017810 $Y=780775
X2120 164 34071 45 18 34714 XOR2X1 $T=1042320 765485 1 0 $X=1041890 $Y=760930
X2121 32674 34514 45 18 34578 XOR2X1 $T=1052400 773325 0 180 $X=1045810 $Y=768770
X2122 167 34913 45 18 32106 XOR2X1 $T=1056320 765485 0 180 $X=1049730 $Y=760930
X2123 165 34529 45 18 34954 XOR2X1 $T=1050720 741965 0 0 $X=1050290 $Y=741575
X2124 35219 34895 45 18 35058 XOR2X1 $T=1066400 796845 0 180 $X=1059810 $Y=792290
X2125 172 100 45 18 35518 XOR2X1 $T=1068080 741965 0 0 $X=1067650 $Y=741575
X2126 35700 174 45 18 35799 XOR2X1 $T=1078720 734125 0 0 $X=1078290 $Y=733735
X2127 174 33544 45 18 36067 XOR2X1 $T=1088240 741965 1 0 $X=1087810 $Y=737410
X2128 36933 37377 45 18 37470 XOR2X1 $T=1129680 741965 1 0 $X=1129250 $Y=737410
X2146 18 45 53 51 52 ICV_79 $T=749440 734125 0 180 $X=746210 $Y=729570
X2147 18 45 47 26023 26551 ICV_79 $T=790320 836045 0 180 $X=787090 $Y=831490
X2148 18 45 46 28042 29096 ICV_79 $T=868720 859565 0 180 $X=865490 $Y=855010
X2149 18 45 29596 29656 29674 ICV_79 $T=887760 843885 0 180 $X=884530 $Y=839330
X2150 18 45 83 101 29777 ICV_79 $T=891680 765485 1 180 $X=888450 $Y=765095
X2151 18 45 83 99 29679 ICV_79 $T=894480 765485 0 180 $X=891250 $Y=760930
X2152 18 45 87 111 30558 ICV_79 $T=916880 749805 0 180 $X=913650 $Y=745250
X2153 18 45 46 29930 31547 ICV_79 $T=948240 867405 1 180 $X=945010 $Y=867015
X2154 18 45 31671 31667 31546 ICV_79 $T=953280 804685 0 180 $X=950050 $Y=800130
X2155 18 45 140 125 32152 ICV_79 $T=969520 749805 0 180 $X=966290 $Y=745250
X2156 18 45 32276 32133 32281 ICV_79 $T=972880 773325 1 180 $X=969650 $Y=772935
X2157 18 45 46 35397 35930 ICV_79 $T=1087120 859565 1 180 $X=1083890 $Y=859175
X2158 18 45 35978 178 35490 ICV_79 $T=1088240 765485 1 180 $X=1085010 $Y=765095
X2159 18 45 36102 35750 35927 ICV_79 $T=1092160 757645 0 180 $X=1088930 $Y=753090
X2160 18 45 36230 35963 35680 ICV_79 $T=1103920 781165 0 180 $X=1100690 $Y=776610
X2161 18 45 53 37256 37638 ICV_79 $T=1140320 828205 0 180 $X=1137090 $Y=823650
X2162 18 45 53 38462 38824 ICV_79 $T=1178960 781165 0 180 $X=1175730 $Y=776610
X2163 18 45 40026 198 40004 ICV_79 $T=1211440 741965 0 180 $X=1208210 $Y=737410
X2236 18 45 25372 25391 181 26173 ICV_80 $T=753360 812525 0 0 $X=752930 $Y=812135
X2237 18 45 26898 26860 181 102 ICV_80 $T=786960 741965 1 0 $X=786530 $Y=737410
X2238 18 45 28221 28273 181 28143 ICV_80 $T=833440 851725 0 0 $X=833010 $Y=851335
X2239 18 45 30462 30225 181 30499 ICV_80 $T=895600 867405 1 0 $X=895170 $Y=862850
X2240 18 45 32055 31915 181 31363 ICV_80 $T=949360 883085 1 0 $X=948930 $Y=878530
X2241 18 45 32318 33266 181 31363 ICV_80 $T=979040 859565 1 0 $X=978610 $Y=855010
X2242 18 45 156 33320 181 296 ICV_80 $T=996400 749805 1 0 $X=995970 $Y=745250
X2243 18 45 33773 33546 181 31363 ICV_80 $T=1000880 867405 0 0 $X=1000450 $Y=867015
X2244 18 45 34167 34133 181 33784 ICV_80 $T=1018240 828205 1 0 $X=1017810 $Y=823650
X2245 18 45 34736 34501 181 33784 ICV_80 $T=1033360 890925 1 0 $X=1032930 $Y=886370
X2246 18 45 34936 34802 181 33784 ICV_80 $T=1041200 851725 1 0 $X=1040770 $Y=847170
X2247 18 45 35061 34878 181 33784 ICV_80 $T=1049040 867405 0 0 $X=1048610 $Y=867015
X2248 18 45 35757 35800 181 34542 ICV_80 $T=1055760 812525 1 0 $X=1055330 $Y=807970
X2249 18 45 36498 36294 181 36042 ICV_80 $T=1100560 851725 1 0 $X=1100130 $Y=847170
X2250 18 45 37971 37749 181 37385 ICV_80 $T=1130240 843885 0 0 $X=1129810 $Y=843495
X2251 18 45 37780 37747 181 37803 ICV_80 $T=1132480 789005 1 0 $X=1132050 $Y=784450
X2252 18 45 38895 39535 181 39869 ICV_80 $T=1198000 836045 1 0 $X=1197570 $Y=831490
X2253 18 45 38330 40213 181 39869 ICV_80 $T=1199680 828205 1 0 $X=1199250 $Y=823650
X2254 18 45 47 24437 24910 ICV_71 $T=737680 757645 0 0 $X=737250 $Y=757255
X2255 18 45 47 24258 25293 ICV_71 $T=748320 789005 0 0 $X=747890 $Y=788615
X2256 18 45 27686 27670 27685 ICV_71 $T=821120 796845 0 0 $X=820690 $Y=796455
X2257 18 45 27384 49 27635 ICV_71 $T=821120 812525 0 0 $X=820690 $Y=812135
X2258 18 45 28221 49 27849 ICV_71 $T=837920 859565 0 0 $X=837490 $Y=859175
X2259 18 45 46 27236 28595 ICV_71 $T=850800 859565 0 0 $X=850370 $Y=859175
X2260 18 45 29331 83 29316 ICV_71 $T=871520 757645 0 0 $X=871090 $Y=757255
X2261 18 45 32008 31825 31990 ICV_71 $T=959440 789005 0 0 $X=959010 $Y=788615
X2262 18 45 124 141 143 ICV_71 $T=969520 734125 1 0 $X=969090 $Y=729570
X2263 18 45 32423 32316 32262 ICV_71 $T=972880 796845 1 0 $X=972450 $Y=792290
X2264 18 45 32517 32389 31671 ICV_71 $T=975680 812525 1 0 $X=975250 $Y=807970
X2265 18 45 32516 32497 32423 ICV_71 $T=976800 796845 1 0 $X=976370 $Y=792290
X2266 18 45 32617 32515 32473 ICV_71 $T=979040 773325 0 0 $X=978610 $Y=772935
X2267 18 45 32639 31587 32623 ICV_71 $T=979600 812525 1 0 $X=979170 $Y=807970
X2268 18 45 47 32055 32917 ICV_71 $T=988560 875245 1 0 $X=988130 $Y=870690
X2269 18 45 53 32970 33264 ICV_71 $T=998640 836045 0 0 $X=998210 $Y=835655
X2270 18 45 46 32916 34610 ICV_71 $T=1042320 867405 1 0 $X=1041890 $Y=862850
X2271 18 45 35058 83 34798 ICV_71 $T=1057440 765485 1 0 $X=1057010 $Y=760930
X2272 18 45 36793 36103 36836 ICV_71 $T=1116800 781165 1 0 $X=1116370 $Y=776610
X2273 18 45 46 35520 37236 ICV_71 $T=1124640 851725 0 0 $X=1124210 $Y=851335
X2274 18 45 38805 38685 38789 ICV_71 $T=1172240 781165 1 0 $X=1171810 $Y=776610
X2275 18 45 47 41024 41147 ICV_71 $T=1240000 741965 1 0 $X=1239570 $Y=737410
X2276 18 45 25413 25642 181 54 ICV_73 $T=752240 749805 0 0 $X=751810 $Y=749415
X2277 18 45 27409 27465 181 28143 ICV_73 $T=803760 843885 1 0 $X=803330 $Y=839330
X2278 18 45 29059 29332 181 29574 ICV_73 $T=863120 781165 1 0 $X=862690 $Y=776610
X2279 18 45 29281 29226 181 30499 ICV_73 $T=863120 875245 1 0 $X=862690 $Y=870690
X2280 18 45 29762 29670 181 29574 ICV_73 $T=872640 836045 1 0 $X=872210 $Y=831490
X2281 18 45 30031 29992 181 29574 ICV_73 $T=884960 789005 0 0 $X=884530 $Y=788615
X2282 18 45 30396 30226 181 30499 ICV_73 $T=894480 875245 1 0 $X=894050 $Y=870690
X2283 18 45 30490 30460 181 30499 ICV_73 $T=909040 804685 0 0 $X=908610 $Y=804295
X2284 18 45 34913 303 181 304 ICV_73 $T=1090480 734125 1 0 $X=1090050 $Y=729570
X2285 18 45 37814 37779 181 37803 ICV_73 $T=1131920 773325 1 0 $X=1131490 $Y=768770
X2286 18 45 37949 37915 181 37803 ICV_73 $T=1131920 781165 1 0 $X=1131490 $Y=776610
X2287 18 45 38351 38309 181 37803 ICV_73 $T=1148720 749805 0 0 $X=1148290 $Y=749415
X2288 18 45 199 313 181 201 ICV_73 $T=1199120 734125 1 0 $X=1198690 $Y=729570
X2289 18 45 40178 40177 181 39869 ICV_73 $T=1199680 781165 0 0 $X=1199250 $Y=780775
X2290 18 45 40552 40266 181 201 ICV_73 $T=1205840 749805 1 0 $X=1205410 $Y=745250
X2291 18 45 40906 40632 181 39869 ICV_73 $T=1221520 789005 0 0 $X=1221090 $Y=788615
X2292 18 45 208 41223 181 39869 ICV_73 $T=1232720 796845 1 0 $X=1232290 $Y=792290
X2293 18 45 25371 49 25351 ICV_82 $T=753920 773325 0 180 $X=750690 $Y=768770
X2294 18 45 53 26809 27110 ICV_82 $T=810480 789005 0 180 $X=807250 $Y=784450
X2295 18 45 53 27362 27686 ICV_82 $T=825040 804685 0 180 $X=821810 $Y=800130
X2296 18 45 30029 83 30013 ICV_82 $T=899520 765485 0 180 $X=896290 $Y=760930
X2297 18 45 46 29745 30751 ICV_82 $T=924160 875245 0 180 $X=920930 $Y=870690
X2298 18 45 46 31441 32498 ICV_82 $T=979600 875245 0 180 $X=976370 $Y=870690
X2299 18 45 32636 31296 32765 ICV_82 $T=988000 741965 0 180 $X=984770 $Y=737410
X2300 18 45 33052 32106 33032 ICV_82 $T=995840 804685 1 180 $X=992610 $Y=804295
X2301 18 45 35029 35059 35107 ICV_82 $T=1063600 843885 0 180 $X=1060370 $Y=839330
X2302 18 45 59 34955 35619 ICV_82 $T=1078160 828205 1 180 $X=1074930 $Y=827815
X2303 18 45 178 36310 36431 ICV_82 $T=1103360 765485 0 180 $X=1100130 $Y=760930
X2304 18 45 47 36265 36602 ICV_82 $T=1109520 859565 0 180 $X=1106290 $Y=855010
X2305 18 45 53 36312 36652 ICV_82 $T=1111200 836045 0 180 $X=1107970 $Y=831490
X2306 18 45 83 34913 36710 ICV_82 $T=1113440 734125 1 180 $X=1110210 $Y=733735
X2307 18 45 47 35061 36783 ICV_82 $T=1115680 851725 1 180 $X=1112450 $Y=851335
X2308 18 45 37470 83 185 ICV_82 $T=1134720 734125 1 180 $X=1131490 $Y=733735
X2309 18 45 53 37748 38159 ICV_82 $T=1158240 812525 1 180 $X=1155010 $Y=812135
X2310 18 45 38462 49 38726 ICV_82 $T=1176160 820365 0 180 $X=1172930 $Y=815810
X2311 18 45 39510 39432 39488 ICV_82 $T=1196880 749805 0 180 $X=1193650 $Y=745250
X2312 18 151 ANTENNA $T=993040 757645 0 0 $X=992610 $Y=757255
X2313 18 155 ANTENNA $T=1005360 781165 1 0 $X=1004930 $Y=776610
X2314 18 158 ANTENNA $T=1018800 781165 1 0 $X=1018370 $Y=776610
X2315 18 164 ANTENNA $T=1041200 765485 1 0 $X=1040770 $Y=760930
X2316 18 167 ANTENNA $T=1056320 765485 1 0 $X=1055890 $Y=760930
X2335 18 45 25704 26437 181 26173 ICV_84 $T=761200 789005 0 0 $X=760770 $Y=788615
X2336 18 45 25725 26147 181 26173 ICV_84 $T=761760 781165 1 0 $X=761330 $Y=776610
X2337 18 45 26311 26980 181 28143 ICV_84 $T=781920 836045 0 0 $X=781490 $Y=835655
X2338 18 45 26436 26828 181 102 ICV_84 $T=783600 757645 1 0 $X=783170 $Y=753090
X2339 18 45 26608 27406 181 28143 ICV_84 $T=789200 859565 0 0 $X=788770 $Y=859175
X2340 18 45 27384 27785 181 28178 ICV_84 $T=813280 796845 1 0 $X=812850 $Y=792290
X2341 18 45 27852 28185 181 28178 ICV_84 $T=829520 773325 1 0 $X=829090 $Y=768770
X2342 18 45 28042 29672 181 30499 ICV_84 $T=863120 867405 1 0 $X=862690 $Y=862850
X2343 18 45 30128 30831 181 113 ICV_84 $T=901200 796845 0 0 $X=900770 $Y=796455
X2344 18 45 111 30737 181 113 ICV_84 $T=907920 757645 1 0 $X=907490 $Y=753090
X2345 18 45 33075 33396 181 33784 ICV_84 $T=994720 820365 0 0 $X=994290 $Y=819975
X2346 18 45 34530 34912 181 36042 ICV_84 $T=1041200 836045 1 0 $X=1040770 $Y=831490
X2347 18 45 36312 36861 181 37385 ICV_84 $T=1097200 836045 0 0 $X=1096770 $Y=835655
X2348 18 45 37256 37796 181 37385 ICV_84 $T=1126880 836045 1 0 $X=1126450 $Y=831490
X2349 18 45 37748 38182 181 37385 ICV_84 $T=1141440 812525 1 0 $X=1141010 $Y=807970
X2350 18 45 37932 38703 181 37385 ICV_84 $T=1153200 851725 0 0 $X=1152770 $Y=851335
X2351 18 45 53 26255 26199 ICV_83 $T=776880 765485 1 0 $X=776450 $Y=760930
X2352 18 45 26291 26453 26437 ICV_83 $T=783040 789005 1 0 $X=782610 $Y=784450
X2353 18 45 26882 26917 26918 ICV_83 $T=798160 765485 1 0 $X=797730 $Y=760930
X2354 18 45 47 27327 27374 ICV_83 $T=818320 859565 1 0 $X=817890 $Y=855010
X2355 18 45 47 28042 27046 ICV_83 $T=832880 843885 0 0 $X=832450 $Y=843495
X2356 18 45 28253 28290 28273 ICV_83 $T=841280 851725 1 0 $X=840850 $Y=847170
X2357 18 45 29333 49 29671 ICV_83 $T=884960 851725 0 0 $X=884530 $Y=851335
X2358 18 45 53 29762 29688 ICV_83 $T=887760 828205 0 0 $X=887330 $Y=827815
X2359 18 45 59 30708 30772 ICV_83 $T=922480 836045 1 0 $X=922050 $Y=831490
X2360 18 45 31634 31671 31602 ICV_83 $T=948800 812525 1 0 $X=948370 $Y=807970
X2361 18 45 47 32318 30918 ICV_83 $T=970640 867405 0 0 $X=970210 $Y=867015
X2362 18 45 83 33719 34988 ICV_83 $T=1057440 773325 0 0 $X=1057010 $Y=772935
X2363 18 45 34954 83 35008 ICV_83 $T=1058560 741965 1 0 $X=1058130 $Y=737410
X2364 18 45 53 35982 35965 ICV_83 $T=1085440 836045 0 0 $X=1085010 $Y=835655
X2365 18 45 37358 37285 37375 ICV_83 $T=1129680 812525 1 0 $X=1129250 $Y=807970
X2366 18 45 53 39003 38964 ICV_83 $T=1179520 765485 1 0 $X=1179090 $Y=760930
.ENDS
***************************************
.SUBCKT ICV_46
** N=35 EP=0 IP=38 FDC=0
.ENDS
***************************************
.SUBCKT ICV_47
** N=69 EP=0 IP=75 FDC=0
.ENDS
***************************************
.SUBCKT ICV_48
** N=69 EP=0 IP=138 FDC=0
.ENDS
***************************************
.SUBCKT ICV_36
** N=5 EP=0 IP=8 FDC=0
.ENDS
***************************************
.SUBCKT ICV_40
** N=7 EP=0 IP=17 FDC=0
.ENDS
***************************************
.SUBCKT ICV_49 62 102
** N=219245 EP=2 IP=887 FDC=1
D0 62 102 pdio_m AREA=9e-10 PJ=0.00012 $X=171260 $Y=969475 $D=31
.ENDS
***************************************
.SUBCKT ICV_31
** N=4 EP=0 IP=8 FDC=0
.ENDS
***************************************
.SUBCKT ICV_32 72 132
** N=77688 EP=2 IP=225 FDC=1
D0 72 132 ndio_m AREA=9e-10 PJ=0.00012 $X=707490 $Y=1314355 $D=30
.ENDS
***************************************
.SUBCKT ICV_14
** N=3 EP=0 IP=6 FDC=0
.ENDS
***************************************
.SUBCKT ICV_30
** N=120061 EP=0 IP=76 FDC=0
.ENDS
***************************************
.SUBCKT ICV_7
** N=714 EP=0 IP=4 FDC=0
.ENDS
***************************************
.SUBCKT ICV_5
** N=632 EP=0 IP=4 FDC=0
.ENDS
***************************************
.SUBCKT ICV_3
** N=693 EP=0 IP=4 FDC=0
.ENDS
***************************************
.SUBCKT ICV_9 32 33 34
** N=3232 EP=3 IP=5 FDC=96
X0 32 33 34 pad_in $T=0 0 0 0 $X=-900 $Y=0
.ENDS
***************************************
.SUBCKT ICV_8 32 33 37
** N=3326 EP=3 IP=5 FDC=96
X0 32 33 37 pad_in $T=0 0 0 0 $X=-900 $Y=0
.ENDS
***************************************
.SUBCKT ICV_1 30 31 32
** N=3314 EP=3 IP=5 FDC=96
X0 30 31 32 pad_in $T=0 0 0 0 $X=-900 $Y=0
.ENDS
***************************************
.SUBCKT ICV_26
** N=13677 EP=0 IP=45 FDC=0
.ENDS
***************************************
.SUBCKT ICV_25
** N=22249 EP=0 IP=79 FDC=0
.ENDS
***************************************
.SUBCKT ICV_6
** N=708 EP=0 IP=4 FDC=0
.ENDS
***************************************
.SUBCKT ICV_24 57 59 115
** N=22602 EP=3 IP=113 FDC=96
X31 57 59 115 pad_in $T=1771680 531325 0 90 $X=1537580 $Y=530425
.ENDS
***************************************
.SUBCKT ICV_4
** N=708 EP=0 IP=4 FDC=0
.ENDS
***************************************
.SUBCKT ICV_23 1 2 3 4 5 62
** N=21378 EP=6 IP=115 FDC=52
M0 4 1 62 62 N L=3.5e-07 W=2e-05 $X=1549200 $Y=933815 $D=0
M1 62 1 4 62 N L=3.5e-07 W=2e-05 $X=1554110 $Y=933815 $D=0
M2 4 1 62 62 N L=3.5e-07 W=2e-05 $X=1555680 $Y=933815 $D=0
M3 62 1 4 62 N L=3.5e-07 W=2e-05 $X=1560590 $Y=933815 $D=0
M4 4 1 62 62 N L=3.5e-07 W=2e-05 $X=1562160 $Y=933815 $D=0
M5 62 1 4 62 N L=3.5e-07 W=2e-05 $X=1567070 $Y=933815 $D=0
M6 4 1 62 62 N L=3.5e-07 W=2e-05 $X=1568640 $Y=933815 $D=0
M7 62 1 4 62 N L=3.5e-07 W=2e-05 $X=1573550 $Y=933815 $D=0
M8 4 1 62 62 N L=3.5e-07 W=2e-05 $X=1575120 $Y=933815 $D=0
M9 62 1 4 62 N L=3.5e-07 W=2e-05 $X=1580030 $Y=933815 $D=0
M10 62 3 555 62 N L=3.5e-07 W=9e-06 $X=1615580 $Y=923745 $D=0
M11 556 555 62 62 N L=3.5e-07 W=9e-06 $X=1615580 $Y=926145 $D=0
M12 62 2 1 62 N L=3.5e-07 W=9e-06 $X=1615580 $Y=931245 $D=0
M13 1 2 62 62 N L=3.5e-07 W=9e-06 $X=1615580 $Y=933645 $D=0
M14 62 2 1 62 N L=3.5e-07 W=9e-06 $X=1615580 $Y=936045 $D=0
M15 1 2 62 62 N L=3.5e-07 W=9e-06 $X=1615580 $Y=938445 $D=0
M16 62 2 1 62 N L=3.5e-07 W=9e-06 $X=1615580 $Y=940845 $D=0
M17 1 555 62 62 N L=3.5e-07 W=9e-06 $X=1615580 $Y=943245 $D=0
M18 62 555 1 62 N L=3.5e-07 W=9e-06 $X=1615580 $Y=945645 $D=0
M19 1 555 62 62 N L=3.5e-07 W=9e-06 $X=1615580 $Y=948045 $D=0
M20 62 555 1 62 N L=3.5e-07 W=9e-06 $X=1615580 $Y=950445 $D=0
M21 1 555 62 62 N L=3.5e-07 W=9e-06 $X=1615580 $Y=952845 $D=0
M22 5 556 1 62 N L=3.5e-07 W=9e-06 $X=1615580 $Y=955245 $D=0
M23 1 556 5 62 N L=3.5e-07 W=9e-06 $X=1615580 $Y=957645 $D=0
M24 5 556 1 62 N L=3.5e-07 W=9e-06 $X=1615580 $Y=960045 $D=0
M25 1 556 5 62 N L=3.5e-07 W=9e-06 $X=1615580 $Y=962445 $D=0
M26 3 3 555 3 P L=3.5e-07 W=1.56e-05 $X=1590530 $Y=923745 $D=16
M27 556 555 3 3 P L=3.5e-07 W=1.56e-05 $X=1590530 $Y=926145 $D=16
M28 3 2 5 3 P L=3.5e-07 W=1.56e-05 $X=1590530 $Y=931245 $D=16
M29 5 2 3 3 P L=3.5e-07 W=1.56e-05 $X=1590530 $Y=933645 $D=16
M30 3 2 5 3 P L=3.5e-07 W=1.56e-05 $X=1590530 $Y=936045 $D=16
M31 5 2 3 3 P L=3.5e-07 W=1.56e-05 $X=1590530 $Y=938445 $D=16
M32 3 2 5 3 P L=3.5e-07 W=1.56e-05 $X=1590530 $Y=940845 $D=16
M33 5 556 3 3 P L=3.5e-07 W=1.56e-05 $X=1590530 $Y=943245 $D=16
M34 3 556 5 3 P L=3.5e-07 W=1.56e-05 $X=1590530 $Y=945645 $D=16
M35 5 556 3 3 P L=3.5e-07 W=1.56e-05 $X=1590530 $Y=948045 $D=16
M36 3 556 5 3 P L=3.5e-07 W=1.56e-05 $X=1590530 $Y=950445 $D=16
M37 5 556 3 3 P L=3.5e-07 W=1.56e-05 $X=1590530 $Y=952845 $D=16
M38 1 555 5 3 P L=3.5e-07 W=1.56e-05 $X=1590530 $Y=955245 $D=16
M39 5 555 1 3 P L=3.5e-07 W=1.56e-05 $X=1590530 $Y=957645 $D=16
M40 1 555 5 3 P L=3.5e-07 W=1.56e-05 $X=1590530 $Y=960045 $D=16
M41 5 555 1 3 P L=3.5e-07 W=1.56e-05 $X=1590530 $Y=962445 $D=16
M42 4 5 3 3 P L=3.5e-07 W=2e-05 $X=1643415 $Y=933840 $D=16
M43 3 5 4 3 P L=3.5e-07 W=2e-05 $X=1648325 $Y=933840 $D=16
M44 4 5 3 3 P L=3.5e-07 W=2e-05 $X=1649895 $Y=933840 $D=16
M45 3 5 4 3 P L=3.5e-07 W=2e-05 $X=1654805 $Y=933840 $D=16
M46 4 5 3 3 P L=3.5e-07 W=2e-05 $X=1656375 $Y=933840 $D=16
M47 3 5 4 3 P L=3.5e-07 W=2e-05 $X=1661285 $Y=933840 $D=16
M48 4 5 3 3 P L=3.5e-07 W=2e-05 $X=1662855 $Y=933840 $D=16
M49 3 5 4 3 P L=3.5e-07 W=2e-05 $X=1667765 $Y=933840 $D=16
M50 4 5 3 3 P L=3.5e-07 W=2e-05 $X=1669335 $Y=933840 $D=16
M51 3 5 4 3 P L=3.5e-07 W=2e-05 $X=1674245 $Y=933840 $D=16
.ENDS
***************************************
.SUBCKT ICV_22 1 2 3 60 61
** N=23583 EP=5 IP=75 FDC=44
M0 2 1 60 60 N L=3.5e-07 W=2e-05 $X=1549200 $Y=972275 $D=0
M1 60 1 2 60 N L=3.5e-07 W=2e-05 $X=1554110 $Y=972275 $D=0
M2 2 1 60 60 N L=3.5e-07 W=2e-05 $X=1555680 $Y=972275 $D=0
M3 60 1 2 60 N L=3.5e-07 W=2e-05 $X=1560590 $Y=972275 $D=0
M4 2 1 60 60 N L=3.5e-07 W=2e-05 $X=1562160 $Y=972275 $D=0
M5 60 1 2 60 N L=3.5e-07 W=2e-05 $X=1567070 $Y=972275 $D=0
M6 2 1 60 60 N L=3.5e-07 W=2e-05 $X=1568640 $Y=972275 $D=0
M7 60 1 2 60 N L=3.5e-07 W=2e-05 $X=1573550 $Y=972275 $D=0
M8 2 1 60 60 N L=3.5e-07 W=2e-05 $X=1575120 $Y=972275 $D=0
M9 60 1 2 60 N L=3.5e-07 W=2e-05 $X=1580030 $Y=972275 $D=0
M10 568 2 60 60 N L=3.5e-07 W=9e-06 $X=1615730 $Y=977445 $D=0
M11 60 2 568 60 N L=3.5e-07 W=9e-06 $X=1615730 $Y=979845 $D=0
M12 568 2 60 60 N L=3.5e-07 W=9e-06 $X=1615730 $Y=982245 $D=0
M13 60 2 568 60 N L=3.5e-07 W=9e-06 $X=1615730 $Y=984645 $D=0
M14 568 2 60 60 N L=3.5e-07 W=9e-06 $X=1615730 $Y=987045 $D=0
M15 60 2 568 60 N L=3.5e-07 W=9e-06 $X=1615730 $Y=989445 $D=0
M16 2361 568 60 60 N L=3.5e-07 W=9e-06 $X=1615730 $Y=991845 $D=0
M17 60 568 2361 60 N L=3.5e-07 W=9e-06 $X=1615730 $Y=994245 $D=0
M18 2361 568 60 60 N L=3.5e-07 W=9e-06 $X=1615730 $Y=996645 $D=0
M19 60 568 2361 60 N L=3.5e-07 W=9e-06 $X=1615730 $Y=999045 $D=0
M20 2361 568 60 60 N L=3.5e-07 W=9e-06 $X=1615730 $Y=1001445 $D=0
M21 60 568 2361 60 N L=3.5e-07 W=9e-06 $X=1615730 $Y=1003845 $D=0
M22 568 2 61 61 P L=3.5e-07 W=1.56e-05 $X=1590530 $Y=977445 $D=16
M23 61 2 568 61 P L=3.5e-07 W=1.56e-05 $X=1590530 $Y=979845 $D=16
M24 568 2 61 61 P L=3.5e-07 W=1.56e-05 $X=1590530 $Y=982245 $D=16
M25 61 2 568 61 P L=3.5e-07 W=1.56e-05 $X=1590530 $Y=984645 $D=16
M26 568 2 61 61 P L=3.5e-07 W=1.56e-05 $X=1590530 $Y=987045 $D=16
M27 61 2 568 61 P L=3.5e-07 W=1.56e-05 $X=1590530 $Y=989445 $D=16
M28 2361 568 61 61 P L=3.5e-07 W=1.56e-05 $X=1590530 $Y=991845 $D=16
M29 61 568 2361 61 P L=3.5e-07 W=1.56e-05 $X=1590530 $Y=994245 $D=16
M30 2361 568 61 61 P L=3.5e-07 W=1.56e-05 $X=1590530 $Y=996645 $D=16
M31 61 568 2361 61 P L=3.5e-07 W=1.56e-05 $X=1590530 $Y=999045 $D=16
M32 2361 568 61 61 P L=3.5e-07 W=1.56e-05 $X=1590530 $Y=1001445 $D=16
M33 61 568 2361 61 P L=3.5e-07 W=1.56e-05 $X=1590530 $Y=1003845 $D=16
M34 2 3 61 61 P L=3.5e-07 W=2e-05 $X=1643415 $Y=971375 $D=16
M35 61 3 2 61 P L=3.5e-07 W=2e-05 $X=1648325 $Y=971375 $D=16
M36 2 3 61 61 P L=3.5e-07 W=2e-05 $X=1649895 $Y=971375 $D=16
M37 61 3 2 61 P L=3.5e-07 W=2e-05 $X=1654805 $Y=971375 $D=16
M38 2 3 61 61 P L=3.5e-07 W=2e-05 $X=1656375 $Y=971375 $D=16
M39 61 3 2 61 P L=3.5e-07 W=2e-05 $X=1661285 $Y=971375 $D=16
M40 2 3 61 61 P L=3.5e-07 W=2e-05 $X=1662855 $Y=971375 $D=16
M41 61 3 2 61 P L=3.5e-07 W=2e-05 $X=1667765 $Y=971375 $D=16
M42 2 3 61 61 P L=3.5e-07 W=2e-05 $X=1669335 $Y=971375 $D=16
M43 61 3 2 61 P L=3.5e-07 W=2e-05 $X=1674245 $Y=971375 $D=16
.ENDS
***************************************
.SUBCKT ICV_2
** N=704 EP=0 IP=4 FDC=0
.ENDS
***************************************
.SUBCKT ICV_21
** N=20696 EP=0 IP=109 FDC=0
.ENDS
***************************************
.SUBCKT ICV_27
** N=23930 EP=0 IP=90 FDC=0
.ENDS
***************************************
.SUBCKT ICV_20
** N=28071 EP=0 IP=72 FDC=0
.ENDS
***************************************
.SUBCKT top_pad_merged VSS VDD
** N=8487 EP=2 IP=17153 FDC=42683
X4 VSS VDD 1241 1244 1243 2888 1367 1247 4388 4387 4386 4385 1246 1249 4391 1250 4392 1251 4390 4395
+ 4455 1279 1252 1257 4461 4431 4462 1254 1253 1332 4401 4396 4417 4394 1270 1288 4405 1304 1256 1255
+ 4403 1284 4404 4397 1259 1258 4459 4402 4406 4400 1322 4408 4407 1268 1266 1311 4468 4398 2889 4422
+ 1260 1261 4413 1262 1263 1264 2890 4412 1272 1265 2891 4414 4416 4415 1307 1267 4427 4419 4410 4418
+ 1269 4420 1271 4428 4447 1345 4421 4425 2802 4399 4423 1273 4434 4424 4432 1278 4411 4426 1274 1275
+ 4409 1277 1276 1286 4443 4449 1298 4435 1281 4429 1280 1283 1282 4433 4458 4436 4437 4445 1285 4448
+ 1287 1289 4441 1290 1291 4440 4439 4430 4442 4457 1330 1292 4444 4465 1293 4446 4453 1299 4454 4450
+ 1296 1308 1295 4456 1305 1302 1294 2803 1301 1297 1318 4452 4460 1306 4502 1303 1352 1312 4464 1313
+ 4506 4469 4470 1314 4488 1316 1315 1317 4467 1320 1319 4463 4472 2893 4476 4481 4479 4473 4474 4483
+ 4477 1324 1310 1309 1300 4471 4495 1321 4475 1323 1328 4466 1325 4480 2804 1326 4505 4484 1327 1329
+ 1373 4486 4487 1372 1331 4490 4485 1333 4493 4491 4489 4492 4494 1339 1334 4501 4496 1335 1336 4497
+ 1338 4516 4498 4499 4515 4393 1350 4504 1340 1337 1343 4478 4482 1342 1344 1341 4500 1351 4503 4507
+ 4511 4510 4508 4513 1353 4509 1346 1348 1349 1347 1356 4528 1357 4534 1365 4529 4525 1358 1359 1496
+ 1363 1364 1366 1368 4536 1481 4539 4537 1240 1242 4383 4384 1245 1248 4389 1362 4533 4521 4523 4535
+ 1369 4538
+ ICV_117 $T=0 0 0 0 $X=-80000 $Y=234005
X7 VSS VDD 1416 4618 1415 1418 1367 4529 1247 1240 4632 1496 1419 2888 1420 1241 4620 1479 1417 1244
+ 1421 1481 4623 1242 1352 2979 4386 1243 4622 4621 4383 1246 1245 1422 1423 4630 4385 1248 4388 4387
+ 4626 1424 1249 1250 1425 4629 4625 1426 4627 4656 1441 4390 1427 4628 1434 1428 1429 4389 1431 1432
+ 1433 1430 4391 1435 1436 1437 1438 1439 4631 1440 1442 1443 4393 4633 4634 4640 4637 1444 4635 4394
+ 1446 4395 4636 1445 4396 4646 1252 1447 4392 1251 1271 4638 1449 1254 1253 4401 4421 4461 4641 1275
+ 4402 4405 1332 1356 4397 4639 1255 4412 4408 4400 1448 4406 4404 1256 1261 4398 4403 2889 4407 4409
+ 4643 1257 4642 1259 4468 4437 1260 1304 1258 1450 1262 4410 4413 1322 4459 4399 1451 4430 1263 1311
+ 1265 4411 4645 4462 1268 1264 1266 4414 4455 1267 4415 2890 1452 4420 1345 1286 4417 4416 4418 4447
+ 1270 4423 1269 1273 4435 1453 1272 1307 2891 4426 1454 4422 1274 4424 1455 4419 4425 4444 4451 4427
+ 1239 1277 1280 4429 4428 1278 1279 4449 2803 1281 4438 4502 1285 4433 4443 1282 1283 1456 4665 1276
+ 4458 4434 4432 4436 1284 4452 4647 4431 4649 1457 4439 1288 1287 4655 1330 4441 4440 4448 1460 1289
+ 1458 4450 1474 1470 4648 1459 1293 1290 1291 1292 4465 4442 1461 1463 4657 4658 1473 4445 1464 4653
+ 4457 1466 4446 1465 1467 1303 1462 1294 4651 1295 1468 1469 4453 4460 1296 4456 4652 1471 1308 1302
+ 4650 1318 1299 4654 1472 1306 1298 1297 1475 4672 1476 1477 4454 1301 1478 2994 2995 1312 1480 1344
+ 1313 1305 4491 4463 4503 2804 4661 1485 1316 1315 4466 1325 4467 4487 2996 1317 4473 1342 4469 1319
+ 4471 1320 1314 4660 4472 1321 4662 4475 4464 4476 1323 4483 4481 1351 4474 4663 4478 4477 1324 4479
+ 4480 4470 1326 4489 4664 4485 1353 4484 4482 1329 1328 3000 4486 1331 4494 1327 1333 1349 4492 4490
+ 1334 4493 1483 1484 4488 1335 4659 4496 3003 4495 3001 2893 1336 4501 1348 4516 1338 4497 4499 1337
+ 1341 4500 4515 4498 1340 1339 3004 4507 4504 4511 1343 4505 4666 1491 4506 4673 4667 4510 4508 4509
+ 1346 1350 4513 4668 1347 4669 1487 1486 1489 1490 4671 4521 3011 4674 4523 4525 4670 4675 1359 4676
+ 1358 4677 4528 1492 4678 1495 4533 1493 1494 1363 1366 1365 1368 4535 4679 1369 1497 4537 4534 4538
+ 1498 4536 4680 4681 1501 1500 1502 1499 4683 4684 4685 4539 4686 2937 4619 4384 4624 4644 1482 1488
+ 1357 1364 4682
+ ICV_114 $T=0 0 0 0 $X=-80000 $Y=486530
X8 VSS VDD 4683 4685 1416 1501 4618 1415 1420 1418 4619 4636 1417 1419 4620 1496 2979 4529 4621 4623
+ 4622 1423 4626 1424 4627 1425 4625 4628 1427 1426 1429 1428 1430 1432 4629 1434 1431 1436 1435 1352
+ 1437 1433 1438 4632 1439 4631 1440 1441 4640 1442 4633 1443 1444 4630 4634 4642 1446 4635 4624 4637
+ 4638 1449 4639 1452 4643 1448 1462 4641 1450 4644 1453 4645 1454 4646 1455 1459 4649 1457 1456 1458
+ 1472 1469 4655 1460 1470 4647 4648 1461 1463 4651 1466 4650 1464 1465 1467 1468 4652 1471 4654 1474
+ 4653 1473 1475 1476 1477 4657 4660 1310 1479 2994 1480 1300 4659 2995 1309 2996 1481 4662 4663 4664
+ 1373 1478 3000 1372 3001 1482 4665 3003 3004 1483 1485 1484 4656 4666 4668 1487 1566 4384 1489 1488
+ 4669 4671 4673 1491 4675 4672 4674 4676 3011 4677 1492 4678 1493 1495 4679 1498 4680 4682 4681 1499
+ 4684 1500 4686 1502 3056 1421 1422 1447 1445 1451 4658 4661 1486 4667 1490 4670 1494 1497
+ ICV_85 $T=0 0 0 0 $X=-80000 $Y=729570
X9 VSS VDD ICV_49 $T=0 0 0 0 $X=-80000 $Y=964770
X10 VSS VDD ICV_32 $T=0 0 0 0 $X=-80000 $Y=1224800
X15 VSS VDD 1239 ICV_9 $T=658270 1405 0 0 $X=657370 $Y=1405
X16 VSS VDD 1362 ICV_8 $T=1098375 1405 0 0 $X=1097475 $Y=1405
X17 VSS VDD 1566 ICV_1 $T=1188375 1537965 0 180 $X=1097475 $Y=1303865
X21 VSS VDD 2937 ICV_24 $T=0 0 0 0 $X=1537580 $Y=487800
X23 906 3056 VDD 390 477 VSS ICV_23 $T=0 0 0 0 $X=1537580 $Y=729600
X24 906 390 477 VSS VDD ICV_22 $T=0 0 0 0 $X=1537580 $Y=964800
*.CALIBRE WARNING SCONNECT SCONNECT conflict(s) detected by extraction in this cell. See extraction report for details.
.ENDS
***************************************
