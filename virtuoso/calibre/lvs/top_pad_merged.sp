* SPICE NETLIST
***************************************

.SUBCKT crtmom PLUS MINUS BULK
.ENDS
***************************************
.SUBCKT cfmom PLUS MINUS BULK
.ENDS
***************************************
.SUBCKT cfmom_rf PLUS MINUS BULK
.ENDS
***************************************
.SUBCKT cfmom_mx PLUS1 MINUS1 PLUS2 MINUS2 BULK
.ENDS
***************************************
.SUBCKT lcesd1_rf PLUS MINUS
.ENDS
***************************************
.SUBCKT lcesd2_rf PLUS MINUS
.ENDS
***************************************
.SUBCKT mimcap_2p0_shield PLUS MINUS BULK
.ENDS
***************************************
.SUBCKT mimcap_2p0_sin TOP BOT
.ENDS
***************************************
.SUBCKT mimcap_2p0_sin_3t PLUS MINUS BULK
.ENDS
***************************************
.SUBCKT mimcap_2p0_wos PLUS MINUS BULK
.ENDS
***************************************
.SUBCKT moscap_rf PLUS MINUS BULK
.ENDS
***************************************
.SUBCKT moscap_rf33 PLUS MINUS BULK
.ENDS
***************************************
.SUBCKT moscap_rf33_nw PLUS MINUS BULK
.ENDS
***************************************
.SUBCKT moscap_rf_nw PLUS MINUS BULK
.ENDS
***************************************
.SUBCKT nmos_rf D G S B
.ENDS
***************************************
.SUBCKT nmos_rf33 D G S B
.ENDS
***************************************
.SUBCKT nmos_rf33_6t D G S B NG PG
.ENDS
***************************************
.SUBCKT nmos_rf_6t D G S B NG PG
.ENDS
***************************************
.SUBCKT nmoscap PLUS MINUS
.ENDS
***************************************
.SUBCKT nmoscap_33 PLUS MINUS
.ENDS
***************************************
.SUBCKT pmos_rf D G S B
.ENDS
***************************************
.SUBCKT pmos_rf33 D G S B
.ENDS
***************************************
.SUBCKT pmos_rf33_5t D G S B PG
.ENDS
***************************************
.SUBCKT pmos_rf33_nw D G S B
.ENDS
***************************************
.SUBCKT pmos_rf33_nw_5t D G S B PG
.ENDS
***************************************
.SUBCKT pmos_rf_5t D G S B PG
.ENDS
***************************************
.SUBCKT pmos_rf_nw D G S B
.ENDS
***************************************
.SUBCKT pmos_rf_nw_5t D G S B PG
.ENDS
***************************************
.SUBCKT rnod_m PLUS MINUS B
.ENDS
***************************************
.SUBCKT rnodrpo_m PLUS MINUS B
.ENDS
***************************************
.SUBCKT rnodw_m PLUS MINUS B
.ENDS
***************************************
.SUBCKT rnpo1_dis PLUS MINUS B
.ENDS
***************************************
.SUBCKT rnpo1rpo_dis PLUS MINUS B
.ENDS
***************************************
.SUBCKT rnpo1w_dis PLUS MINUS B
.ENDS
***************************************
.SUBCKT rnwod_m PLUS MINUS B
.ENDS
***************************************
.SUBCKT rnwsti_m PLUS MINUS B
.ENDS
***************************************
.SUBCKT rpod_m PLUS MINUS B
.ENDS
***************************************
.SUBCKT rpodrpo_m PLUS MINUS B
.ENDS
***************************************
.SUBCKT rpodw_m PLUS MINUS B
.ENDS
***************************************
.SUBCKT rppo1_dis PLUS MINUS B
.ENDS
***************************************
.SUBCKT rppo1rpo_dis PLUS MINUS B
.ENDS
***************************************
.SUBCKT rppo1w_dis PLUS MINUS B
.ENDS
***************************************
.SUBCKT rppolyhri_dis PLUS MINUS B
.ENDS
***************************************
.SUBCKT rppolyhri_rf PLUS MINUS BULK
.ENDS
***************************************
.SUBCKT rppolyl_rf PLUS MINUS BULK
.ENDS
***************************************
.SUBCKT rppolys_rf PLUS MINUS BULK
.ENDS
***************************************
.SUBCKT rppolywo_rf PLUS MINUS BULK
.ENDS
***************************************
.SUBCKT sbd_rf PLUS MINUS BULK
.ENDS
***************************************
.SUBCKT sbd_rf_nw PLUS MINUS BULK
.ENDS
***************************************
.SUBCKT spiral_std_mu_x_40k PLUS MINUS BULK
.ENDS
***************************************
.SUBCKT spiral_sym_ct_mu_x_40k PLUS MINUS BULK CTAP
.ENDS
***************************************
.SUBCKT spiral_sym_mu_x_40k PLUS MINUS BULK
.ENDS
***************************************
.SUBCKT xjvar_nr36 PLUS MINUS BULK
.ENDS
***************************************
.SUBCKT xjvar_w40 PLUS MINUS BULK
.ENDS
***************************************
.SUBCKT tsmc_c018_sealring_corner_1p6m
** N=2 EP=0 IP=0 FDC=0
.ENDS
***************************************
.SUBCKT tsmc_c018_seal_ring_edge_1p6m
** N=2 EP=0 IP=0 FDC=0
.ENDS
***************************************
.SUBCKT ICV_10
** N=2 EP=0 IP=4 FDC=0
.ENDS
***************************************
.SUBCKT ICV_11
** N=2 EP=0 IP=4 FDC=0
.ENDS
***************************************
.SUBCKT ICV_12
** N=2 EP=0 IP=4 FDC=0
.ENDS
***************************************
.SUBCKT ICV_13
** N=2 EP=0 IP=4 FDC=0
.ENDS
***************************************
.SUBCKT ICV_15
** N=2 EP=0 IP=4 FDC=0
.ENDS
***************************************
.SUBCKT ICV_16
** N=2 EP=0 IP=4 FDC=0
.ENDS
***************************************
.SUBCKT ICV_17
** N=2 EP=0 IP=4 FDC=0
.ENDS
***************************************
.SUBCKT ICV_18
** N=2 EP=0 IP=4 FDC=0
.ENDS
***************************************
.SUBCKT ICV_19
** N=2 EP=0 IP=4 FDC=0
.ENDS
***************************************
.SUBCKT ICV_28
** N=2 EP=0 IP=4 FDC=0
.ENDS
***************************************
.SUBCKT ICV_29
** N=2 EP=0 IP=4 FDC=0
.ENDS
***************************************
.SUBCKT ICV_120
** N=102759 EP=0 IP=62 FDC=0
.ENDS
***************************************
.SUBCKT pad_corner
** N=4 EP=0 IP=0 FDC=0
*.CALIBRE ISOLATED NETS: VSS VDD
.ENDS
***************************************
.SUBCKT pad_fill_32
** N=4 EP=0 IP=0 FDC=0
*.CALIBRE ISOLATED NETS: VSS VDD
.ENDS
***************************************
.SUBCKT ICV_118
** N=4 EP=0 IP=8 FDC=0
.ENDS
***************************************
.SUBCKT pad_fill_16
** N=4 EP=0 IP=0 FDC=0
*.CALIBRE ISOLATED NETS: VSS VDD
.ENDS
***************************************
.SUBCKT pad_fill_8
** N=4 EP=0 IP=0 FDC=0
*.CALIBRE ISOLATED NETS: VSS VDD
.ENDS
***************************************
.SUBCKT pad_fill_4
** N=4 EP=0 IP=0 FDC=0
*.CALIBRE ISOLATED NETS: VSS VDD
.ENDS
***************************************
.SUBCKT pad_fill_2
** N=4 EP=0 IP=0 FDC=0
*.CALIBRE ISOLATED NETS: VSS VDD
.ENDS
***************************************
.SUBCKT pad_fill_01
** N=4 EP=0 IP=0 FDC=0
*.CALIBRE ISOLATED NETS: VSS VDD
.ENDS
***************************************
.SUBCKT pad_fill_005
** N=4 EP=0 IP=0 FDC=0
*.CALIBRE ISOLATED NETS: VSS VDD
.ENDS
***************************************
.SUBCKT ICV_119
** N=36581 EP=0 IP=150 FDC=0
.ENDS
***************************************
.SUBCKT FILL32
** N=8 EP=0 IP=0 FDC=0
.ENDS
***************************************
.SUBCKT ICV_37
** N=4 EP=0 IP=8 FDC=0
.ENDS
***************************************
.SUBCKT ICV_38
** N=5 EP=0 IP=8 FDC=0
.ENDS
***************************************
.SUBCKT ICV_41
** N=5 EP=0 IP=8 FDC=0
.ENDS
***************************************
.SUBCKT ICV_42
** N=5 EP=0 IP=10 FDC=0
.ENDS
***************************************
.SUBCKT ICV_43
** N=7 EP=0 IP=10 FDC=0
.ENDS
***************************************
.SUBCKT ICV_44
** N=11 EP=0 IP=14 FDC=0
.ENDS
***************************************
.SUBCKT ICV_45
** N=19 EP=0 IP=22 FDC=0
.ENDS
***************************************
.SUBCKT ICV_116
** N=19 EP=0 IP=38 FDC=0
.ENDS
***************************************
.SUBCKT FILL16
** N=8 EP=0 IP=0 FDC=0
.ENDS
***************************************
.SUBCKT FILL8
** N=8 EP=0 IP=0 FDC=0
.ENDS
***************************************
.SUBCKT ICV_55
** N=4 EP=0 IP=8 FDC=0
.ENDS
***************************************
.SUBCKT FILL4
** N=4 EP=0 IP=0 FDC=0
.ENDS
***************************************
.SUBCKT ICV_53
** N=4 EP=0 IP=8 FDC=0
.ENDS
***************************************
.SUBCKT FILL1
** N=4 EP=0 IP=0 FDC=0
.ENDS
***************************************
.SUBCKT DFFQSRX1 D CLK SETB RESETB VSS VDD Q
** N=34 EP=7 IP=0 FDC=40
M0 VSS D 20 VSS N L=1.8e-07 W=2.2e-07 $X=945 $Y=750 $D=0
M1 10 CLK VSS VSS N L=1.8e-07 W=2.2e-07 $X=1745 $Y=750 $D=0
M2 11 10 20 VSS N L=1.8e-07 W=2.2e-07 $X=3245 $Y=755 $D=0
M3 12 11 VSS VSS N L=1.8e-07 W=2.2e-07 $X=4745 $Y=755 $D=0
M4 13 12 VSS VSS N L=1.8e-07 W=2.2e-07 $X=6250 $Y=760 $D=0
M5 VSS 14 13 VSS N L=1.8e-07 W=2.2e-07 $X=7050 $Y=760 $D=0
M6 15 13 VSS VSS N L=1.8e-07 W=2.2e-07 $X=7850 $Y=1120 $D=0
M7 VSS SETB 14 VSS N L=1.8e-07 W=2.2e-07 $X=9355 $Y=755 $D=0
M8 22 CLK 11 VSS N L=1.8e-07 W=2.2e-07 $X=10860 $Y=750 $D=0
M9 33 15 VSS VSS N L=1.8e-07 W=4.4e-07 $X=12320 $Y=965 $D=0
M10 22 RESETB 33 VSS N L=1.8e-07 W=4.4e-07 $X=13040 $Y=965 $D=0
M11 16 CLK 15 VSS N L=1.8e-07 W=2.2e-07 $X=14500 $Y=755 $D=0
M12 34 16 VSS VSS N L=1.8e-07 W=4.4e-07 $X=15960 $Y=740 $D=0
M13 17 RESETB 34 VSS N L=1.8e-07 W=4.4e-07 $X=16680 $Y=740 $D=0
M14 18 17 VSS VSS N L=1.8e-07 W=2.2e-07 $X=18140 $Y=755 $D=0
M15 19 18 VSS VSS N L=1.8e-07 W=2.2e-07 $X=19640 $Y=755 $D=0
M16 VSS 14 19 VSS N L=1.8e-07 W=2.2e-07 $X=20440 $Y=755 $D=0
M17 24 19 VSS VSS N L=1.8e-07 W=2.2e-07 $X=21240 $Y=755 $D=0
M18 16 10 24 VSS N L=1.8e-07 W=2.2e-07 $X=22740 $Y=755 $D=0
M19 Q 17 VSS VSS N L=1.8e-07 W=2.2e-07 $X=24240 $Y=755 $D=0
M20 VDD D 20 VDD P L=1.8e-07 W=4.4e-07 $X=945 $Y=2705 $D=16
M21 10 CLK VDD VDD P L=1.8e-07 W=4.4e-07 $X=1665 $Y=2705 $D=16
M22 11 CLK 20 VDD P L=1.8e-07 W=4.4e-07 $X=3245 $Y=2725 $D=16
M23 12 11 VDD VDD P L=1.8e-07 W=4.4e-07 $X=4745 $Y=2725 $D=16
M24 21 12 13 VDD P L=1.8e-07 W=8.8e-07 $X=6250 $Y=2300 $D=16
M25 VDD 14 21 VDD P L=1.8e-07 W=8.8e-07 $X=6970 $Y=2300 $D=16
M26 15 13 VDD VDD P L=1.8e-07 W=4.4e-07 $X=7730 $Y=2520 $D=16
M27 VDD SETB 14 VDD P L=1.8e-07 W=4.4e-07 $X=9355 $Y=2535 $D=16
M28 22 10 11 VDD P L=1.8e-07 W=4.4e-07 $X=10815 $Y=2505 $D=16
M29 22 15 VDD VDD P L=1.8e-07 W=4.4e-07 $X=12320 $Y=2505 $D=16
M30 VDD RESETB 22 VDD P L=1.8e-07 W=4.4e-07 $X=13040 $Y=2505 $D=16
M31 16 10 15 VDD P L=1.8e-07 W=4.4e-07 $X=14500 $Y=2505 $D=16
M32 17 16 VDD VDD P L=1.8e-07 W=4.4e-07 $X=15960 $Y=2665 $D=16
M33 VDD RESETB 17 VDD P L=1.8e-07 W=4.4e-07 $X=16680 $Y=2665 $D=16
M34 18 17 VDD VDD P L=1.8e-07 W=4.4e-07 $X=18140 $Y=2725 $D=16
M35 23 18 19 VDD P L=1.8e-07 W=8.8e-07 $X=19640 $Y=2285 $D=16
M36 VDD 14 23 VDD P L=1.8e-07 W=8.8e-07 $X=20360 $Y=2285 $D=16
M37 24 19 VDD VDD P L=1.8e-07 W=4.4e-07 $X=21120 $Y=2505 $D=16
M38 16 CLK 24 VDD P L=1.8e-07 W=4.4e-07 $X=22740 $Y=2505 $D=16
M39 Q 17 VDD VDD P L=1.8e-07 W=4.4e-07 $X=24200 $Y=2505 $D=16
.ENDS
***************************************
.SUBCKT FILL2
** N=4 EP=0 IP=0 FDC=0
.ENDS
***************************************
.SUBCKT ICV_51
** N=4 EP=0 IP=8 FDC=0
.ENDS
***************************************
.SUBCKT MUX2X1 A S B VSS VDD Z
** N=16 EP=6 IP=0 FDC=12
M0 VSS S 9 VSS N L=1.8e-07 W=4.4e-07 $X=940 $Y=960 $D=0
M1 15 A VSS VSS N L=1.8e-07 W=4.4e-07 $X=1660 $Y=960 $D=0
M2 10 9 15 VSS N L=1.8e-07 W=4.4e-07 $X=2380 $Y=960 $D=0
M3 16 S 10 VSS N L=1.8e-07 W=4.4e-07 $X=3100 $Y=960 $D=0
M4 VSS B 16 VSS N L=1.8e-07 W=4.4e-07 $X=3920 $Y=740 $D=0
M5 Z 10 VSS VSS N L=1.8e-07 W=4.4e-07 $X=4640 $Y=740 $D=0
M6 VDD S 9 VDD P L=1.8e-07 W=4.4e-07 $X=940 $Y=2520 $D=16
M7 11 A VDD VDD P L=1.8e-07 W=4.4e-07 $X=1660 $Y=2520 $D=16
M8 10 S 11 VDD P L=1.8e-07 W=4.4e-07 $X=2380 $Y=2520 $D=16
M9 12 9 10 VDD P L=1.8e-07 W=4.4e-07 $X=3100 $Y=2520 $D=16
M10 VDD B 12 VDD P L=1.8e-07 W=4.4e-07 $X=3920 $Y=2735 $D=16
M11 Z 10 VDD VDD P L=1.8e-07 W=4.4e-07 $X=4640 $Y=2735 $D=16
.ENDS
***************************************
.SUBCKT NAND2X1 A B VSS VDD Z
** N=9 EP=5 IP=0 FDC=4
M0 9 A VSS VSS N L=1.8e-07 W=4.4e-07 $X=985 $Y=745 $D=0
M1 Z B 9 VSS N L=1.8e-07 W=4.4e-07 $X=1705 $Y=745 $D=0
M2 Z A VDD VDD P L=1.8e-07 W=4.4e-07 $X=985 $Y=2670 $D=16
M3 VDD B Z VDD P L=1.8e-07 W=4.4e-07 $X=1705 $Y=2670 $D=16
.ENDS
***************************************
.SUBCKT ICV_50
** N=4 EP=0 IP=8 FDC=0
.ENDS
***************************************
.SUBCKT ICV_34
** N=4 EP=0 IP=8 FDC=0
.ENDS
***************************************
.SUBCKT ICV_61
** N=5 EP=0 IP=10 FDC=0
.ENDS
***************************************
.SUBCKT ICV_64
** N=7 EP=0 IP=10 FDC=0
.ENDS
***************************************
.SUBCKT ICV_65
** N=7 EP=0 IP=14 FDC=0
.ENDS
***************************************
.SUBCKT ICV_66
** N=11 EP=0 IP=14 FDC=0
.ENDS
***************************************
.SUBCKT ICV_57
** N=4 EP=0 IP=8 FDC=0
.ENDS
***************************************
.SUBCKT ICV_68 1 2 3 4 5
** N=7 EP=5 IP=11 FDC=4
X1 3 4 1 2 5 NAND2X1 $T=1120 0 0 0 $X=690 $Y=-390
.ENDS
***************************************
.SUBCKT ICV_69 1 2 3 4 5
** N=7 EP=5 IP=11 FDC=4
X0 2 3 1 5 4 NAND2X1 $T=1680 0 0 0 $X=1250 $Y=-390
.ENDS
***************************************
.SUBCKT NOR2X1 A B VSS VDD Z
** N=10 EP=5 IP=0 FDC=4
M0 Z A VSS VSS N L=1.8e-07 W=2.2e-07 $X=925 $Y=760 $D=0
M1 VSS B Z VSS N L=1.8e-07 W=2.2e-07 $X=1725 $Y=760 $D=0
M2 8 A VDD VDD P L=1.8e-07 W=8.8e-07 $X=925 $Y=2300 $D=16
M3 Z B 8 VDD P L=1.8e-07 W=8.8e-07 $X=1645 $Y=2300 $D=16
.ENDS
***************************************
.SUBCKT ICV_81 1 2 3 4 5
** N=7 EP=5 IP=11 FDC=4
X1 3 4 1 2 5 NAND2X1 $T=2240 0 0 0 $X=1810 $Y=-390
.ENDS
***************************************
.SUBCKT ICV_76 1 2 3 4 5
** N=7 EP=5 IP=11 FDC=4
X1 3 4 1 2 5 NAND2X1 $T=560 0 0 0 $X=130 $Y=-390
.ENDS
***************************************
.SUBCKT NAND3X1 A B C VSS VDD Z
** N=10 EP=6 IP=0 FDC=6
M0 9 A VSS VSS N L=1.8e-07 W=6.6e-07 $X=1210 $Y=745 $D=0
M1 10 B 9 VSS N L=1.8e-07 W=6.6e-07 $X=1930 $Y=745 $D=0
M2 Z C 10 VSS N L=1.8e-07 W=6.6e-07 $X=2650 $Y=745 $D=0
M3 Z A VDD VDD P L=1.8e-07 W=4.4e-07 $X=1210 $Y=2670 $D=16
M4 VDD B Z VDD P L=1.8e-07 W=4.4e-07 $X=1930 $Y=2670 $D=16
M5 Z C VDD VDD P L=1.8e-07 W=4.4e-07 $X=2650 $Y=2670 $D=16
.ENDS
***************************************
.SUBCKT ICV_115 1 2 3 4 5 6 7 8
** N=10 EP=8 IP=14 FDC=8
X0 2 3 1 5 4 NAND2X1 $T=0 0 1 180 $X=-3230 $Y=-390
X1 6 7 1 5 8 NAND2X1 $T=0 0 0 0 $X=-430 $Y=-390
.ENDS
***************************************
.SUBCKT OR2X1 A B VSS VDD Z
** N=12 EP=5 IP=0 FDC=6
M0 8 A VSS VSS N L=1.8e-07 W=2.2e-07 $X=835 $Y=760 $D=0
M1 VSS B 8 VSS N L=1.8e-07 W=2.2e-07 $X=1635 $Y=760 $D=0
M2 Z 8 VSS VSS N L=1.8e-07 W=2.2e-07 $X=2435 $Y=760 $D=0
M3 9 A 8 VDD P L=1.8e-07 W=8.8e-07 $X=835 $Y=2300 $D=16
M4 VDD B 9 VDD P L=1.8e-07 W=8.8e-07 $X=1555 $Y=2300 $D=16
M5 Z 8 VDD VDD P L=1.8e-07 W=4.4e-07 $X=2315 $Y=2520 $D=16
.ENDS
***************************************
.SUBCKT ICV_74 1 2 3 4 5
** N=7 EP=5 IP=11 FDC=4
X1 3 4 1 2 5 NAND2X1 $T=3360 0 1 180 $X=130 $Y=-390
.ENDS
***************************************
.SUBCKT ICV_78 1 2 3 4 5
** N=7 EP=5 IP=11 FDC=4
X0 2 3 1 5 4 NAND2X1 $T=4480 0 1 180 $X=1250 $Y=-390
.ENDS
***************************************
.SUBCKT ICV_52
** N=4 EP=0 IP=8 FDC=0
.ENDS
***************************************
.SUBCKT ICV_72 1 2 3 4 5
** N=7 EP=5 IP=11 FDC=4
X1 3 4 1 2 5 NAND2X1 $T=0 0 0 0 $X=-430 $Y=-390
.ENDS
***************************************
.SUBCKT AND2X1 A B VSS VDD Z
** N=10 EP=5 IP=0 FDC=6
M0 10 A 8 VSS N L=1.8e-07 W=4.4e-07 $X=905 $Y=750 $D=0
M1 VSS B 10 VSS N L=1.8e-07 W=4.4e-07 $X=1625 $Y=750 $D=0
M2 Z 8 VSS VSS N L=1.8e-07 W=2.2e-07 $X=2385 $Y=860 $D=0
M3 8 A VDD VDD P L=1.8e-07 W=4.4e-07 $X=905 $Y=2670 $D=16
M4 VDD B 8 VDD P L=1.8e-07 W=4.4e-07 $X=1625 $Y=2670 $D=16
M5 Z 8 VDD VDD P L=1.8e-07 W=4.4e-07 $X=2385 $Y=2670 $D=16
.ENDS
***************************************
.SUBCKT INVX2 A VSS VDD Z
** N=6 EP=4 IP=0 FDC=2
M0 Z A VSS VSS N L=1.8e-07 W=4.4e-07 $X=740 $Y=740 $D=0
M1 Z A VDD VDD P L=1.8e-07 W=8.8e-07 $X=740 $Y=2300 $D=16
.ENDS
***************************************
.SUBCKT ICV_62
** N=4 EP=0 IP=8 FDC=0
.ENDS
***************************************
.SUBCKT ICV_63
** N=4 EP=0 IP=8 FDC=0
.ENDS
***************************************
.SUBCKT ICV_33
** N=4 EP=0 IP=8 FDC=0
.ENDS
***************************************
.SUBCKT ICV_35
** N=4 EP=0 IP=8 FDC=0
.ENDS
***************************************
.SUBCKT BUFX1 A VSS VDD Z
** N=7 EP=4 IP=0 FDC=4
M0 VSS A 7 VSS N L=1.8e-07 W=2.2e-07 $X=925 $Y=760 $D=0
M1 Z 7 VSS VSS N L=1.8e-07 W=2.2e-07 $X=1725 $Y=760 $D=0
M2 VDD A 7 VDD P L=1.8e-07 W=4.4e-07 $X=925 $Y=2715 $D=16
M3 Z 7 VDD VDD P L=1.8e-07 W=4.4e-07 $X=1645 $Y=2715 $D=16
.ENDS
***************************************
.SUBCKT ICV_70
** N=4 EP=0 IP=8 FDC=0
.ENDS
***************************************
.SUBCKT ICV_117 44 84 85 86 87 88 89 90 91 92 93 94 95 96 97 98 99 100 101 102
+ 103 104 105 106 107 108 109 110 111 112 113 114 115 116 117 118 119 120 121 122
+ 123 124 125 126 127 128 129 130 131 132 133 134 135 136 137 138 139 140 141 142
+ 143 144 145 146 147 148 149 150 151 152 153 154 155 156 157 158 159 160 161 162
+ 163 164 165 166 167 168 169 170 171 172 173 174 175 176 177 178 179 180 181 182
+ 183 184 185 186 187 188 189 190 191 192 193 194 195 196 197 198 199 200 201 202
+ 203 204 205 206 207 208 209 210 211 212 213 214 215 216 217 218 219 220 221 222
+ 223 224 225 226 227 228 229 230 231 232 233 234 235 236 237 238 239 240 241 242
+ 243 244 245 246 247 248 249 250 251 252 253 254 255 256 257 258 259 260 261 262
+ 263 264 265 266 267 268 269 270 271 272 273 274 275 276 277 278 279 280 281 282
+ 283 284 285 286 287 288 289 290 291 292 293 294 295 296 297 298 299 300 301 302
+ 303 304 305 306 307 308 309 310 311 312 313 314 315 316 317 318 319 320 321 322
+ 323 324 325 326 327 328 329 330 331 332 333 334 335 336 337 338 339 340 341 342
+ 343 344 345 346 347 348 349 350 423 424 425 426 427 428 429 430 433 434 435 438
+ 439 440
** N=185336 EP=282 IP=9399 FDC=5526
X481 423 425 84 426 44 84 85 DFFQSRX1 $T=753920 475405 0 0 $X=753490 $Y=475015
X482 424 425 84 426 44 84 86 DFFQSRX1 $T=753920 483245 1 0 $X=753490 $Y=478690
X483 27358 425 84 426 44 84 87 DFFQSRX1 $T=763440 475405 1 0 $X=763010 $Y=470850
X484 27810 425 84 426 44 84 92 DFFQSRX1 $T=778560 459725 0 0 $X=778130 $Y=459335
X485 27715 425 84 426 44 84 91 DFFQSRX1 $T=778560 467565 1 0 $X=778130 $Y=463010
X486 427 425 84 426 44 84 95 DFFQSRX1 $T=779120 483245 1 0 $X=778690 $Y=478690
X487 28676 429 84 426 44 84 93 DFFQSRX1 $T=828400 459725 0 180 $X=802770 $Y=455170
X488 28677 429 84 426 44 84 94 DFFQSRX1 $T=828960 475405 0 180 $X=803330 $Y=470850
X489 428 429 84 426 44 84 96 DFFQSRX1 $T=805440 483245 1 0 $X=805010 $Y=478690
X490 29312 429 84 426 44 84 29443 DFFQSRX1 $T=826720 459725 0 0 $X=826290 $Y=459335
X491 29335 429 84 426 44 84 29460 DFFQSRX1 $T=828960 475405 1 0 $X=828530 $Y=470850
X492 29934 429 84 426 44 84 30026 DFFQSRX1 $T=834000 451885 1 0 $X=833570 $Y=447330
X493 29601 429 84 426 44 84 99 DFFQSRX1 $T=834000 451885 0 0 $X=833570 $Y=451495
X494 29672 429 84 426 44 84 100 DFFQSRX1 $T=834000 467565 0 0 $X=833570 $Y=467175
X495 34290 35892 84 426 44 84 33339 DFFQSRX1 $T=1009840 397005 0 180 $X=984210 $Y=392450
X496 34896 35892 84 426 44 84 34255 DFFQSRX1 $T=1028320 397005 1 180 $X=1002690 $Y=396615
X497 37510 35892 84 426 44 84 133 DFFQSRX1 $T=1089920 412685 1 0 $X=1089490 $Y=408130
X498 37718 35892 84 426 44 84 110 DFFQSRX1 $T=1125760 444045 0 180 $X=1100130 $Y=439490
X499 37873 35892 84 426 44 84 37457 DFFQSRX1 $T=1129120 420525 1 180 $X=1103490 $Y=420135
X500 434 433 84 426 44 84 38224 DFFQSRX1 $T=1151520 459725 1 180 $X=1125890 $Y=459335
X501 38811 433 84 426 44 84 37252 DFFQSRX1 $T=1153760 467565 1 180 $X=1128130 $Y=467175
X502 38812 435 84 426 44 84 32313 DFFQSRX1 $T=1153760 483245 0 180 $X=1128130 $Y=478690
X503 39132 433 84 426 44 84 37384 DFFQSRX1 $T=1164960 459725 0 180 $X=1139330 $Y=455170
X504 39320 433 84 426 44 84 190 DFFQSRX1 $T=1165520 420525 0 180 $X=1139890 $Y=415970
X505 39048 433 84 426 44 84 38562 DFFQSRX1 $T=1165520 428365 0 180 $X=1139890 $Y=423810
X506 38979 433 84 426 44 84 39429 DFFQSRX1 $T=1140320 451885 0 0 $X=1139890 $Y=451495
X507 39271 433 84 426 44 84 39557 DFFQSRX1 $T=1157680 444045 0 0 $X=1157250 $Y=443655
X508 39768 433 84 426 44 84 334 DFFQSRX1 $T=1185120 467565 1 180 $X=1159490 $Y=467175
X509 39786 433 84 426 44 84 341 DFFQSRX1 $T=1185120 483245 0 180 $X=1159490 $Y=478690
X510 430 433 84 426 44 84 40299 DFFQSRX1 $T=1167200 420525 1 0 $X=1166770 $Y=415970
X511 40261 438 84 426 44 84 39359 DFFQSRX1 $T=1192400 428365 0 180 $X=1166770 $Y=423810
X512 40281 438 84 426 44 84 39751 DFFQSRX1 $T=1203600 459725 1 180 $X=1177970 $Y=459335
X513 40361 438 84 426 44 84 39733 DFFQSRX1 $T=1205840 467565 0 180 $X=1180210 $Y=463010
X514 40586 438 84 426 44 84 40638 DFFQSRX1 $T=1194640 451885 1 0 $X=1194210 $Y=447330
X515 40299 438 84 426 44 84 349 DFFQSRX1 $T=1198560 428365 1 0 $X=1198130 $Y=423810
X516 40585 438 84 426 44 84 39486 DFFQSRX1 $T=1198560 436205 1 0 $X=1198130 $Y=431650
X517 40634 438 84 426 44 84 346 DFFQSRX1 $T=1198560 467565 0 0 $X=1198130 $Y=467175
X518 439 438 84 426 44 84 343 DFFQSRX1 $T=1198560 483245 0 0 $X=1198130 $Y=482855
X519 41296 440 84 426 44 84 40300 DFFQSRX1 $T=1234400 428365 1 180 $X=1208770 $Y=427975
X520 41170 440 84 426 44 84 40765 DFFQSRX1 $T=1234400 444045 1 180 $X=1208770 $Y=443655
X521 41317 440 84 426 44 84 40960 DFFQSRX1 $T=1237760 483245 0 180 $X=1212130 $Y=478690
X522 41509 440 84 426 44 84 41026 DFFQSRX1 $T=1240000 451885 1 180 $X=1214370 $Y=451495
X621 87 88 85 44 84 27358 MUX2X1 $T=784720 475405 1 180 $X=778690 $Y=475015
X622 93 88 91 44 84 28676 MUX2X1 $T=812720 467565 1 0 $X=812290 $Y=463010
X623 94 88 92 44 84 28677 MUX2X1 $T=812720 475405 0 0 $X=812290 $Y=475015
X624 29443 97 94 44 84 29312 MUX2X1 $T=841840 467565 0 180 $X=835810 $Y=463010
X625 29460 97 96 44 84 29335 MUX2X1 $T=842400 483245 0 180 $X=836370 $Y=478690
X626 99 97 87 44 84 29601 MUX2X1 $T=850800 467565 0 180 $X=844770 $Y=463010
X627 100 97 98 44 84 29672 MUX2X1 $T=853040 483245 0 180 $X=847010 $Y=478690
X628 30026 97 93 44 84 29934 MUX2X1 $T=861440 459725 1 180 $X=855410 $Y=459335
X629 31475 133 122 44 84 30951 MUX2X1 $T=904560 459725 1 180 $X=898530 $Y=459335
X630 123 133 130 44 84 30952 MUX2X1 $T=906800 451885 1 180 $X=900770 $Y=451495
X631 31580 138 128 44 84 31113 MUX2X1 $T=907920 436205 1 180 $X=901890 $Y=435815
X632 141 138 135 44 84 31472 MUX2X1 $T=908480 428365 0 180 $X=902450 $Y=423810
X633 31475 138 31507 44 84 31265 MUX2X1 $T=904000 459725 1 0 $X=903570 $Y=455170
X634 140 138 145 44 84 31486 MUX2X1 $T=904560 420525 1 0 $X=904130 $Y=415970
X635 31661 138 137 44 84 31724 MUX2X1 $T=907920 436205 0 0 $X=907490 $Y=435815
X636 31661 133 31618 44 84 31646 MUX2X1 $T=908480 451885 1 0 $X=908050 $Y=447330
X637 153 133 145 44 84 31766 MUX2X1 $T=918560 404845 1 180 $X=912530 $Y=404455
X638 31893 133 153 44 84 31439 MUX2X1 $T=919120 412685 0 180 $X=913090 $Y=408130
X639 170 133 163 44 84 31930 MUX2X1 $T=924160 420525 1 180 $X=918130 $Y=420135
X640 31618 133 31893 44 84 32091 MUX2X1 $T=919120 412685 1 0 $X=918690 $Y=408130
X641 149 133 32222 44 84 32308 MUX2X1 $T=929200 412685 1 0 $X=928770 $Y=408130
X642 32222 133 175 44 84 32393 MUX2X1 $T=931440 420525 1 0 $X=931010 $Y=415970
X643 179 133 172 44 84 32438 MUX2X1 $T=942080 436205 0 180 $X=936050 $Y=431650
X644 140 133 149 44 84 32582 MUX2X1 $T=937040 420525 1 0 $X=936610 $Y=415970
X645 179 138 192 44 84 32691 MUX2X1 $T=940400 428365 1 0 $X=939970 $Y=423810
X646 204 133 32641 44 84 32371 MUX2X1 $T=948240 436205 1 180 $X=942210 $Y=435815
X647 32641 133 192 44 84 32775 MUX2X1 $T=943200 436205 1 0 $X=942770 $Y=431650
X648 244 133 255 44 84 35118 MUX2X1 $T=1019360 420525 0 0 $X=1018930 $Y=420135
X649 275 133 270 44 84 35309 MUX2X1 $T=1036720 483245 0 180 $X=1030690 $Y=478690
X650 256 133 274 44 84 34933 MUX2X1 $T=1037840 451885 1 180 $X=1031810 $Y=451495
X651 254 138 259 44 84 35386 MUX2X1 $T=1039520 459725 0 180 $X=1033490 $Y=455170
X652 34610 133 35480 44 84 35417 MUX2X1 $T=1035040 420525 1 0 $X=1034610 $Y=415970
X653 247 138 279 44 84 35418 MUX2X1 $T=1046240 420525 0 180 $X=1040210 $Y=415970
X654 261 138 271 44 84 35558 MUX2X1 $T=1046800 412685 1 180 $X=1040770 $Y=412295
X655 34610 138 276 44 84 35992 MUX2X1 $T=1051840 420525 1 0 $X=1051410 $Y=415970
X656 293 133 36035 44 84 34998 MUX2X1 $T=1061360 451885 0 180 $X=1055330 $Y=447330
X657 35480 133 279 44 84 36256 MUX2X1 $T=1070320 412685 1 180 $X=1064290 $Y=412295
X658 280 138 36456 44 84 36419 MUX2X1 $T=1075920 420525 1 180 $X=1069890 $Y=420135
X659 314 138 263 44 84 36457 MUX2X1 $T=1078720 451885 1 180 $X=1072690 $Y=451495
X660 36508 138 36110 44 84 36537 MUX2X1 $T=1079840 428365 1 180 $X=1073810 $Y=427975
X661 36110 138 302 44 84 36691 MUX2X1 $T=1074800 459725 1 0 $X=1074370 $Y=455170
X662 36456 138 36508 44 84 36567 MUX2X1 $T=1075360 428365 1 0 $X=1074930 $Y=423810
X663 304 133 302 44 84 36657 MUX2X1 $T=1075360 451885 1 0 $X=1074930 $Y=447330
X664 239 133 37304 44 84 37510 MUX2X1 $T=1100560 420525 1 0 $X=1100130 $Y=415970
X665 333 97 334 44 84 335 MUX2X1 $T=1134160 483245 0 0 $X=1133730 $Y=482855
X666 37252 97 336 44 84 38811 MUX2X1 $T=1139760 475405 1 0 $X=1139330 $Y=470850
X667 32313 97 337 44 84 38812 MUX2X1 $T=1139760 483245 0 0 $X=1139330 $Y=482855
X668 37384 97 340 44 84 39132 MUX2X1 $T=1150400 475405 1 0 $X=1149970 $Y=470850
X669 334 88 39733 44 84 39768 MUX2X1 $T=1170560 475405 1 0 $X=1170130 $Y=470850
X670 341 88 39751 44 84 39786 MUX2X1 $T=1171120 475405 0 0 $X=1170690 $Y=475015
X671 340 88 343 44 84 344 MUX2X1 $T=1173360 483245 0 0 $X=1172930 $Y=482855
X672 40300 41170 350 44 84 41296 MUX2X1 $T=1219280 436205 0 0 $X=1218850 $Y=435815
X673 89 85 44 84 27582 NAND2X1 $T=787520 475405 1 180 $X=784290 $Y=475015
X674 89 86 44 84 27676 NAND2X1 $T=790320 475405 1 180 $X=787090 $Y=475015
X675 27582 27733 44 84 27715 NAND2X1 $T=788640 475405 1 0 $X=788210 $Y=470850
X676 27676 27833 44 84 27810 NAND2X1 $T=791440 475405 1 0 $X=791010 $Y=470850
X677 90 91 44 84 27733 NAND2X1 $T=794240 475405 1 0 $X=793810 $Y=470850
X678 90 92 44 84 27833 NAND2X1 $T=799280 475405 0 0 $X=798850 $Y=475015
X679 105 29443 44 84 106 NAND2X1 $T=887760 483245 0 0 $X=887330 $Y=482855
X680 31115 31099 44 84 31114 NAND2X1 $T=891680 451885 1 180 $X=888450 $Y=451495
X681 30951 109 44 84 31131 NAND2X1 $T=889440 459725 0 0 $X=889010 $Y=459335
X682 112 111 44 84 31002 NAND2X1 $T=893920 444045 1 180 $X=890690 $Y=443655
X683 31228 31267 44 84 31249 NAND2X1 $T=893360 475405 0 0 $X=892930 $Y=475015
X684 120 122 44 84 31332 NAND2X1 $T=896160 459725 0 0 $X=895730 $Y=459335
X685 31113 109 44 84 31379 NAND2X1 $T=897840 444045 1 0 $X=897410 $Y=439490
X686 112 126 44 84 31292 NAND2X1 $T=897840 451885 1 0 $X=897410 $Y=447330
X687 125 122 44 84 31228 NAND2X1 $T=900640 483245 0 180 $X=897410 $Y=478690
X688 121 132 44 84 31458 NAND2X1 $T=900640 451885 1 0 $X=900210 $Y=447330
X689 31486 129 44 84 31471 NAND2X1 $T=904000 404845 1 180 $X=900770 $Y=404455
X690 125 31507 44 84 31087 NAND2X1 $T=901760 467565 1 0 $X=901330 $Y=463010
X691 121 134 44 84 31491 NAND2X1 $T=901760 475405 0 0 $X=901330 $Y=475015
X692 139 137 44 84 31376 NAND2X1 $T=906800 412685 1 180 $X=903570 $Y=412295
X693 142 31618 44 84 31416 NAND2X1 $T=905680 436205 1 0 $X=905250 $Y=431650
X694 142 140 44 84 31581 NAND2X1 $T=908480 467565 0 180 $X=905250 $Y=463010
X695 136 132 44 84 31527 NAND2X1 $T=909600 451885 1 180 $X=906370 $Y=451495
X696 31472 129 44 84 31678 NAND2X1 $T=908480 436205 1 0 $X=908050 $Y=431650
X697 142 130 44 84 31676 NAND2X1 $T=911280 467565 0 180 $X=908050 $Y=463010
X698 136 146 44 84 147 NAND2X1 $T=911280 483245 1 180 $X=908050 $Y=482855
X699 31265 131 44 84 31706 NAND2X1 $T=912400 451885 1 180 $X=909170 $Y=451495
X700 142 145 44 84 31415 NAND2X1 $T=912960 420525 0 180 $X=909730 $Y=415970
X701 31724 129 44 84 31754 NAND2X1 $T=914080 436205 0 180 $X=910850 $Y=431650
X702 139 31661 44 84 31755 NAND2X1 $T=914080 467565 0 180 $X=910850 $Y=463010
X703 142 137 44 84 31767 NAND2X1 $T=914640 412685 1 180 $X=911410 $Y=412295
X704 139 128 44 84 31790 NAND2X1 $T=915200 428365 1 180 $X=911970 $Y=427975
X705 148 126 44 84 31787 NAND2X1 $T=915200 444045 1 180 $X=911970 $Y=443655
X706 139 163 44 84 31894 NAND2X1 $T=917440 428365 1 0 $X=917010 $Y=423810
X707 31930 131 44 84 31911 NAND2X1 $T=919120 420525 1 0 $X=918690 $Y=415970
X708 168 123 44 84 31949 NAND2X1 $T=922480 459725 1 180 $X=919250 $Y=459335
X709 136 162 44 84 166 NAND2X1 $T=922480 467565 0 180 $X=919250 $Y=463010
X710 31930 129 44 84 31965 NAND2X1 $T=920240 428365 1 0 $X=919810 $Y=423810
X711 139 175 44 84 31832 NAND2X1 $T=921920 420525 1 0 $X=921490 $Y=415970
X712 142 170 44 84 32002 NAND2X1 $T=925280 459725 1 180 $X=922050 $Y=459335
X713 178 31977 44 84 31893 NAND2X1 $T=925840 475405 0 180 $X=922610 $Y=470850
X714 139 31893 44 84 32106 NAND2X1 $T=923600 451885 0 0 $X=923170 $Y=451495
X715 142 135 44 84 32121 NAND2X1 $T=924160 420525 0 0 $X=923730 $Y=420135
X716 178 31134 44 84 174 NAND2X1 $T=924160 475405 0 0 $X=923730 $Y=475015
X717 142 175 44 84 32136 NAND2X1 $T=924720 420525 1 0 $X=924290 $Y=415970
X718 136 32171 44 84 159 NAND2X1 $T=925840 467565 0 0 $X=925410 $Y=467175
X719 178 169 44 84 32171 NAND2X1 $T=928640 475405 0 180 $X=925410 $Y=470850
X720 106 185 44 84 32222 NAND2X1 $T=927520 483245 0 0 $X=927090 $Y=482855
X721 148 183 44 84 32060 NAND2X1 $T=930880 428365 1 180 $X=927650 $Y=427975
X722 148 187 44 84 31457 NAND2X1 $T=928080 436205 0 0 $X=927650 $Y=435815
X723 142 32222 44 84 32177 NAND2X1 $T=928080 459725 1 0 $X=927650 $Y=455170
X724 184 31134 44 84 31618 NAND2X1 $T=931440 467565 1 180 $X=928210 $Y=467175
X725 32303 32218 44 84 189 NAND2X1 $T=933120 444045 0 180 $X=929890 $Y=439490
X726 110 32313 44 84 31977 NAND2X1 $T=930320 483245 0 0 $X=929890 $Y=482855
X727 32371 103 44 84 32156 NAND2X1 $T=935360 436205 0 180 $X=932130 $Y=431650
X728 112 191 44 84 32270 NAND2X1 $T=935360 467565 0 180 $X=932130 $Y=463010
X729 32393 131 44 84 32262 NAND2X1 $T=935920 412685 1 180 $X=932690 $Y=412295
X730 32438 109 44 84 32409 NAND2X1 $T=938160 428365 1 180 $X=934930 $Y=427975
X731 125 192 44 84 32561 NAND2X1 $T=939840 436205 0 0 $X=939410 $Y=435815
X732 200 118 44 84 32641 NAND2X1 $T=946000 475405 1 180 $X=942770 $Y=475015
X733 112 171 44 84 203 NAND2X1 $T=943200 483245 0 0 $X=942770 $Y=482855
X734 32691 103 44 84 32548 NAND2X1 $T=947680 420525 1 180 $X=944450 $Y=420135
X735 121 32171 44 84 32741 NAND2X1 $T=946560 451885 1 0 $X=946130 $Y=447330
X736 207 32171 44 84 208 NAND2X1 $T=951600 467565 1 180 $X=948370 $Y=467175
X737 212 31893 44 84 32874 NAND2X1 $T=953280 436205 0 180 $X=950050 $Y=431650
X738 207 205 44 84 32894 NAND2X1 $T=953840 467565 0 180 $X=950610 $Y=463010
X739 32775 129 44 84 32966 NAND2X1 $T=953280 412685 0 0 $X=952850 $Y=412295
X740 216 135 44 84 32920 NAND2X1 $T=956080 436205 0 180 $X=952850 $Y=431650
X741 120 32532 44 84 32963 NAND2X1 $T=953280 475405 0 0 $X=952850 $Y=475015
X742 121 210 44 84 32926 NAND2X1 $T=957200 451885 0 180 $X=953970 $Y=447330
X743 33034 32963 44 84 33050 NAND2X1 $T=958880 475405 1 180 $X=955650 $Y=475015
X744 140 219 44 84 33105 NAND2X1 $T=957760 428365 1 0 $X=957330 $Y=423810
X745 220 141 44 84 32946 NAND2X1 $T=961120 483245 1 180 $X=957890 $Y=482855
X746 31580 227 44 84 33236 NAND2X1 $T=962240 436205 0 0 $X=961810 $Y=435815
X747 33284 33251 44 84 33015 NAND2X1 $T=966160 444045 1 180 $X=962930 $Y=443655
X748 111 227 44 84 33321 NAND2X1 $T=967840 436205 1 180 $X=964610 $Y=435815
X749 33403 33376 44 84 31947 NAND2X1 $T=968400 444045 1 0 $X=967970 $Y=439490
X750 33351 33441 44 84 229 NAND2X1 $T=968960 483245 0 0 $X=968530 $Y=482855
X751 33434 33441 44 84 33320 NAND2X1 $T=969520 467565 1 0 $X=969090 $Y=463010
X752 109 222 44 84 33536 NAND2X1 $T=975680 436205 0 180 $X=972450 $Y=431650
X753 33373 233 44 84 33134 NAND2X1 $T=973440 428365 1 0 $X=973010 $Y=423810
X754 109 32532 44 84 33555 NAND2X1 $T=976240 451885 0 180 $X=973010 $Y=447330
X755 34023 33235 44 84 228 NAND2X1 $T=994160 475405 1 0 $X=993730 $Y=470850
X756 34371 227 44 84 34494 NAND2X1 $T=1002000 451885 0 0 $X=1001570 $Y=451495
X757 34255 33339 44 84 240 NAND2X1 $T=1005360 420525 0 180 $X=1002130 $Y=415970
X758 245 33235 44 84 34692 NAND2X1 $T=1012080 420525 1 180 $X=1008850 $Y=420135
X759 246 33235 44 84 34693 NAND2X1 $T=1012080 483245 1 180 $X=1008850 $Y=482855
X760 247 224 44 84 34748 NAND2X1 $T=1013760 420525 0 180 $X=1010530 $Y=415970
X761 245 224 44 84 34795 NAND2X1 $T=1015440 436205 0 180 $X=1012210 $Y=431650
X762 157 34923 44 84 34808 NAND2X1 $T=1022160 475405 1 180 $X=1018930 $Y=475015
X763 34998 197 44 84 35031 NAND2X1 $T=1025520 444045 0 180 $X=1022290 $Y=439490
X764 125 259 44 84 34989 NAND2X1 $T=1023840 459725 0 0 $X=1023410 $Y=459335
X765 121 260 44 84 35032 NAND2X1 $T=1025520 467565 0 0 $X=1025090 $Y=467175
X766 142 261 44 84 35180 NAND2X1 $T=1025520 475405 0 0 $X=1025090 $Y=475015
X767 35260 35199 44 84 265 NAND2X1 $T=1030560 436205 1 180 $X=1027330 $Y=435815
X768 35261 35231 44 84 266 NAND2X1 $T=1030560 444045 0 180 $X=1027330 $Y=439490
X769 271 168 44 84 35305 NAND2X1 $T=1033920 467565 1 180 $X=1030690 $Y=467175
X770 35417 188 44 84 35360 NAND2X1 $T=1036160 404845 1 180 $X=1032930 $Y=404455
X771 35418 188 44 84 35361 NAND2X1 $T=1036160 412685 1 180 $X=1032930 $Y=412295
X772 34933 131 44 84 35402 NAND2X1 $T=1036160 436205 1 180 $X=1032930 $Y=435815
X773 35378 103 44 84 35403 NAND2X1 $T=1033360 444045 1 0 $X=1032930 $Y=439490
X774 35418 197 44 84 35320 NAND2X1 $T=1036720 412685 0 180 $X=1033490 $Y=408130
X775 276 216 44 84 35304 NAND2X1 $T=1037280 428365 0 180 $X=1034050 $Y=423810
X776 168 263 44 84 34850 NAND2X1 $T=1036720 483245 1 0 $X=1036290 $Y=478690
X777 35558 129 44 84 35542 NAND2X1 $T=1041200 412685 1 180 $X=1037970 $Y=412295
X778 35575 190 44 84 35511 NAND2X1 $T=1041760 436205 1 180 $X=1038530 $Y=435815
X779 260 213 44 84 35561 NAND2X1 $T=1041760 451885 1 180 $X=1038530 $Y=451495
X780 121 278 44 84 35594 NAND2X1 $T=1043440 475405 0 180 $X=1040210 $Y=470850
X781 35558 188 44 84 35638 NAND2X1 $T=1041760 404845 1 0 $X=1041330 $Y=400290
X782 112 273 44 84 35725 NAND2X1 $T=1047360 467565 1 180 $X=1044130 $Y=467175
X783 148 284 44 84 35804 NAND2X1 $T=1050160 444045 1 180 $X=1046930 $Y=443655
X784 34546 35572 44 84 35696 NAND2X1 $T=1050720 451885 0 180 $X=1047490 $Y=447330
X785 261 234 44 84 35765 NAND2X1 $T=1049600 428365 0 0 $X=1049170 $Y=427975
X786 148 291 44 84 35884 NAND2X1 $T=1050720 436205 0 0 $X=1050290 $Y=435815
X787 35928 35960 44 84 35903 NAND2X1 $T=1052400 428365 0 0 $X=1051970 $Y=427975
X788 35992 197 44 84 35973 NAND2X1 $T=1056320 404845 0 180 $X=1053090 $Y=400290
X789 142 276 44 84 35960 NAND2X1 $T=1056320 420525 1 180 $X=1053090 $Y=420135
X790 136 35882 44 84 35928 NAND2X1 $T=1053520 436205 0 0 $X=1053090 $Y=435815
X791 293 139 44 84 35881 NAND2X1 $T=1053520 444045 0 0 $X=1053090 $Y=443655
X792 35974 36009 44 84 36006 NAND2X1 $T=1054080 412685 1 0 $X=1053650 $Y=408130
X793 202 35882 44 84 297 NAND2X1 $T=1058000 483245 0 180 $X=1054770 $Y=478690
X794 136 291 44 84 36056 NAND2X1 $T=1059120 444045 0 180 $X=1055890 $Y=439490
X795 279 139 44 84 36113 NAND2X1 $T=1061360 420525 1 180 $X=1058130 $Y=420135
X796 142 293 44 84 36148 NAND2X1 $T=1062480 428365 1 180 $X=1059250 $Y=427975
X797 36256 188 44 84 36238 NAND2X1 $T=1066400 412685 0 180 $X=1063170 $Y=408130
X798 36256 197 44 84 36291 NAND2X1 $T=1067520 404845 0 180 $X=1064290 $Y=400290
X799 139 270 44 84 36318 NAND2X1 $T=1069760 451885 1 180 $X=1066530 $Y=451495
X800 105 308 44 84 36350 NAND2X1 $T=1066960 483245 0 0 $X=1066530 $Y=482855
X801 110 308 44 84 36274 NAND2X1 $T=1070320 483245 0 180 $X=1067090 $Y=478690
X802 139 274 44 84 36390 NAND2X1 $T=1070880 459725 0 180 $X=1067650 $Y=455170
X803 148 298 44 84 36361 NAND2X1 $T=1072560 467565 0 180 $X=1069330 $Y=463010
X804 36457 129 44 84 36403 NAND2X1 $T=1070880 451885 1 0 $X=1070450 $Y=447330
X805 234 314 44 84 36489 NAND2X1 $T=1071440 428365 0 0 $X=1071010 $Y=427975
X806 36457 109 44 84 36421 NAND2X1 $T=1074800 444045 0 180 $X=1071570 $Y=439490
X807 36567 109 44 84 36491 NAND2X1 $T=1076480 412685 1 180 $X=1073250 $Y=412295
X808 36458 190 44 84 36436 NAND2X1 $T=1077600 444045 0 180 $X=1074370 $Y=439490
X809 36600 315 44 84 36456 NAND2X1 $T=1077600 467565 0 180 $X=1074370 $Y=463010
X810 142 36508 44 84 36601 NAND2X1 $T=1078160 436205 0 180 $X=1074930 $Y=431650
X811 36600 36274 44 84 317 NAND2X1 $T=1078160 475405 0 180 $X=1074930 $Y=470850
X812 36629 36274 44 84 36508 NAND2X1 $T=1078720 467565 1 180 $X=1075490 $Y=467175
X813 36537 109 44 84 36591 NAND2X1 $T=1079280 412685 1 180 $X=1076050 $Y=412295
X814 36657 103 44 84 36381 NAND2X1 $T=1079840 444045 1 180 $X=1076610 $Y=443655
X815 318 36224 44 84 36110 NAND2X1 $T=1077040 483245 1 0 $X=1076610 $Y=478690
X816 168 317 44 84 36659 NAND2X1 $T=1080400 483245 1 180 $X=1077170 $Y=482855
X817 142 36456 44 84 36692 NAND2X1 $T=1081520 444045 0 180 $X=1078290 $Y=439490
X818 139 263 44 84 36752 NAND2X1 $T=1083760 451885 1 180 $X=1080530 $Y=451495
X819 136 319 44 84 36754 NAND2X1 $T=1083760 467565 1 180 $X=1080530 $Y=467175
X820 142 280 44 84 36765 NAND2X1 $T=1084320 420525 1 180 $X=1081090 $Y=420135
X821 136 284 44 84 36770 NAND2X1 $T=1084320 444045 0 180 $X=1081090 $Y=439490
X822 36839 129 44 84 34915 NAND2X1 $T=1086000 412685 0 180 $X=1082770 $Y=408130
X823 139 36035 44 84 36823 NAND2X1 $T=1086000 451885 0 180 $X=1082770 $Y=447330
X824 36691 131 44 84 36907 NAND2X1 $T=1086000 459725 1 0 $X=1085570 $Y=455170
X825 36691 129 44 84 36910 NAND2X1 $T=1086000 459725 0 0 $X=1085570 $Y=459335
X826 36657 131 44 84 36924 NAND2X1 $T=1091600 444045 0 180 $X=1088370 $Y=439490
X827 136 37038 44 84 324 NAND2X1 $T=1093840 467565 1 180 $X=1090610 $Y=467175
X828 148 309 44 84 329 NAND2X1 $T=1093840 483245 1 180 $X=1090610 $Y=482855
X829 148 331 44 84 37095 NAND2X1 $T=1092160 483245 1 0 $X=1091730 $Y=478690
X830 37095 37078 44 84 37153 NAND2X1 $T=1097200 459725 0 180 $X=1093970 $Y=455170
X831 37755 37894 44 84 37873 NAND2X1 $T=1115120 436205 1 0 $X=1114690 $Y=431650
X832 38793 38630 44 84 37894 NAND2X1 $T=1145360 436205 0 180 $X=1142130 $Y=431650
X833 38958 38996 44 84 38979 NAND2X1 $T=1149280 444045 0 0 $X=1148850 $Y=443655
X834 38940 338 44 84 39048 NAND2X1 $T=1151520 436205 0 0 $X=1151090 $Y=435815
X835 39290 39251 44 84 39271 NAND2X1 $T=1161600 451885 0 180 $X=1158370 $Y=447330
X836 38630 39359 44 84 39096 NAND2X1 $T=1161040 436205 0 0 $X=1160610 $Y=435815
X837 39371 39429 44 84 38958 NAND2X1 $T=1167200 436205 0 0 $X=1166770 $Y=435815
X838 39371 39557 44 84 39290 NAND2X1 $T=1167200 444045 1 0 $X=1166770 $Y=439490
X839 345 40339 44 84 40361 NAND2X1 $T=1195200 475405 1 180 $X=1191970 $Y=475015
X840 90 39733 44 84 40339 NAND2X1 $T=1192960 475405 1 0 $X=1192530 $Y=470850
X841 90 346 44 84 40618 NAND2X1 $T=1203600 475405 1 180 $X=1200370 $Y=475015
X842 40506 40618 44 84 40634 NAND2X1 $T=1204160 475405 0 180 $X=1200930 $Y=470850
X843 41075 347 44 84 41187 NAND2X1 $T=1219280 467565 1 0 $X=1218850 $Y=463010
X844 41363 347 44 84 40929 NAND2X1 $T=1227680 459725 1 180 $X=1224450 $Y=459335
X845 41507 40929 44 84 41509 NAND2X1 $T=1232720 459725 1 180 $X=1229490 $Y=459335
X846 41187 41026 44 84 41507 NAND2X1 $T=1229920 467565 1 0 $X=1229490 $Y=463010
X847 41453 41026 44 84 41384 NAND2X1 $T=1229920 475405 1 0 $X=1229490 $Y=470850
X1003 44 84 30756 30801 101 ICV_68 $T=877680 467565 1 0 $X=877250 $Y=463010
X1004 44 84 112 117 31034 ICV_68 $T=892240 459725 0 0 $X=891810 $Y=459335
X1005 44 84 120 123 31044 ICV_68 $T=896160 451885 0 0 $X=895730 $Y=451495
X1006 44 84 31768 190 32279 ICV_68 $T=928640 475405 1 0 $X=928210 $Y=470850
X1007 44 84 32438 103 32549 ICV_68 $T=938160 428365 0 0 $X=937730 $Y=427975
X1008 44 84 210 213 32848 ICV_68 $T=949360 451885 1 0 $X=948930 $Y=447330
X1009 44 84 170 33235 33217 ICV_68 $T=960560 428365 1 0 $X=960130 $Y=423810
X1010 44 84 33269 33303 32642 ICV_68 $T=962800 451885 0 0 $X=962370 $Y=451495
X1011 44 84 175 224 33396 ICV_68 $T=967840 420525 1 0 $X=967410 $Y=415970
X1012 44 84 35118 188 35182 ICV_68 $T=1024400 428365 1 0 $X=1023970 $Y=423810
X1013 44 84 35417 129 35510 ICV_68 $T=1036160 404845 0 0 $X=1035730 $Y=404455
X1014 44 84 33165 281 35632 ICV_68 $T=1040640 483245 0 0 $X=1040210 $Y=482855
X1015 44 84 276 237 35661 ICV_68 $T=1041200 428365 1 0 $X=1040770 $Y=423810
X1016 44 84 285 34546 35821 ICV_68 $T=1046800 451885 0 0 $X=1046370 $Y=451495
X1017 44 84 296 35963 273 ICV_68 $T=1058000 483245 1 0 $X=1057570 $Y=478690
X1018 44 84 36419 103 36555 ICV_68 $T=1072560 420525 1 0 $X=1072130 $Y=415970
X1019 44 84 157 246 36790 ICV_68 $T=1080400 483245 0 0 $X=1079970 $Y=482855
X1020 44 30893 30873 102 84 ICV_69 $T=881040 436205 0 0 $X=880610 $Y=435815
X1021 44 30952 109 31115 84 ICV_69 $T=887200 459725 1 0 $X=886770 $Y=455170
X1022 44 31439 131 31350 84 ICV_69 $T=898960 420525 0 0 $X=898530 $Y=420135
X1023 44 31472 131 31378 84 ICV_69 $T=900080 428365 0 0 $X=899650 $Y=427975
X1024 44 136 144 31615 84 ICV_69 $T=904560 475405 0 0 $X=904130 $Y=475015
X1025 44 31486 131 31833 84 ICV_69 $T=912960 428365 1 0 $X=912530 $Y=423810
X1026 44 31134 182 181 84 ICV_69 $T=924160 483245 1 0 $X=923730 $Y=478690
X1027 44 184 31196 186 84 ICV_69 $T=926960 475405 0 0 $X=926530 $Y=475015
X1028 44 105 32313 195 84 ICV_69 $T=933120 483245 0 0 $X=932690 $Y=482855
X1029 44 112 194 32449 84 ICV_69 $T=934800 451885 1 0 $X=934370 $Y=447330
X1030 44 31766 188 32690 84 ICV_69 $T=942640 404845 0 0 $X=942210 $Y=404455
X1031 44 32308 188 32806 84 ICV_69 $T=947120 412685 1 0 $X=946690 $Y=408130
X1032 44 33084 107 33104 84 ICV_69 $T=956080 420525 1 0 $X=955650 $Y=415970
X1033 44 125 222 32972 84 ICV_69 $T=957200 444045 1 0 $X=956770 $Y=439490
X1034 44 103 222 33434 84 ICV_69 $T=967280 459725 0 0 $X=966850 $Y=459335
X1035 44 103 32532 33433 84 ICV_69 $T=967840 451885 1 0 $X=967410 $Y=447330
X1036 44 33433 33441 33269 84 ICV_69 $T=967840 459725 1 0 $X=967410 $Y=455170
X1037 44 33536 231 33403 84 ICV_69 $T=971200 444045 1 0 $X=970770 $Y=439490
X1038 44 34371 219 34546 84 ICV_69 $T=1002560 444045 0 0 $X=1002130 $Y=443655
X1039 44 34663 34795 34815 84 ICV_69 $T=1010960 428365 0 0 $X=1010530 $Y=427975
X1040 44 157 252 34952 84 ICV_69 $T=1015440 459725 0 0 $X=1015010 $Y=459335
X1041 44 142 263 35068 84 ICV_69 $T=1024400 475405 1 0 $X=1023970 $Y=470850
X1042 44 35118 129 35228 84 ICV_69 $T=1024960 420525 1 0 $X=1024530 $Y=415970
X1043 44 213 269 35282 84 ICV_69 $T=1026640 451885 0 0 $X=1026210 $Y=451495
X1044 44 207 273 35280 84 ICV_69 $T=1029440 467565 1 0 $X=1029010 $Y=463010
X1045 44 245 237 35401 84 ICV_69 $T=1031680 420525 0 0 $X=1031250 $Y=420135
X1046 44 216 35480 35321 84 ICV_69 $T=1033920 436205 1 0 $X=1033490 $Y=431650
X1047 44 289 290 35882 84 ICV_69 $T=1048480 475405 0 0 $X=1048050 $Y=475015
X1048 44 34546 35961 35945 84 ICV_69 $T=1050720 451885 0 0 $X=1050290 $Y=451495
X1049 44 112 35819 35838 84 ICV_69 $T=1050720 483245 0 0 $X=1050290 $Y=482855
X1050 44 303 36274 295 84 ICV_69 $T=1061920 475405 0 0 $X=1061490 $Y=475015
X1051 44 312 36350 309 84 ICV_69 $T=1069760 483245 0 0 $X=1069330 $Y=482855
X1052 44 36823 328 35929 84 ICV_69 $T=1086560 444045 0 0 $X=1086130 $Y=443655
X1053 44 148 37038 328 84 ICV_69 $T=1088240 467565 1 0 $X=1087810 $Y=463010
X1054 44 37153 190 36599 84 ICV_69 $T=1092720 428365 0 0 $X=1092290 $Y=427975
X1055 44 110 37252 311 84 ICV_69 $T=1094400 475405 0 0 $X=1093970 $Y=475015
X1056 44 105 37384 36600 84 ICV_69 $T=1100000 475405 1 0 $X=1099570 $Y=470850
X1057 30853 30894 44 84 30873 NOR2X1 $T=881600 444045 0 0 $X=881170 $Y=443655
X1058 30874 30916 44 84 30801 NOR2X1 $T=882160 467565 1 0 $X=881730 $Y=463010
X1059 31249 31114 44 84 31227 NOR2X1 $T=895600 475405 0 180 $X=892370 $Y=470850
X1060 31246 31280 44 84 31252 NOR2X1 $T=893920 444045 0 0 $X=893490 $Y=443655
X1061 31298 31330 44 84 31236 NOR2X1 $T=895600 412685 1 0 $X=895170 $Y=408130
X1062 31299 31331 44 84 31086 NOR2X1 $T=895600 436205 0 0 $X=895170 $Y=435815
X1063 31351 31377 44 84 31216 NOR2X1 $T=897280 428365 0 0 $X=896850 $Y=427975
X1064 31423 31456 44 84 31205 NOR2X1 $T=900080 428365 1 0 $X=899650 $Y=423810
X1065 31847 31876 44 84 31312 NOR2X1 $T=915200 428365 0 0 $X=914770 $Y=427975
X1066 31989 32155 44 84 32139 NOR2X1 $T=924720 436205 1 0 $X=924290 $Y=431650
X1067 32154 31895 44 84 32217 NOR2X1 $T=926960 420525 0 0 $X=926530 $Y=420135
X1068 32219 31440 44 84 32218 NOR2X1 $T=930320 444045 1 180 $X=927090 $Y=443655
X1069 107 32217 44 84 32278 NOR2X1 $T=932560 428365 0 180 $X=929330 $Y=423810
X1070 31931 32356 44 84 32422 NOR2X1 $T=934800 459725 1 0 $X=934370 $Y=455170
X1071 32294 32373 44 84 32395 NOR2X1 $T=935360 467565 1 0 $X=934930 $Y=463010
X1072 32439 32473 44 84 31251 NOR2X1 $T=935920 444045 1 0 $X=935490 $Y=439490
X1073 32490 32278 44 84 198 NOR2X1 $T=939280 428365 0 180 $X=936050 $Y=423810
X1074 32491 32457 44 84 199 NOR2X1 $T=937600 459725 1 0 $X=937170 $Y=455170
X1075 190 32422 44 84 32583 NOR2X1 $T=943200 459725 0 180 $X=939970 $Y=455170
X1076 32577 32659 44 84 32707 NOR2X1 $T=944320 459725 0 0 $X=943890 $Y=459335
X1077 32732 32583 44 84 211 NOR2X1 $T=949360 459725 0 0 $X=948930 $Y=459335
X1078 33050 32828 44 84 33118 NOR2X1 $T=957760 475405 1 0 $X=957330 $Y=470850
X1079 33232 33270 44 84 32474 NOR2X1 $T=962800 475405 1 0 $X=962370 $Y=470850
X1080 190 34002 44 84 103 NOR2X1 $T=985200 444045 0 0 $X=984770 $Y=443655
X1081 107 34002 44 84 197 NOR2X1 $T=994720 451885 0 180 $X=991490 $Y=447330
X1082 34255 133 44 84 227 NOR2X1 $T=996400 420525 1 180 $X=993170 $Y=420135
X1083 34255 34166 44 84 109 NOR2X1 $T=996400 436205 0 180 $X=993170 $Y=431650
X1084 34256 190 44 84 34023 NOR2X1 $T=996400 436205 1 180 $X=993170 $Y=435815
X1085 133 34002 44 84 157 NOR2X1 $T=993600 459725 1 0 $X=993170 $Y=455170
X1086 107 33339 44 84 233 NOR2X1 $T=995280 428365 1 0 $X=994850 $Y=423810
X1087 107 34256 44 84 236 NOR2X1 $T=998080 444045 1 180 $X=994850 $Y=443655
X1088 34256 34255 44 84 131 NOR2X1 $T=996400 420525 0 0 $X=995970 $Y=420135
X1089 34432 133 44 84 224 NOR2X1 $T=1002560 420525 0 180 $X=999330 $Y=415970
X1090 34432 33339 44 84 129 NOR2X1 $T=1003120 412685 0 180 $X=999890 $Y=408130
X1091 138 34432 44 84 33235 NOR2X1 $T=1000320 420525 0 0 $X=999890 $Y=420135
X1092 138 34255 44 84 219 NOR2X1 $T=1003120 428365 1 180 $X=999890 $Y=427975
X1093 34255 33339 44 84 235 NOR2X1 $T=1000320 436205 1 0 $X=999890 $Y=431650
X1094 190 33339 44 84 34371 NOR2X1 $T=1000320 444045 1 0 $X=999890 $Y=439490
X1095 138 34002 44 84 168 NOR2X1 $T=1003120 459725 1 180 $X=999890 $Y=459335
X1096 138 240 44 84 136 NOR2X1 $T=1009280 436205 0 180 $X=1006050 $Y=431650
X1097 34969 34999 44 84 34922 NOR2X1 $T=1018800 451885 0 0 $X=1018370 $Y=451495
X1098 35131 35212 44 84 35199 NOR2X1 $T=1026080 428365 0 0 $X=1025650 $Y=427975
X1099 35244 35279 44 84 267 NOR2X1 $T=1028320 412685 0 0 $X=1027890 $Y=412295
X1100 35102 35281 44 84 35231 NOR2X1 $T=1030560 444045 1 0 $X=1030130 $Y=439490
X1101 35512 35543 44 84 277 NOR2X1 $T=1037840 483245 0 0 $X=1037410 $Y=482855
X1102 35822 35852 44 84 286 NOR2X1 $T=1048480 467565 0 0 $X=1048050 $Y=467175
X1103 35737 35724 44 84 35856 NOR2X1 $T=1049040 404845 0 0 $X=1048610 $Y=404455
X1104 35914 35856 44 84 35852 NOR2X1 $T=1053520 412685 1 180 $X=1050290 $Y=412295
X1105 35929 35903 44 84 35659 NOR2X1 $T=1054080 436205 0 180 $X=1050850 $Y=431650
X1106 190 36112 44 84 35279 NOR2X1 $T=1058000 420525 1 0 $X=1057570 $Y=415970
X1107 36174 36210 44 84 35811 NOR2X1 $T=1061360 444045 1 0 $X=1060930 $Y=439490
X1108 36146 35559 44 84 36220 NOR2X1 $T=1062480 428365 1 0 $X=1062050 $Y=423810
X1109 36292 36257 44 84 305 NOR2X1 $T=1066960 444045 0 180 $X=1063730 $Y=439490
X1110 107 36220 44 84 36257 NOR2X1 $T=1068640 428365 0 180 $X=1065410 $Y=423810
X1111 36173 36366 44 84 307 NOR2X1 $T=1066960 404845 0 0 $X=1066530 $Y=404455
X1112 36258 36420 44 84 310 NOR2X1 $T=1069760 467565 0 0 $X=1069330 $Y=467175
X1113 36722 36855 44 84 35810 NOR2X1 $T=1083760 436205 0 0 $X=1083330 $Y=435815
X1114 36617 36272 44 84 36873 NOR2X1 $T=1084320 420525 0 0 $X=1083890 $Y=420135
X1115 36789 36840 44 84 36112 NOR2X1 $T=1086000 412685 0 0 $X=1085570 $Y=412295
X1116 36908 36925 44 84 325 NOR2X1 $T=1087120 475405 0 0 $X=1086690 $Y=475015
X1117 37273 37304 44 84 34608 NOR2X1 $T=1097760 420525 1 0 $X=1097330 $Y=415970
X1118 133 37420 44 84 37273 NOR2X1 $T=1101120 420525 0 0 $X=1100690 $Y=420135
X1119 37457 37420 44 84 239 NOR2X1 $T=1121840 436205 0 180 $X=1118610 $Y=431650
X1120 38598 38562 44 84 36839 NOR2X1 $T=1138640 420525 1 180 $X=1135410 $Y=420135
X1121 37457 37748 44 84 38630 NOR2X1 $T=1137520 436205 0 0 $X=1137090 $Y=435815
X1122 107 38630 44 84 39152 NOR2X1 $T=1154880 436205 1 0 $X=1154450 $Y=431650
X1123 39486 39166 44 84 39284 NOR2X1 $T=1167760 436205 0 180 $X=1164530 $Y=431650
X1124 39486 39359 44 84 38905 NOR2X1 $T=1184560 436205 1 180 $X=1181330 $Y=435815
X1125 40280 40238 44 84 40261 NOR2X1 $T=1192400 436205 0 180 $X=1189170 $Y=431650
X1126 39359 40300 44 84 40238 NOR2X1 $T=1190160 444045 1 0 $X=1189730 $Y=439490
X1127 39486 40448 44 84 40432 NOR2X1 $T=1194640 436205 0 0 $X=1194210 $Y=435815
X1128 40280 40432 44 84 40585 NOR2X1 $T=1202480 436205 1 180 $X=1199250 $Y=435815
X1129 41234 40929 44 84 41170 NOR2X1 $T=1223200 459725 0 180 $X=1219970 $Y=455170
X1130 44 84 30952 103 30992 ICV_81 $T=882160 459725 1 0 $X=881730 $Y=455170
X1131 44 84 120 31475 31459 ICV_81 $T=898400 467565 0 0 $X=897970 $Y=467175
X1132 44 84 120 192 32235 ICV_81 $T=929760 451885 1 0 $X=929330 $Y=447330
X1133 44 84 31766 197 32392 ICV_81 $T=935920 404845 1 0 $X=935490 $Y=400290
X1134 44 84 32680 32809 32828 ICV_81 $T=946560 475405 1 0 $X=946130 $Y=470850
X1135 44 84 163 212 32873 ICV_81 $T=947680 420525 0 0 $X=947250 $Y=420135
X1136 44 84 204 219 33117 ICV_81 $T=956080 436205 1 0 $X=955650 $Y=431650
X1137 44 84 183 33235 33250 ICV_81 $T=960000 428365 0 0 $X=959570 $Y=427975
X1138 44 84 33555 231 33284 ICV_81 $T=971200 444045 0 0 $X=970770 $Y=443655
X1139 44 84 34609 138 35034 ICV_81 $T=1018240 412685 0 0 $X=1017810 $Y=412295
X1140 44 84 213 258 35109 ICV_81 $T=1021600 451885 0 0 $X=1021170 $Y=451495
X1141 44 84 289 35963 34610 ICV_81 $T=1050160 483245 1 0 $X=1049730 $Y=478690
X1142 44 84 35386 103 36307 ICV_81 $T=1062480 428365 0 0 $X=1062050 $Y=427975
X1143 44 84 36419 109 36402 ICV_81 $T=1067520 420525 1 0 $X=1067090 $Y=415970
X1144 44 84 148 319 36723 ICV_81 $T=1077600 467565 1 0 $X=1077170 $Y=463010
X1145 44 84 105 37252 36629 ICV_81 $T=1093840 467565 0 0 $X=1093410 $Y=467175
X1146 44 84 110 332 36224 ICV_81 $T=1093840 483245 0 0 $X=1093410 $Y=482855
X1147 44 84 37511 37736 37718 ICV_81 $T=1108400 451885 0 0 $X=1107970 $Y=451495
X1148 44 84 38905 40606 40586 ICV_81 $T=1197440 444045 1 0 $X=1197010 $Y=439490
X1149 44 84 40730 40765 40280 ICV_81 $T=1202480 436205 0 0 $X=1202050 $Y=435815
X1150 44 84 30951 103 30950 ICV_76 $T=883840 451885 1 0 $X=883410 $Y=447330
X1151 44 84 31204 31251 113 ICV_76 $T=892240 436205 0 0 $X=891810 $Y=435815
X1152 44 84 121 127 31267 ICV_76 $T=897280 483245 0 0 $X=896850 $Y=482855
X1153 44 84 120 128 31076 ICV_76 $T=898400 467565 1 0 $X=897970 $Y=463010
X1154 44 84 31439 129 31455 ICV_76 $T=900640 412685 1 0 $X=900210 $Y=408130
X1155 44 84 142 149 31610 ICV_76 $T=909600 412685 1 0 $X=909170 $Y=408130
X1156 44 84 164 169 31580 ICV_76 $T=919680 475405 1 0 $X=919250 $Y=470850
X1157 44 84 151 118 171 ICV_76 $T=920800 483245 1 0 $X=920370 $Y=478690
X1158 44 84 125 179 32138 ICV_76 $T=924160 444045 0 0 $X=923730 $Y=443655
X1159 44 84 32091 129 32137 ICV_76 $T=924720 412685 1 0 $X=924290 $Y=408130
X1160 44 84 32091 188 32248 ICV_76 $T=928080 404845 1 0 $X=927650 $Y=400290
X1161 44 84 32393 197 32437 ICV_76 $T=934800 412685 1 0 $X=934370 $Y=408130
X1162 44 84 31912 190 32394 ICV_76 $T=934800 451885 0 0 $X=934370 $Y=451495
X1163 44 84 32371 109 32516 ICV_76 $T=941520 420525 0 0 $X=941090 $Y=420135
X1164 44 84 120 172 32677 ICV_76 $T=943200 451885 0 0 $X=942770 $Y=451495
X1165 44 84 213 215 32883 ICV_76 $T=951600 459725 1 0 $X=951170 $Y=455170
X1166 44 84 179 224 33203 ICV_76 $T=960560 420525 1 0 $X=960130 $Y=415970
X1167 44 84 33165 31507 33237 ICV_76 $T=961680 467565 1 0 $X=961250 $Y=463010
X1168 44 84 33301 33339 33169 ICV_76 $T=964480 412685 1 0 $X=964050 $Y=408130
X1169 44 84 228 33377 33006 ICV_76 $T=967840 475405 1 0 $X=967410 $Y=470850
X1170 44 84 219 34023 231 ICV_76 $T=985200 459725 0 0 $X=984770 $Y=459335
X1171 44 84 34254 34303 34290 ICV_76 $T=994720 404845 1 0 $X=994290 $Y=400290
X1172 44 84 239 237 34833 ICV_76 $T=1014880 412685 0 0 $X=1014450 $Y=412295
X1173 44 84 34834 233 34916 ICV_76 $T=1016000 420525 0 0 $X=1015570 $Y=420135
X1174 44 84 34835 233 35000 ICV_76 $T=1018240 483245 0 0 $X=1017810 $Y=482855
X1175 44 84 34998 188 34968 ICV_76 $T=1019360 444045 1 0 $X=1018930 $Y=439490
X1176 44 84 212 255 35083 ICV_76 $T=1021040 428365 1 0 $X=1020610 $Y=423810
X1177 44 84 136 257 35036 ICV_76 $T=1022160 475405 0 0 $X=1021730 $Y=475015
X1178 44 84 120 252 35560 ICV_76 $T=1037840 444045 0 0 $X=1037410 $Y=443655
X1179 44 84 148 278 35533 ICV_76 $T=1038400 436205 1 0 $X=1037970 $Y=431650
X1180 44 84 34463 282 35674 ICV_76 $T=1043440 475405 1 0 $X=1043010 $Y=470850
X1181 44 84 136 295 35975 ICV_76 $T=1052960 444045 1 0 $X=1052530 $Y=439490
X1182 44 84 35992 188 36128 ICV_76 $T=1058560 404845 1 0 $X=1058130 $Y=400290
X1183 44 84 125 36508 36227 ICV_76 $T=1070880 475405 1 0 $X=1070450 $Y=470850
X1184 44 84 36600 330 37038 ICV_76 $T=1089920 475405 1 0 $X=1089490 $Y=470850
X1185 44 84 110 37384 35963 ICV_76 $T=1099440 467565 1 0 $X=1099010 $Y=463010
X1186 44 84 89 346 40302 ICV_76 $T=1195760 475405 1 0 $X=1195330 $Y=470850
X1187 44 84 40479 40638 40606 ICV_76 $T=1200240 451885 0 0 $X=1199810 $Y=451495
X1188 44 84 40638 40960 41075 ICV_76 $T=1214800 459725 0 0 $X=1214370 $Y=459335
X1189 30950 31002 31044 44 84 30894 NAND3X1 $T=884400 444045 0 0 $X=883970 $Y=443655
X1190 30992 31034 31076 44 84 30874 NAND3X1 $T=885520 459725 0 0 $X=885090 $Y=459335
X1191 31131 31087 31045 44 84 30916 NAND3X1 $T=891680 467565 1 180 $X=887330 $Y=467175
X1192 31247 31292 31332 44 84 31246 NAND3X1 $T=893920 451885 1 0 $X=893490 $Y=447330
X1193 31333 31227 31248 44 84 116 NAND3X1 $T=898400 467565 1 180 $X=894050 $Y=467175
X1194 31350 119 115 44 84 31298 NAND3X1 $T=898960 420525 0 180 $X=894610 $Y=415970
X1195 31378 31416 31457 44 84 31299 NAND3X1 $T=898400 436205 0 0 $X=897970 $Y=435815
X1196 31379 31417 31458 44 84 31440 NAND3X1 $T=898400 444045 0 0 $X=897970 $Y=443655
X1197 31455 31415 31376 44 84 31377 NAND3X1 $T=902880 412685 1 180 $X=898530 $Y=412295
X1198 31569 31527 31487 44 84 31351 NAND3X1 $T=906800 444045 1 180 $X=902450 $Y=443655
X1199 31471 31610 31568 44 84 31330 NAND3X1 $T=909600 412685 0 180 $X=905250 $Y=408130
X1200 31709 31717 31583 44 84 31423 NAND3X1 $T=913520 420525 1 180 $X=909170 $Y=420135
X1201 31644 150 31755 44 84 31768 NAND3X1 $T=910160 475405 1 0 $X=909730 $Y=470850
X1202 31754 159 31894 44 84 31331 NAND3X1 $T=914080 436205 1 0 $X=913650 $Y=431650
X1203 31833 154 31900 44 84 31895 NAND3X1 $T=914640 436205 0 0 $X=914210 $Y=435815
X1204 31911 31767 31832 44 84 31876 NAND3X1 $T=919120 420525 0 180 $X=914770 $Y=415970
X1205 31783 160 31949 44 84 31931 NAND3X1 $T=915760 459725 0 0 $X=915330 $Y=459335
X1206 31947 31905 31858 44 84 31280 NAND3X1 $T=920240 444045 0 180 $X=915890 $Y=439490
X1207 31948 155 31804 44 84 31912 NAND3X1 $T=920240 451885 1 180 $X=915890 $Y=451495
X1208 31678 31990 32028 44 84 31847 NAND3X1 $T=918560 436205 0 0 $X=918130 $Y=435815
X1209 31965 32008 31787 44 84 31989 NAND3X1 $T=919120 428365 0 0 $X=918690 $Y=427975
X1210 32108 176 173 44 84 32061 NAND3X1 $T=926400 467565 0 180 $X=922050 $Y=463010
X1211 32137 32102 32060 44 84 31456 NAND3X1 $T=926960 428365 1 180 $X=922610 $Y=427975
X1212 32191 32136 32015 44 84 32154 NAND3X1 $T=928640 404845 1 180 $X=924290 $Y=404455
X1213 32156 31834 32235 44 84 32219 NAND3X1 $T=925840 451885 1 0 $X=925410 $Y=447330
X1214 32262 32121 32192 44 84 32155 NAND3X1 $T=931440 420525 0 180 $X=927090 $Y=415970
X1215 31545 32270 32138 44 84 32294 NAND3X1 $T=928640 467565 1 0 $X=928210 $Y=463010
X1216 31706 166 32372 44 84 32356 NAND3X1 $T=930880 459725 1 0 $X=930450 $Y=455170
X1217 32394 32431 32470 44 84 32457 NAND3X1 $T=934240 420525 0 0 $X=933810 $Y=420135
X1218 32395 32279 32474 44 84 196 NAND3X1 $T=934240 475405 1 0 $X=933810 $Y=470850
X1219 32409 32449 32293 44 84 32473 NAND3X1 $T=934800 444045 0 0 $X=934370 $Y=443655
X1220 202 32593 32546 44 84 31248 NAND3X1 $T=944320 467565 1 180 $X=939970 $Y=467175
X1221 32642 32561 32562 44 84 32439 NAND3X1 $T=944880 444045 0 180 $X=940530 $Y=439490
X1222 32690 32688 32565 44 84 32659 NAND3X1 $T=947680 412685 1 180 $X=943330 $Y=412295
X1223 32776 32733 32677 44 84 32491 NAND3X1 $T=949360 459725 0 180 $X=945010 $Y=455170
X1224 32821 32549 32740 44 84 32490 NAND3X1 $T=951040 428365 0 180 $X=946690 $Y=423810
X1225 32825 32742 32741 44 84 32799 NAND3X1 $T=951040 444045 0 180 $X=946690 $Y=439490
X1226 32806 32848 32873 44 84 32872 NAND3X1 $T=948800 420525 1 0 $X=948370 $Y=415970
X1227 32676 32883 32894 44 84 32760 NAND3X1 $T=949920 451885 0 0 $X=949490 $Y=451495
X1228 32884 32920 32874 44 84 32807 NAND3X1 $T=955520 436205 1 180 $X=951170 $Y=435815
X1229 33015 32972 32926 44 84 30853 NAND3X1 $T=957200 444045 0 180 $X=952850 $Y=439490
X1230 202 33006 33030 44 84 32825 NAND3X1 $T=953840 467565 0 0 $X=953410 $Y=467175
X1231 33138 33093 33049 44 84 32776 NAND3X1 $T=961120 459725 0 180 $X=956770 $Y=455170
X1232 32707 33118 33170 44 84 221 NAND3X1 $T=957760 467565 0 0 $X=957330 $Y=467175
X1233 33169 32966 32389 44 84 33084 NAND3X1 $T=962240 412685 0 180 $X=957890 $Y=408130
X1234 33104 33134 32991 44 84 218 NAND3X1 $T=962240 420525 1 180 $X=957890 $Y=420135
X1235 223 33237 33302 44 84 33270 NAND3X1 $T=962240 475405 0 0 $X=961810 $Y=475015
X1236 33203 33297 33250 44 84 33301 NAND3X1 $T=967840 420525 0 180 $X=963490 $Y=415970
X1237 33341 33396 33217 44 84 33373 NAND3X1 $T=971200 420525 1 180 $X=966850 $Y=420135
X1238 239 133 34256 44 84 34254 NAND3X1 $T=993600 412685 0 0 $X=993170 $Y=412295
X1239 34644 34611 34432 44 84 34581 NAND3X1 $T=1009840 428365 0 180 $X=1005490 $Y=423810
X1240 202 34755 34780 44 84 34796 NAND3X1 $T=1010960 467565 0 0 $X=1010530 $Y=467175
X1241 34581 34692 34748 44 84 34834 NAND3X1 $T=1012080 420525 0 0 $X=1011650 $Y=420135
X1242 248 34693 250 44 84 34835 NAND3X1 $T=1012080 483245 0 0 $X=1011650 $Y=482855
X1243 34850 34808 107 44 84 249 NAND3X1 $T=1016560 475405 1 180 $X=1012210 $Y=475015
X1244 34833 34710 34915 44 84 34896 NAND3X1 $T=1014320 404845 0 0 $X=1013890 $Y=404455
X1245 34881 34897 34968 44 84 251 NAND3X1 $T=1016000 444045 0 0 $X=1015570 $Y=443655
X1246 34796 34989 35032 44 84 253 NAND3X1 $T=1018240 467565 0 0 $X=1017810 $Y=467175
X1247 35067 35024 34952 44 84 34969 NAND3X1 $T=1023840 459725 1 180 $X=1019490 $Y=459335
X1248 35031 35035 35084 44 84 35102 NAND3X1 $T=1021040 436205 0 0 $X=1020610 $Y=435815
X1249 34932 35109 35083 44 84 35131 NAND3X1 $T=1022160 428365 0 0 $X=1021730 $Y=427975
X1250 35262 264 35179 44 84 34999 NAND3X1 $T=1030560 459725 0 180 $X=1026210 $Y=455170
X1251 35182 35232 35282 44 84 35281 NAND3X1 $T=1027200 451885 1 0 $X=1026770 $Y=447330
X1252 35268 35320 35360 44 84 35244 NAND3X1 $T=1029440 404845 0 0 $X=1029010 $Y=404455
X1253 35344 35304 35259 44 84 35290 NAND3X1 $T=1033360 428365 1 180 $X=1029010 $Y=427975
X1254 35345 35305 35180 44 84 268 NAND3X1 $T=1033360 475405 1 180 $X=1029010 $Y=475015
X1255 238 35258 272 44 84 35344 NAND3X1 $T=1029440 483245 0 0 $X=1029010 $Y=482855
X1256 35361 35321 35280 44 84 35212 NAND3X1 $T=1033920 436205 0 180 $X=1029570 $Y=431650
X1257 202 35439 35477 44 84 35463 NAND3X1 $T=1033920 467565 0 0 $X=1033490 $Y=467175
X1258 35228 35533 35401 44 84 35559 NAND3X1 $T=1037280 428365 1 0 $X=1036850 $Y=423810
X1259 35511 35403 35560 44 84 35576 NAND3X1 $T=1037840 444045 1 0 $X=1037410 $Y=439490
X1260 35542 35402 35659 44 84 35575 NAND3X1 $T=1040080 428365 0 0 $X=1039650 $Y=427975
X1261 35493 35631 103 44 84 35660 NAND3X1 $T=1040640 459725 0 0 $X=1040210 $Y=459335
X1262 35594 35632 35674 44 84 35512 NAND3X1 $T=1040640 475405 0 0 $X=1040210 $Y=475015
X1263 35658 35510 35736 44 84 35724 NAND3X1 $T=1042880 412685 1 0 $X=1042450 $Y=408130
X1264 33138 35696 35738 44 84 35713 NAND3X1 $T=1042880 451885 0 0 $X=1042450 $Y=451495
X1265 35673 35713 35725 44 84 35701 NAND3X1 $T=1043440 444045 0 0 $X=1043010 $Y=443655
X1266 35803 35765 35661 44 84 35737 NAND3X1 $T=1049600 428365 0 180 $X=1045250 $Y=423810
X1267 35000 35795 35838 44 84 35543 NAND3X1 $T=1046240 483245 1 0 $X=1045810 $Y=478690
X1268 35837 35741 34609 44 84 35658 NAND3X1 $T=1050720 412685 1 180 $X=1046370 $Y=412295
X1269 35463 35812 35660 44 84 35822 NAND3X1 $T=1046800 459725 0 0 $X=1046370 $Y=459335
X1270 33138 35908 35945 44 84 35812 NAND3X1 $T=1050160 459725 1 0 $X=1049730 $Y=455170
X1271 33138 35509 35783 44 84 288 NAND3X1 $T=1054080 475405 0 180 $X=1049730 $Y=470850
X1272 35946 294 35962 44 84 35843 NAND3X1 $T=1052960 459725 0 0 $X=1052530 $Y=459335
X1273 33138 36002 35821 44 84 35946 NAND3X1 $T=1058000 459725 0 180 $X=1053650 $Y=455170
X1274 36024 36113 36148 44 84 36146 NAND3X1 $T=1058000 428365 1 0 $X=1057570 $Y=423810
X1275 202 36120 36096 44 84 36147 NAND3X1 $T=1058000 467565 0 0 $X=1057570 $Y=467175
X1276 35865 36128 36111 44 84 36173 NAND3X1 $T=1059120 404845 0 0 $X=1058690 $Y=404455
X1277 36161 36056 36239 44 84 36174 NAND3X1 $T=1060800 436205 0 0 $X=1060370 $Y=435815
X1278 36240 36206 131 44 84 36161 NAND3X1 $T=1065280 444045 1 180 $X=1060930 $Y=443655
X1279 300 36227 36175 44 84 36258 NAND3X1 $T=1061920 467565 0 0 $X=1061490 $Y=467175
X1280 36238 35561 35343 44 84 36272 NAND3X1 $T=1067520 420525 0 180 $X=1063170 $Y=415970
X1281 33138 36269 36189 44 84 36241 NAND3X1 $T=1067520 467565 0 180 $X=1063170 $Y=463010
X1282 36334 36381 36421 44 84 36292 NAND3X1 $T=1066960 444045 1 0 $X=1066530 $Y=439490
X1283 36403 36361 36318 44 84 36210 NAND3X1 $T=1070880 451885 0 180 $X=1066530 $Y=447330
X1284 36032 36380 36436 44 84 36420 NAND3X1 $T=1067520 428365 0 0 $X=1067090 $Y=427975
X1285 36521 313 36390 44 84 36458 NAND3X1 $T=1074800 459725 0 180 $X=1070450 $Y=455170
X1286 36627 36591 36555 44 84 36366 NAND3X1 $T=1078720 412685 0 180 $X=1074370 $Y=408130
X1287 36578 36601 36322 44 84 36722 NAND3X1 $T=1078160 436205 1 0 $X=1077730 $Y=431650
X1288 36690 36765 36774 44 84 36789 NAND3X1 $T=1080400 420525 1 0 $X=1079970 $Y=415970
X1289 36907 322 320 44 84 36840 NAND3X1 $T=1088240 467565 0 180 $X=1083890 $Y=463010
X1290 36924 36770 36692 44 84 36880 NAND3X1 $T=1088800 444045 0 180 $X=1084450 $Y=439490
X1291 36361 36754 36874 44 84 36925 NAND3X1 $T=1084880 467565 0 0 $X=1084450 $Y=467175
X1292 36910 324 36752 44 84 36855 NAND3X1 $T=1090480 451885 1 180 $X=1086130 $Y=451495
X1293 36960 36873 34916 44 84 326 NAND3X1 $T=1091040 420525 1 180 $X=1086690 $Y=420135
X1294 36902 36806 323 44 84 36941 NAND3X1 $T=1091600 436205 0 180 $X=1087250 $Y=431650
X1295 239 136 105 44 84 37511 NAND3X1 $T=1108960 459725 0 180 $X=1104610 $Y=455170
X1296 239 136 110 44 84 37755 NAND3X1 $T=1110080 444045 0 0 $X=1109650 $Y=443655
X1297 37563 37748 110 44 84 37736 NAND3X1 $T=1110640 451885 1 0 $X=1110210 $Y=447330
X1298 38557 38598 38562 44 84 38810 NAND3X1 $T=1142000 444045 0 0 $X=1141570 $Y=443655
X1299 41234 41026 347 44 84 348 NAND3X1 $T=1223200 475405 0 180 $X=1218850 $Y=470850
X1300 44 105 30026 108 84 105 29460 104 ICV_115 $T=889440 483245 0 180 $X=886210 $Y=478690
X1301 44 110 29443 118 84 110 29460 31196 ICV_115 $T=894480 483245 1 180 $X=891250 $Y=482855
X1302 44 104 143 31475 84 136 127 119 ICV_115 $T=905680 483245 1 180 $X=902450 $Y=482855
X1303 44 148 146 31487 84 31646 131 31569 ICV_115 $T=909600 444045 1 180 $X=906370 $Y=443655
X1304 44 136 158 155 84 148 144 152 ICV_115 $T=914080 483245 1 180 $X=910850 $Y=482855
X1305 44 121 161 31858 84 112 146 31834 ICV_115 $T=916880 451885 0 180 $X=913650 $Y=447330
X1306 44 148 162 31913 84 157 122 31752 ICV_115 $T=916880 467565 0 180 $X=913650 $Y=463010
X1307 44 148 117 31900 84 136 124 154 ICV_115 $T=916880 475405 0 180 $X=913650 $Y=470850
X1308 44 165 31977 167 84 148 158 160 ICV_115 $T=919680 483245 1 180 $X=916450 $Y=482855
X1309 44 139 174 31859 84 31977 164 117 ICV_115 $T=921360 475405 1 180 $X=918130 $Y=475015
X1310 44 136 180 32102 84 136 161 32008 ICV_115 $T=925280 436205 1 180 $X=922050 $Y=435815
X1311 44 148 194 32028 84 148 180 32312 ICV_115 $T=933680 436205 1 180 $X=930450 $Y=435815
X1312 44 31646 197 32676 84 121 171 32562 ICV_115 $T=943760 451885 0 180 $X=940530 $Y=447330
X1313 44 142 247 36009 84 261 139 35974 ICV_115 $T=1056320 412685 1 180 $X=1053090 $Y=412295
X1314 44 142 304 36239 84 234 247 36055 ICV_115 $T=1062480 436205 0 180 $X=1059250 $Y=431650
X1315 44 36350 35963 299 84 36350 311 35480 ICV_115 $T=1073680 475405 1 180 $X=1070450 $Y=475015
X1316 44 36629 36224 321 84 36629 306 243 ICV_115 $T=1082640 475405 1 180 $X=1079410 $Y=475015
X1317 107 31086 44 84 30756 OR2X1 $T=891120 436205 0 180 $X=887330 $Y=431650
X1318 107 31205 44 84 30893 OR2X1 $T=895040 428365 0 180 $X=891250 $Y=423810
X1319 107 31216 44 84 31186 OR2X1 $T=895600 428365 1 180 $X=891810 $Y=427975
X1320 107 31236 44 84 31204 OR2X1 $T=896160 412685 1 180 $X=892370 $Y=412295
X1321 107 31312 44 84 31333 OR2X1 $T=895040 428365 1 0 $X=894610 $Y=423810
X1322 107 32139 44 84 32303 OR2X1 $T=929200 436205 1 0 $X=928770 $Y=431650
X1323 177 120 44 84 32546 OR2X1 $T=938720 475405 1 0 $X=938290 $Y=470850
X1324 204 112 44 84 32593 OR2X1 $T=945440 467565 0 180 $X=941650 $Y=463010
X1325 32807 32760 44 84 32732 OR2X1 $T=949920 451885 1 180 $X=946130 $Y=451495
X1326 187 120 44 84 33030 OR2X1 $T=953840 467565 1 0 $X=953410 $Y=463010
X1327 31580 121 44 84 33049 OR2X1 $T=961120 451885 0 180 $X=957330 $Y=447330
X1328 172 33165 44 84 33201 OR2X1 $T=959440 459725 0 0 $X=959010 $Y=459335
X1329 167 33165 44 84 225 OR2X1 $T=960560 483245 1 0 $X=960130 $Y=478690
X1330 215 125 44 84 33093 OR2X1 $T=964480 459725 0 180 $X=960690 $Y=455170
X1331 31507 226 44 84 33251 OR2X1 $T=962240 451885 1 0 $X=961810 $Y=447330
X1332 33165 222 44 84 33303 OR2X1 $T=964480 459725 1 0 $X=964050 $Y=455170
X1333 32532 226 44 84 33376 OR2X1 $T=971200 444045 1 180 $X=967410 $Y=443655
X1334 33357 33441 44 84 33302 OR2X1 $T=972320 475405 1 180 $X=968530 $Y=475015
X1335 207 213 44 84 238 OR2X1 $T=989120 483245 0 0 $X=988690 $Y=482855
X1336 227 34610 44 84 34611 OR2X1 $T=1005920 420525 0 0 $X=1005490 $Y=420135
X1337 219 241 44 84 34644 OR2X1 $T=1005920 444045 1 0 $X=1005490 $Y=439490
X1338 34432 34608 44 84 34710 OR2X1 $T=1008160 412685 1 0 $X=1007730 $Y=408130
X1339 241 120 44 84 34755 OR2X1 $T=1015440 459725 1 180 $X=1011650 $Y=459335
X1340 190 34922 44 84 34881 OR2X1 $T=1019920 451885 0 180 $X=1016130 $Y=447330
X1341 257 213 44 84 35258 OR2X1 $T=1026640 483245 1 0 $X=1026210 $Y=478690
X1342 120 35309 44 84 35378 OR2X1 $T=1036720 451885 0 180 $X=1032930 $Y=447330
X1343 34463 259 44 84 35493 OR2X1 $T=1035040 459725 0 0 $X=1034610 $Y=459335
X1344 257 125 44 84 35509 OR2X1 $T=1035600 475405 0 0 $X=1035170 $Y=475015
X1345 254 112 44 84 35439 OR2X1 $T=1041200 467565 1 180 $X=1037410 $Y=467175
X1346 262 120 44 84 35477 OR2X1 $T=1044560 467565 1 180 $X=1040770 $Y=467175
X1347 33165 280 44 84 35631 OR2X1 $T=1041760 459725 1 0 $X=1041330 $Y=455170
X1348 35576 35701 44 84 283 OR2X1 $T=1044000 444045 1 0 $X=1043570 $Y=439490
X1349 280 121 44 84 35738 OR2X1 $T=1045120 459725 1 0 $X=1044690 $Y=455170
X1350 282 121 44 84 35783 OR2X1 $T=1045120 475405 0 0 $X=1044690 $Y=475015
X1351 136 279 44 84 35741 OR2X1 $T=1049600 428365 1 180 $X=1045810 $Y=427975
X1352 190 35810 44 84 35260 OR2X1 $T=1050720 436205 0 180 $X=1046930 $Y=431650
X1353 190 35811 44 84 35261 OR2X1 $T=1050720 444045 0 180 $X=1046930 $Y=439490
X1354 213 35819 44 84 287 OR2X1 $T=1047360 483245 0 0 $X=1046930 $Y=482855
X1355 298 142 44 84 35837 OR2X1 $T=1058560 428365 1 180 $X=1054770 $Y=427975
X1356 243 120 44 84 36096 OR2X1 $T=1056320 475405 1 0 $X=1055890 $Y=470850
X1357 36110 121 44 84 35908 OR2X1 $T=1061360 459725 0 180 $X=1057570 $Y=455170
X1358 112 36110 44 84 36120 OR2X1 $T=1058000 467565 1 0 $X=1057570 $Y=463010
X1359 34923 121 44 84 36189 OR2X1 $T=1059680 459725 0 0 $X=1059250 $Y=459335
X1360 34923 234 44 84 36206 OR2X1 $T=1061360 451885 1 0 $X=1060930 $Y=447330
X1361 121 302 44 84 36002 OR2X1 $T=1061360 459725 1 0 $X=1060930 $Y=455170
X1362 252 237 44 84 36240 OR2X1 $T=1063600 451885 0 0 $X=1063170 $Y=451495
X1363 309 125 44 84 36269 OR2X1 $T=1069760 467565 1 180 $X=1065970 $Y=467175
X1364 327 37036 44 84 37078 OR2X1 $T=1089920 459725 1 0 $X=1089490 $Y=455170
X1365 37036 37304 44 84 37563 OR2X1 $T=1104480 444045 0 0 $X=1104050 $Y=443655
X1366 38562 37457 44 84 38474 OR2X1 $T=1138640 428365 1 180 $X=1134850 $Y=427975
X1367 38562 38224 44 84 37748 OR2X1 $T=1139760 451885 0 180 $X=1135970 $Y=447330
X1368 38557 37420 44 84 338 OR2X1 $T=1141440 444045 1 0 $X=1141010 $Y=439490
X1369 38557 37748 44 84 339 OR2X1 $T=1142000 451885 1 0 $X=1141570 $Y=447330
X1370 38810 38905 44 84 38940 OR2X1 $T=1146480 444045 1 0 $X=1146050 $Y=439490
X1371 190 38810 44 84 38996 OR2X1 $T=1152080 444045 0 0 $X=1151650 $Y=443655
X1372 107 38810 44 84 39251 OR2X1 $T=1156560 444045 1 0 $X=1156130 $Y=439490
X1373 39152 39284 44 84 39320 OR2X1 $T=1158800 428365 0 0 $X=1158370 $Y=427975
X1374 39429 39557 44 84 342 OR2X1 $T=1169440 451885 0 0 $X=1169010 $Y=451495
X1375 40960 40929 44 84 39777 OR2X1 $T=1213680 459725 0 180 $X=1209890 $Y=455170
X1376 44 84 31113 103 31099 ICV_74 $T=887760 444045 1 0 $X=887330 $Y=439490
X1377 44 84 31724 131 31709 ICV_74 $T=909040 428365 0 0 $X=908610 $Y=427975
X1378 44 84 139 145 31804 ICV_74 $T=912400 451885 0 0 $X=911970 $Y=451495
X1379 44 84 125 204 32742 ICV_74 $T=945440 444045 0 0 $X=945010 $Y=443655
X1380 44 84 121 217 33034 ICV_74 $T=954960 483245 0 0 $X=954530 $Y=482855
X1381 44 84 103 174 33351 ICV_74 $T=965600 483245 0 0 $X=965170 $Y=482855
X1382 44 84 34371 224 33441 ICV_74 $T=996960 467565 1 0 $X=996530 $Y=463010
X1383 44 84 243 33235 242 ICV_74 $T=1005920 483245 0 0 $X=1005490 $Y=482855
X1384 44 84 244 33235 34663 ICV_74 $T=1007600 428365 0 0 $X=1007170 $Y=427975
X1385 44 84 34933 197 34897 ICV_74 $T=1016000 444045 1 0 $X=1015570 $Y=439490
X1386 44 84 216 245 35035 ICV_74 $T=1019920 436205 1 0 $X=1019490 $Y=431650
X1387 44 84 207 262 35232 ICV_74 $T=1026640 459725 0 0 $X=1026210 $Y=459335
X1388 44 84 35309 131 35262 ICV_74 $T=1030560 459725 1 0 $X=1030130 $Y=455170
X1389 44 84 148 35882 36322 ICV_74 $T=1065280 436205 1 0 $X=1064850 $Y=431650
X1390 44 84 304 237 36440 ICV_74 $T=1069200 436205 0 0 $X=1068770 $Y=435815
X1391 44 84 136 316 313 ICV_74 $T=1074240 483245 0 0 $X=1073810 $Y=482855
X1392 44 84 36567 129 36690 ICV_74 $T=1078720 412685 1 0 $X=1078290 $Y=408130
X1393 44 84 139 314 36806 ICV_74 $T=1082080 436205 1 0 $X=1081650 $Y=431650
X1394 44 84 40302 40186 40281 ICV_74 $T=1189600 475405 1 0 $X=1189170 $Y=470850
X1395 44 84 41333 348 41317 ICV_74 $T=1223200 475405 1 0 $X=1222770 $Y=470850
X1396 44 110 30026 31134 84 ICV_78 $T=887760 475405 1 0 $X=887330 $Y=470850
X1397 44 31265 103 31247 84 ICV_78 $T=891680 451885 0 0 $X=891250 $Y=451495
X1398 44 139 141 31583 84 ICV_78 $T=903440 420525 0 0 $X=903010 $Y=420135
X1399 44 151 31196 31661 84 ICV_78 $T=909040 475405 0 0 $X=908610 $Y=475015
X1400 44 139 153 32015 84 ICV_78 $T=918560 404845 0 0 $X=918130 $Y=404455
X1401 44 125 172 31905 84 ICV_78 $T=920240 444045 1 0 $X=919810 $Y=439490
X1402 44 32308 129 32191 84 ICV_78 $T=928640 404845 0 0 $X=928210 $Y=404455
X1403 44 32392 32248 32373 84 ICV_78 $T=931440 404845 1 0 $X=931010 $Y=400290
X1404 44 108 193 31507 84 ICV_78 $T=931440 475405 0 0 $X=931010 $Y=475015
X1405 44 200 31196 177 84 ICV_78 $T=935920 475405 0 0 $X=935490 $Y=475015
X1406 44 195 201 32532 84 ICV_78 $T=937600 483245 1 0 $X=937170 $Y=478690
X1407 44 32582 188 32411 84 ICV_78 $T=938160 404845 0 0 $X=937730 $Y=404455
X1408 44 32582 197 32565 84 ICV_78 $T=938160 412685 1 0 $X=937730 $Y=408130
X1409 44 125 32641 32680 84 ICV_78 $T=942080 475405 1 0 $X=941650 $Y=470850
X1410 44 32691 109 32688 84 ICV_78 $T=942640 420525 1 0 $X=942210 $Y=415970
X1411 44 112 205 32733 84 ICV_78 $T=944320 467565 0 0 $X=943890 $Y=467175
X1412 44 207 171 206 84 ICV_78 $T=946000 483245 0 0 $X=945570 $Y=482855
X1413 44 33320 33201 33170 84 ICV_78 $T=962800 459725 0 0 $X=962370 $Y=459335
X1414 44 34451 33339 34303 84 ICV_78 $T=998640 404845 0 0 $X=998210 $Y=404455
X1415 44 34546 34494 33138 84 ICV_78 $T=1006480 451885 1 0 $X=1006050 $Y=447330
X1416 44 254 139 35024 84 ICV_78 $T=1018800 459725 1 0 $X=1018370 $Y=455170
X1417 44 244 212 35343 84 ICV_78 $T=1029440 420525 1 0 $X=1029010 $Y=415970
X1418 44 35386 109 35673 84 ICV_78 $T=1041760 436205 0 0 $X=1041330 $Y=435815
X1419 44 139 271 35824 84 ICV_78 $T=1046240 420525 1 0 $X=1045810 $Y=415970
X1420 44 120 259 35962 84 ICV_78 $T=1051280 467565 0 0 $X=1050850 $Y=467175
X1421 44 296 290 34923 84 ICV_78 $T=1052960 475405 0 0 $X=1052530 $Y=475015
X1422 44 142 35480 36693 84 ICV_78 $T=1077040 459725 0 0 $X=1076610 $Y=459335
X1423 44 139 304 36774 84 ICV_78 $T=1079840 428365 0 0 $X=1079410 $Y=427975
X1424 44 36659 36790 36908 84 ICV_78 $T=1084320 483245 1 0 $X=1083890 $Y=478690
X1425 44 90 39751 40186 84 ICV_78 $T=1185680 475405 0 0 $X=1185250 $Y=475015
X1426 44 89 39733 40506 84 ICV_78 $T=1195200 475405 0 0 $X=1194770 $Y=475015
X1427 44 41384 40960 41333 84 ICV_78 $T=1223760 467565 0 0 $X=1223330 $Y=467175
X1456 44 84 31186 31252 114 ICV_72 $T=892800 444045 1 0 $X=892370 $Y=439490
X1457 44 84 121 124 31045 ICV_72 $T=897280 475405 1 0 $X=896850 $Y=470850
X1458 44 84 125 130 31417 ICV_72 $T=903440 451885 1 0 $X=903010 $Y=447330
X1459 44 84 139 31618 31568 ICV_72 $T=906800 412685 0 0 $X=906370 $Y=412295
X1460 44 84 142 153 31717 ICV_72 $T=913520 420525 0 0 $X=913090 $Y=420135
X1461 44 84 136 171 31990 ICV_72 $T=920800 451885 1 0 $X=920370 $Y=447330
X1462 44 84 148 177 115 ICV_72 $T=922480 483245 0 0 $X=922050 $Y=482855
X1463 44 84 139 149 32192 ICV_72 $T=928080 412685 0 0 $X=927650 $Y=412295
X1464 44 84 120 31507 32293 ICV_72 $T=929760 451885 0 0 $X=929330 $Y=451495
X1465 44 84 139 32532 32372 ICV_72 $T=938160 451885 0 0 $X=937730 $Y=451495
X1466 44 84 112 209 32809 ICV_72 $T=948240 475405 0 0 $X=947810 $Y=475015
X1467 44 84 32775 109 32740 ICV_72 $T=952720 428365 1 0 $X=952290 $Y=423810
X1468 44 84 228 34799 34780 ICV_72 $T=1012080 475405 1 0 $X=1011650 $Y=470850
X1469 44 84 34815 233 34932 ICV_72 $T=1017120 428365 0 0 $X=1016690 $Y=427975
X1470 44 84 212 256 35084 ICV_72 $T=1022160 451885 1 0 $X=1021730 $Y=447330
X1471 44 84 245 212 35259 ICV_72 $T=1029440 428365 1 0 $X=1029010 $Y=423810
X1472 44 84 168 34923 35179 ICV_72 $T=1030000 459725 0 0 $X=1029570 $Y=459335
X1473 44 84 125 299 35795 ICV_72 $T=1056880 483245 0 0 $X=1056450 $Y=482855
X1474 44 84 36006 190 36111 ICV_72 $T=1058560 412685 1 0 $X=1058130 $Y=408130
X1475 44 84 121 35819 36175 ICV_72 $T=1060800 475405 1 0 $X=1060370 $Y=470850
X1476 44 84 301 36224 35819 ICV_72 $T=1061920 483245 0 0 $X=1061490 $Y=482855
X1477 44 84 303 306 36035 ICV_72 $T=1065840 475405 1 0 $X=1065410 $Y=470850
X1478 44 84 142 321 36874 ICV_72 $T=1084880 475405 1 0 $X=1084450 $Y=470850
X1479 44 84 36941 107 36960 ICV_72 $T=1087680 428365 0 0 $X=1087250 $Y=427975
X1480 31459 31491 44 84 31545 AND2X1 $T=902320 475405 1 0 $X=901890 $Y=470850
X1481 31581 31615 44 84 31644 AND2X1 $T=905680 475405 1 0 $X=905250 $Y=470850
X1482 31676 31752 44 84 31783 AND2X1 $T=910720 459725 0 0 $X=910290 $Y=459335
X1483 31900 31859 44 84 156 AND2X1 $T=918560 475405 1 180 $X=914770 $Y=475015
X1484 32002 31913 44 84 31948 AND2X1 $T=920240 451885 0 0 $X=919810 $Y=451495
X1485 32177 32106 44 84 32108 AND2X1 $T=928080 459725 0 180 $X=924290 $Y=455170
X1486 32312 31790 44 84 32389 AND2X1 $T=932000 428365 0 0 $X=931570 $Y=427975
X1487 32411 32437 44 84 32470 AND2X1 $T=934800 404845 0 0 $X=934370 $Y=404455
X1488 32548 32516 44 84 32431 AND2X1 $T=941520 420525 1 180 $X=937730 $Y=420135
X1489 32061 190 44 84 32577 AND2X1 $T=938720 467565 1 0 $X=938290 $Y=463010
X1490 32946 214 44 84 32884 AND2X1 $T=954960 483245 0 180 $X=951170 $Y=478690
X1491 33236 33117 44 84 33297 AND2X1 $T=962800 436205 1 0 $X=962370 $Y=431650
X1492 33201 226 44 84 33232 AND2X1 $T=967280 467565 1 180 $X=963490 $Y=467175
X1493 33105 33321 44 84 33341 AND2X1 $T=970080 428365 1 180 $X=966290 $Y=427975
X1494 230 33235 44 84 232 AND2X1 $T=972320 483245 0 0 $X=971890 $Y=482855
X1495 219 233 44 84 216 AND2X1 $T=980160 428365 1 180 $X=976370 $Y=427975
X1496 227 33339 44 84 234 AND2X1 $T=982960 428365 0 0 $X=982530 $Y=427975
X1497 235 133 44 84 139 AND2X1 $T=985200 451885 0 0 $X=984770 $Y=451495
X1498 219 33339 44 84 237 AND2X1 $T=989120 428365 0 0 $X=988690 $Y=427975
X1499 224 236 44 84 212 AND2X1 $T=992480 444045 0 180 $X=988690 $Y=439490
X1500 33235 236 44 84 213 AND2X1 $T=989120 483245 1 0 $X=988690 $Y=478690
X1501 34023 224 44 84 120 AND2X1 $T=994720 459725 1 180 $X=990930 $Y=459335
X1502 227 34023 44 84 226 AND2X1 $T=994720 467565 1 180 $X=990930 $Y=467175
X1503 227 236 44 84 220 AND2X1 $T=993600 483245 0 0 $X=993170 $Y=482855
X1504 235 138 44 84 148 AND2X1 $T=997520 436205 0 0 $X=997090 $Y=435815
X1505 34371 33235 44 84 33165 AND2X1 $T=1003120 459725 0 180 $X=999330 $Y=455170
X1506 35036 35068 44 84 35067 AND2X1 $T=1021040 475405 1 0 $X=1020610 $Y=470850
X1507 35884 35824 44 84 35803 AND2X1 $T=1052400 420525 1 180 $X=1048610 $Y=420135
X1508 35804 35881 44 84 35345 AND2X1 $T=1053520 444045 1 180 $X=1049730 $Y=443655
X1509 35638 35973 44 84 36032 AND2X1 $T=1054080 397005 0 0 $X=1053650 $Y=396615
X1510 35975 36055 44 84 36024 AND2X1 $T=1059680 436205 0 180 $X=1055890 $Y=431650
X1511 36241 36147 44 84 36334 AND2X1 $T=1064720 459725 0 0 $X=1064290 $Y=459335
X1512 36307 36402 44 84 36380 AND2X1 $T=1072000 428365 0 180 $X=1068210 $Y=423810
X1513 36491 107 44 84 35914 AND2X1 $T=1073680 412685 1 180 $X=1069890 $Y=412295
X1514 36440 36489 44 84 36578 AND2X1 $T=1073120 436205 0 0 $X=1072690 $Y=435815
X1515 36291 36599 44 84 36627 AND2X1 $T=1074800 404845 1 0 $X=1074370 $Y=400290
X1516 36537 103 44 84 36617 AND2X1 $T=1080400 420525 0 180 $X=1076610 $Y=415970
X1517 36693 36723 44 84 36521 AND2X1 $T=1082640 459725 1 0 $X=1082210 $Y=455170
X1518 38474 37748 44 84 37304 AND2X1 $T=1134720 436205 0 180 $X=1130930 $Y=431650
X1519 39096 107 44 84 39166 AND2X1 $T=1153760 428365 0 0 $X=1153330 $Y=427975
X1520 32799 44 84 32821 INVX2 $T=948800 436205 1 0 $X=948370 $Y=431650
X1521 32872 44 84 32991 INVX2 $T=954400 420525 1 0 $X=953970 $Y=415970
X1522 32532 44 84 33357 INVX2 $T=968960 475405 1 180 $X=966850 $Y=475015
X1523 133 44 84 138 INVX2 $T=969520 436205 0 180 $X=967410 $Y=431650
X1524 222 44 84 33377 INVX2 $T=969520 467565 1 180 $X=967410 $Y=467175
X1525 228 44 84 112 INVX2 $T=990800 475405 0 180 $X=988690 $Y=470850
X1526 34023 44 84 34166 INVX2 $T=993600 436205 1 180 $X=991490 $Y=435815
X1527 33339 44 84 34256 INVX2 $T=995840 412685 1 0 $X=995410 $Y=408130
X1528 129 44 84 34002 INVX2 $T=999760 451885 0 180 $X=997650 $Y=447330
X1529 33441 44 84 34463 INVX2 $T=1001440 475405 1 0 $X=1001010 $Y=470850
X1530 34255 44 84 34432 INVX2 $T=1003680 404845 0 0 $X=1003250 $Y=404455
X1531 34608 44 84 34451 INVX2 $T=1008160 404845 1 180 $X=1006050 $Y=404455
X1532 240 44 84 34609 INVX2 $T=1006480 412685 0 0 $X=1006050 $Y=412295
X1533 34494 44 84 121 INVX2 $T=1008160 459725 1 0 $X=1007730 $Y=455170
X1534 34546 44 84 125 INVX2 $T=1009840 459725 1 180 $X=1007730 $Y=459335
X1535 34923 44 84 34799 INVX2 $T=1018800 475405 0 180 $X=1016690 $Y=470850
X1536 35034 44 84 142 INVX2 $T=1024960 412685 0 0 $X=1024530 $Y=412295
X1537 35290 44 84 35268 INVX2 $T=1031120 412685 0 180 $X=1029010 $Y=408130
X1538 258 44 84 35572 INVX2 $T=1039520 459725 1 0 $X=1039090 $Y=455170
X1539 109 44 84 35736 INVX2 $T=1046800 412685 1 0 $X=1046370 $Y=408130
X1540 35843 44 84 35865 INVX2 $T=1049600 412685 1 0 $X=1049170 $Y=408130
X1541 269 44 84 35961 INVX2 $T=1058560 451885 1 180 $X=1056450 $Y=451495
X1542 36880 44 84 36902 INVX2 $T=1086000 436205 1 0 $X=1085570 $Y=431650
X1543 190 44 84 107 INVX2 $T=1095520 436205 0 0 $X=1095090 $Y=435815
X1544 136 44 84 37036 INVX2 $T=1105040 451885 0 180 $X=1102930 $Y=447330
X1545 36839 44 84 37420 INVX2 $T=1130800 420525 1 0 $X=1130370 $Y=415970
X1546 37457 44 84 38557 INVX2 $T=1135280 444045 1 0 $X=1134850 $Y=439490
X1547 38224 44 84 38598 INVX2 $T=1136960 444045 1 0 $X=1136530 $Y=439490
X1548 38905 44 84 38793 INVX2 $T=1149840 436205 0 180 $X=1147730 $Y=431650
X1549 38630 44 84 39371 INVX2 $T=1162160 444045 1 0 $X=1161730 $Y=439490
X1550 39777 44 84 97 INVX2 $T=1176720 459725 1 180 $X=1174610 $Y=459335
X1551 40300 44 84 40448 INVX2 $T=1195760 444045 1 0 $X=1195330 $Y=439490
X1552 342 44 84 40479 INVX2 $T=1196320 451885 0 0 $X=1195890 $Y=451495
X1553 40638 44 84 40730 INVX2 $T=1205840 444045 1 0 $X=1205410 $Y=439490
X1554 40960 44 84 41234 INVX2 $T=1222080 467565 1 0 $X=1221650 $Y=463010
X1555 41026 44 84 41363 INVX2 $T=1225440 467565 1 0 $X=1225010 $Y=463010
X1556 41187 44 84 41453 INVX2 $T=1228240 467565 1 0 $X=1227810 $Y=463010
X1600 292 44 84 35892 BUFX1 $T=1054080 412685 0 180 $X=1050850 $Y=408130
.ENDS
***************************************
.SUBCKT padbox
** N=1 EP=0 IP=0 FDC=0
.ENDS
***************************************
.SUBCKT pad_in VSS VDD DataIn
** N=24 EP=3 IP=1 FDC=96
M0 VSS VSS 6 VSS N L=3.5e-07 W=9e-06 $X=5700 $Y=147100 $D=0
M1 7 6 VSS VSS N L=3.5e-07 W=9e-06 $X=8100 $Y=147100 $D=0
M2 VSS VSS 9 VSS N L=3.5e-07 W=9e-06 $X=13200 $Y=147100 $D=0
M3 9 VSS VSS VSS N L=3.5e-07 W=9e-06 $X=15600 $Y=147100 $D=0
M4 pad 9 VSS VSS N L=3.5e-07 W=2e-05 $X=15770 $Y=191300 $D=0
M5 VSS 9 pad VSS N L=3.5e-07 W=2e-05 $X=15770 $Y=196210 $D=0
M6 pad 9 VSS VSS N L=3.5e-07 W=2e-05 $X=15770 $Y=197780 $D=0
M7 VSS 9 pad VSS N L=3.5e-07 W=2e-05 $X=15770 $Y=202690 $D=0
M8 pad 9 VSS VSS N L=3.5e-07 W=2e-05 $X=15770 $Y=204260 $D=0
M9 VSS 9 pad VSS N L=3.5e-07 W=2e-05 $X=15770 $Y=209170 $D=0
M10 pad 9 VSS VSS N L=3.5e-07 W=2e-05 $X=15770 $Y=210740 $D=0
M11 VSS 9 pad VSS N L=3.5e-07 W=2e-05 $X=15770 $Y=215650 $D=0
M12 pad 9 VSS VSS N L=3.5e-07 W=2e-05 $X=15770 $Y=217220 $D=0
M13 VSS 9 pad VSS N L=3.5e-07 W=2e-05 $X=15770 $Y=222130 $D=0
M14 VSS VSS 9 VSS N L=3.5e-07 W=9e-06 $X=18000 $Y=147100 $D=0
M15 9 VSS VSS VSS N L=3.5e-07 W=9e-06 $X=20400 $Y=147100 $D=0
M16 VSS VSS 9 VSS N L=3.5e-07 W=9e-06 $X=22800 $Y=147100 $D=0
M17 9 6 VSS VSS N L=3.5e-07 W=9e-06 $X=25200 $Y=147100 $D=0
M18 VSS 6 9 VSS N L=3.5e-07 W=9e-06 $X=27600 $Y=147100 $D=0
M19 9 6 VSS VSS N L=3.5e-07 W=9e-06 $X=30000 $Y=147100 $D=0
M20 VSS 6 9 VSS N L=3.5e-07 W=9e-06 $X=32400 $Y=147100 $D=0
M21 9 6 VSS VSS N L=3.5e-07 W=9e-06 $X=34800 $Y=147100 $D=0
M22 8 7 9 VSS N L=3.5e-07 W=9e-06 $X=37200 $Y=147100 $D=0
M23 9 7 8 VSS N L=3.5e-07 W=9e-06 $X=39600 $Y=147100 $D=0
M24 8 7 9 VSS N L=3.5e-07 W=9e-06 $X=42000 $Y=147100 $D=0
M25 9 7 8 VSS N L=3.5e-07 W=9e-06 $X=44400 $Y=147100 $D=0
M26 pad 9 VSS VSS N L=3.5e-07 W=2e-05 $X=54230 $Y=191300 $D=0
M27 VSS 9 pad VSS N L=3.5e-07 W=2e-05 $X=54230 $Y=196210 $D=0
M28 pad 9 VSS VSS N L=3.5e-07 W=2e-05 $X=54230 $Y=197780 $D=0
M29 VSS 9 pad VSS N L=3.5e-07 W=2e-05 $X=54230 $Y=202690 $D=0
M30 pad 9 VSS VSS N L=3.5e-07 W=2e-05 $X=54230 $Y=204260 $D=0
M31 VSS 9 pad VSS N L=3.5e-07 W=2e-05 $X=54230 $Y=209170 $D=0
M32 pad 9 VSS VSS N L=3.5e-07 W=2e-05 $X=54230 $Y=210740 $D=0
M33 VSS 9 pad VSS N L=3.5e-07 W=2e-05 $X=54230 $Y=215650 $D=0
M34 pad 9 VSS VSS N L=3.5e-07 W=2e-05 $X=54230 $Y=217220 $D=0
M35 VSS 9 pad VSS N L=3.5e-07 W=2e-05 $X=54230 $Y=222130 $D=0
M36 11 pad VSS VSS N L=3.5e-07 W=9e-06 $X=59400 $Y=146950 $D=0
M37 VSS pad 11 VSS N L=3.5e-07 W=9e-06 $X=61800 $Y=146950 $D=0
M38 11 pad VSS VSS N L=3.5e-07 W=9e-06 $X=64200 $Y=146950 $D=0
M39 VSS pad 11 VSS N L=3.5e-07 W=9e-06 $X=66600 $Y=146950 $D=0
M40 11 pad VSS VSS N L=3.5e-07 W=9e-06 $X=69000 $Y=146950 $D=0
M41 VSS pad 11 VSS N L=3.5e-07 W=9e-06 $X=71400 $Y=146950 $D=0
M42 DataIn 11 VSS VSS N L=3.5e-07 W=9e-06 $X=73800 $Y=146950 $D=0
M43 VSS 11 DataIn VSS N L=3.5e-07 W=9e-06 $X=76200 $Y=146950 $D=0
M44 DataIn 11 VSS VSS N L=3.5e-07 W=9e-06 $X=78600 $Y=146950 $D=0
M45 VSS 11 DataIn VSS N L=3.5e-07 W=9e-06 $X=81000 $Y=146950 $D=0
M46 DataIn 11 VSS VSS N L=3.5e-07 W=9e-06 $X=83400 $Y=146950 $D=0
M47 VSS 11 DataIn VSS N L=3.5e-07 W=9e-06 $X=85800 $Y=146950 $D=0
M48 VDD VSS 6 VDD P L=3.5e-07 W=1.56e-05 $X=5700 $Y=165550 $D=16
M49 7 6 VDD VDD P L=3.5e-07 W=1.56e-05 $X=8100 $Y=165550 $D=16
M50 VDD VSS 8 VDD P L=3.5e-07 W=1.56e-05 $X=13200 $Y=165550 $D=16
M51 8 VSS VDD VDD P L=3.5e-07 W=1.56e-05 $X=15600 $Y=165550 $D=16
M52 pad 8 VDD VDD P L=3.5e-07 W=2e-05 $X=15795 $Y=97085 $D=16
M53 VDD 8 pad VDD P L=3.5e-07 W=2e-05 $X=15795 $Y=101995 $D=16
M54 pad 8 VDD VDD P L=3.5e-07 W=2e-05 $X=15795 $Y=103565 $D=16
M55 VDD 8 pad VDD P L=3.5e-07 W=2e-05 $X=15795 $Y=108475 $D=16
M56 pad 8 VDD VDD P L=3.5e-07 W=2e-05 $X=15795 $Y=110045 $D=16
M57 VDD 8 pad VDD P L=3.5e-07 W=2e-05 $X=15795 $Y=114955 $D=16
M58 pad 8 VDD VDD P L=3.5e-07 W=2e-05 $X=15795 $Y=116525 $D=16
M59 VDD 8 pad VDD P L=3.5e-07 W=2e-05 $X=15795 $Y=121435 $D=16
M60 pad 8 VDD VDD P L=3.5e-07 W=2e-05 $X=15795 $Y=123005 $D=16
M61 VDD 8 pad VDD P L=3.5e-07 W=2e-05 $X=15795 $Y=127915 $D=16
M62 VDD VSS 8 VDD P L=3.5e-07 W=1.56e-05 $X=18000 $Y=165550 $D=16
M63 8 VSS VDD VDD P L=3.5e-07 W=1.56e-05 $X=20400 $Y=165550 $D=16
M64 VDD VSS 8 VDD P L=3.5e-07 W=1.56e-05 $X=22800 $Y=165550 $D=16
M65 8 7 VDD VDD P L=3.5e-07 W=1.56e-05 $X=25200 $Y=165550 $D=16
M66 VDD 7 8 VDD P L=3.5e-07 W=1.56e-05 $X=27600 $Y=165550 $D=16
M67 8 7 VDD VDD P L=3.5e-07 W=1.56e-05 $X=30000 $Y=165550 $D=16
M68 VDD 7 8 VDD P L=3.5e-07 W=1.56e-05 $X=32400 $Y=165550 $D=16
M69 8 7 VDD VDD P L=3.5e-07 W=1.56e-05 $X=34800 $Y=165550 $D=16
M70 9 6 8 VDD P L=3.5e-07 W=1.56e-05 $X=37200 $Y=165550 $D=16
M71 8 6 9 VDD P L=3.5e-07 W=1.56e-05 $X=39600 $Y=165550 $D=16
M72 9 6 8 VDD P L=3.5e-07 W=1.56e-05 $X=42000 $Y=165550 $D=16
M73 8 6 9 VDD P L=3.5e-07 W=1.56e-05 $X=44400 $Y=165550 $D=16
M74 pad 8 VDD VDD P L=3.5e-07 W=2e-05 $X=53330 $Y=97085 $D=16
M75 VDD 8 pad VDD P L=3.5e-07 W=2e-05 $X=53330 $Y=101995 $D=16
M76 pad 8 VDD VDD P L=3.5e-07 W=2e-05 $X=53330 $Y=103565 $D=16
M77 VDD 8 pad VDD P L=3.5e-07 W=2e-05 $X=53330 $Y=108475 $D=16
M78 pad 8 VDD VDD P L=3.5e-07 W=2e-05 $X=53330 $Y=110045 $D=16
M79 VDD 8 pad VDD P L=3.5e-07 W=2e-05 $X=53330 $Y=114955 $D=16
M80 pad 8 VDD VDD P L=3.5e-07 W=2e-05 $X=53330 $Y=116525 $D=16
M81 VDD 8 pad VDD P L=3.5e-07 W=2e-05 $X=53330 $Y=121435 $D=16
M82 pad 8 VDD VDD P L=3.5e-07 W=2e-05 $X=53330 $Y=123005 $D=16
M83 VDD 8 pad VDD P L=3.5e-07 W=2e-05 $X=53330 $Y=127915 $D=16
M84 11 pad VDD VDD P L=3.5e-07 W=1.56e-05 $X=59400 $Y=165550 $D=16
M85 VDD pad 11 VDD P L=3.5e-07 W=1.56e-05 $X=61800 $Y=165550 $D=16
M86 11 pad VDD VDD P L=3.5e-07 W=1.56e-05 $X=64200 $Y=165550 $D=16
M87 VDD pad 11 VDD P L=3.5e-07 W=1.56e-05 $X=66600 $Y=165550 $D=16
M88 11 pad VDD VDD P L=3.5e-07 W=1.56e-05 $X=69000 $Y=165550 $D=16
M89 VDD pad 11 VDD P L=3.5e-07 W=1.56e-05 $X=71400 $Y=165550 $D=16
M90 DataIn 11 VDD VDD P L=3.5e-07 W=1.56e-05 $X=73800 $Y=165550 $D=16
M91 VDD 11 DataIn VDD P L=3.5e-07 W=1.56e-05 $X=76200 $Y=165550 $D=16
M92 DataIn 11 VDD VDD P L=3.5e-07 W=1.56e-05 $X=78600 $Y=165550 $D=16
M93 VDD 11 DataIn VDD P L=3.5e-07 W=1.56e-05 $X=81000 $Y=165550 $D=16
M94 DataIn 11 VDD VDD P L=3.5e-07 W=1.56e-05 $X=83400 $Y=165550 $D=16
M95 VDD 11 DataIn VDD P L=3.5e-07 W=1.56e-05 $X=85800 $Y=165550 $D=16
.ENDS
***************************************
.SUBCKT ICV_39
** N=7 EP=0 IP=10 FDC=0
.ENDS
***************************************
.SUBCKT ICV_90
** N=4 EP=0 IP=8 FDC=0
.ENDS
***************************************
.SUBCKT ICV_92
** N=4 EP=0 IP=8 FDC=0
.ENDS
***************************************
.SUBCKT ICV_106
** N=4 EP=0 IP=8 FDC=0
.ENDS
***************************************
.SUBCKT ICV_77 1 2 3 4 5
** N=7 EP=5 IP=11 FDC=4
X1 1 2 3 4 5 ICV_76 $T=2240 0 0 0 $X=1810 $Y=-390
.ENDS
***************************************
.SUBCKT ICV_88
** N=4 EP=0 IP=8 FDC=0
.ENDS
***************************************
.SUBCKT ICV_75
** N=4 EP=0 IP=8 FDC=0
.ENDS
***************************************
.SUBCKT ICV_91
** N=4 EP=0 IP=8 FDC=0
.ENDS
***************************************
.SUBCKT ICV_112 1 2 3 4 5 6 7 8
** N=10 EP=8 IP=14 FDC=8
X0 2 3 1 5 4 NAND2X1 $T=0 0 0 0 $X=-430 $Y=-390
X1 6 7 1 5 8 NAND2X1 $T=5600 0 1 180 $X=2370 $Y=-390
.ENDS
***************************************
.SUBCKT XOR2X1 B A VDD VSS Z
** N=11 EP=5 IP=0 FDC=10
M0 VSS B 10 VSS N L=1.8e-07 W=4.4e-07 $X=630 $Y=985 $D=0
M1 8 A VSS VSS N L=1.8e-07 W=4.4e-07 $X=1350 $Y=985 $D=0
M2 9 8 10 VSS N L=1.8e-07 W=4.4e-07 $X=3205 $Y=1000 $D=0
M3 B A 9 VSS N L=1.8e-07 W=4.4e-07 $X=3925 $Y=1000 $D=0
M4 Z 9 VSS VSS N L=1.8e-07 W=4.4e-07 $X=5345 $Y=1000 $D=0
M5 VDD B 10 VDD P L=1.8e-07 W=4.4e-07 $X=630 $Y=2435 $D=16
M6 8 A VDD VDD P L=1.8e-07 W=4.4e-07 $X=1350 $Y=2435 $D=16
M7 9 A 10 VDD P L=1.8e-07 W=4.4e-07 $X=3205 $Y=2435 $D=16
M8 B 8 9 VDD P L=1.8e-07 W=4.4e-07 $X=3925 $Y=2435 $D=16
M9 Z 9 VDD VDD P L=1.8e-07 W=4.4e-07 $X=5345 $Y=2435 $D=16
.ENDS
***************************************
.SUBCKT ICV_96 1 2 3 4 5
** N=7 EP=5 IP=11 FDC=4
X1 3 4 1 2 5 NAND2X1 $T=0 0 0 0 $X=-430 $Y=-390
.ENDS
***************************************
.SUBCKT ICV_94 1 2 3 4 5
** N=7 EP=5 IP=11 FDC=4
X1 1 2 3 4 5 ICV_72 $T=1680 0 0 0 $X=1250 $Y=-390
.ENDS
***************************************
.SUBCKT ICV_101 1 2 3 4 5
** N=7 EP=5 IP=11 FDC=4
X1 3 4 1 2 5 NAND2X1 $T=5040 0 1 180 $X=1810 $Y=-390
.ENDS
***************************************
.SUBCKT ICV_58
** N=4 EP=0 IP=8 FDC=0
.ENDS
***************************************
.SUBCKT ICV_79 1 2 3 4 5
** N=7 EP=5 IP=11 FDC=4
X1 3 4 1 2 5 NAND2X1 $T=0 0 0 0 $X=-430 $Y=-390
.ENDS
***************************************
.SUBCKT ICV_109 1 2 3 4 5
** N=7 EP=5 IP=11 FDC=4
X1 3 4 1 2 5 NAND2X1 $T=0 0 0 0 $X=-430 $Y=-390
.ENDS
***************************************
.SUBCKT ICV_105 1 2 3 4 5
** N=7 EP=5 IP=11 FDC=4
X1 3 4 1 2 5 NAND2X1 $T=6160 0 1 180 $X=2930 $Y=-390
.ENDS
***************************************
.SUBCKT ICV_95
** N=4 EP=0 IP=8 FDC=0
.ENDS
***************************************
.SUBCKT ICV_111 1 2 3 4 5 6
** N=8 EP=6 IP=13 FDC=40
X1 4 6 2 5 1 2 3 DFFQSRX1 $T=0 0 0 0 $X=-430 $Y=-390
.ENDS
***************************************
.SUBCKT ICV_113 1 2 3 4 5 6
** N=8 EP=6 IP=13 FDC=40
X1 4 6 2 5 1 2 3 DFFQSRX1 $T=0 0 0 0 $X=-430 $Y=-390
.ENDS
***************************************
.SUBCKT ICV_54
** N=4 EP=0 IP=8 FDC=0
.ENDS
***************************************
.SUBCKT ICV_56
** N=4 EP=0 IP=8 FDC=0
.ENDS
***************************************
.SUBCKT ICV_89
** N=4 EP=0 IP=8 FDC=0
.ENDS
***************************************
.SUBCKT ICV_104
** N=4 EP=0 IP=8 FDC=0
.ENDS
***************************************
.SUBCKT ICV_97 1 2 3 4 5 6
** N=8 EP=6 IP=12 FDC=6
X1 3 4 6 1 2 5 NAND3X1 $T=560 0 0 0 $X=130 $Y=-390
.ENDS
***************************************
.SUBCKT ICV_99 1 2 3 4 5
** N=7 EP=5 IP=11 FDC=4
X1 3 4 1 2 5 NAND2X1 $T=3360 0 0 0 $X=2930 $Y=-390
.ENDS
***************************************
.SUBCKT ICV_100 1 2 3 4 5 6
** N=8 EP=6 IP=12 FDC=6
X1 3 4 6 1 2 5 NAND3X1 $T=2240 0 0 0 $X=1810 $Y=-390
.ENDS
***************************************
.SUBCKT ICV_107 1 2 3 4 5 6
** N=8 EP=6 IP=12 FDC=12
X0 4 3 5 1 2 6 MUX2X1 $T=7280 0 1 180 $X=1250 $Y=-390
.ENDS
***************************************
.SUBCKT ICV_86
** N=4 EP=0 IP=8 FDC=0
.ENDS
***************************************
.SUBCKT ICV_60
** N=4 EP=0 IP=8 FDC=0
.ENDS
***************************************
.SUBCKT ICV_87
** N=4 EP=0 IP=8 FDC=0
.ENDS
***************************************
.SUBCKT ICV_80 1 2 3 4 5 6
** N=8 EP=6 IP=13 FDC=40
X1 4 6 2 5 1 2 3 DFFQSRX1 $T=560 0 0 0 $X=130 $Y=-390
.ENDS
***************************************
.SUBCKT ICV_103 1 2 3 4 5
** N=7 EP=5 IP=11 FDC=4
X1 3 4 1 2 5 NAND2X1 $T=0 0 0 0 $X=-430 $Y=-390
.ENDS
***************************************
.SUBCKT ICV_71 1 2 3 4 5
** N=7 EP=5 IP=11 FDC=4
X1 3 4 1 2 5 NAND2X1 $T=3920 0 1 180 $X=690 $Y=-390
.ENDS
***************************************
.SUBCKT ICV_73 1 2 3 4 5 6
** N=8 EP=6 IP=13 FDC=40
X0 4 6 2 5 1 2 3 DFFQSRX1 $T=1680 0 0 0 $X=1250 $Y=-390
.ENDS
***************************************
.SUBCKT ICV_108 1 2 3 4 5 6 7 8
** N=10 EP=8 IP=14 FDC=8
X0 2 3 1 5 4 NAND2X1 $T=0 0 0 0 $X=-430 $Y=-390
X1 6 7 1 5 8 NAND2X1 $T=2800 0 0 0 $X=2370 $Y=-390
.ENDS
***************************************
.SUBCKT ICV_93 1 2 3 4 5
** N=7 EP=5 IP=11 FDC=4
X1 3 4 1 2 5 NOR2X1 $T=1680 0 0 0 $X=1250 $Y=-390
.ENDS
***************************************
.SUBCKT ICV_102 1 2 3 4 5 6 7 8
** N=10 EP=8 IP=14 FDC=8
X0 2 3 1 5 4 NAND2X1 $T=-2800 0 0 0 $X=-3230 $Y=-390
X1 6 7 1 5 8 NAND2X1 $T=0 0 0 0 $X=-430 $Y=-390
.ENDS
***************************************
.SUBCKT ICV_98 1 2 3 4 5 6
** N=8 EP=6 IP=12 FDC=6
X1 3 4 6 1 2 5 NAND3X1 $T=5600 0 1 180 $X=1250 $Y=-390
.ENDS
***************************************
.SUBCKT ICV_82 1 2 3 4 5
** N=7 EP=5 IP=11 FDC=4
X1 3 4 1 2 5 NAND2X1 $T=0 0 0 0 $X=-430 $Y=-390
.ENDS
***************************************
.SUBCKT ICV_110 1 2 3 4 5 6
** N=8 EP=6 IP=12 FDC=12
X0 4 3 5 1 2 6 MUX2X1 $T=1680 0 0 0 $X=1250 $Y=-390
.ENDS
***************************************
.SUBCKT ANTENNA VSS A
** N=5 EP=2 IP=0 FDC=1
*.CALIBRE ISOLATED NETS: VDD
D0 VSS A DN AREA=3.9e-13 PJ=2.54e-06 $X=300 $Y=655 $D=26
.ENDS
***************************************
.SUBCKT INVX4 A VSS VDD Z
** N=6 EP=4 IP=0 FDC=4
M0 Z A VSS VSS N L=1.8e-07 W=4.4e-07 $X=670 $Y=760 $D=0
M1 VSS A Z VSS N L=1.8e-07 W=4.4e-07 $X=1390 $Y=760 $D=0
M2 Z A VDD VDD P L=1.8e-07 W=8.8e-07 $X=670 $Y=2300 $D=16
M3 VDD A Z VDD P L=1.8e-07 W=8.8e-07 $X=1390 $Y=2300 $D=16
.ENDS
***************************************
.SUBCKT ICV_67
** N=4 EP=0 IP=8 FDC=0
.ENDS
***************************************
.SUBCKT ICV_114 44 73 74 75 76 77 78 79 80 81 82 83 84 85 86 87 88 89 90 91
+ 92 93 94 95 96 97 98 99 100 101 102 103 104 105 106 107 108 109 110 111
+ 112 113 114 115 116 117 118 119 120 121 122 123 124 125 126 127 128 129 130 131
+ 132 133 134 135 136 137 138 139 140 141 142 143 144 145 146 147 148 149 150 151
+ 152 153 154 155 156 157 158 159 160 161 162 163 164 165 166 167 168 169 170 171
+ 172 173 174 175 176 177 178 179 180 181 182 183 184 185 186 187 188 189 190 191
+ 192 193 194 195 196 197 198 199 200 201 202 203 204 205 206 207 208 209 210 211
+ 212 213 214 215 216 217 218 219 220 221 222 223 224 225 226 227 228 229 230 231
+ 232 233 234 235 236 237 238 239 240 241 242 243 244 245 246 247 248 249 250 251
+ 252 253 254 255 256 257 258 259 260 261 262 263 264 265 266 267 268 269 270 271
+ 272 273 274 275 276 277 278 279 280 281 282 283 284 285 286 287 288 289 290 291
+ 292 293 294 295 296 297 298 299 300 301 302 303 304 305 306 307 308 309 310 311
+ 312 313 314 315 316 317 318 319 320 321 322 323 324 325 326 327 328 329 330 331
+ 332 333 334 335 336 337 338 339 340 341 342 343 344 345 346 347 348 349 350 351
+ 352 353 354 355 356 357 358 359 360 361 362 363 364 365 366 367 368 369 370 371
+ 372 373 374 375 376 377 378 379 380 381 382 383 384 385 386 387 388 389 390 391
+ 392 393 394 395 396 397 398 399 400 401 402 403 404 405 406 407 408 409 410 411
+ 412 413 414 415 416 417 418 419 420 421 422 423 424 425 426 427 428 429 430 431
+ 432 433 434 435 436 437 438 439 440 441 442 443 444 445 446 447 448 449 450 451
+ 452 453 454 455 456 457 458 459 460 461 462 463 464 465 466 467 468 469 470 471
+ 472 473 474 475 476 477 478 479 480 481 482 483 484 485 486 487 488 489 490 491
+ 492 493 494 495 496 497 498 499 500 501 502 503 504 505 577 578 579 580 584 585
+ 587 588 589
** N=196155 EP=443 IP=26688 FDC=24292
X759 25845 26479 73 578 44 73 25824 DFFQSRX1 $T=723120 538125 1 0 $X=722690 $Y=533570
X760 53801 26479 578 73 44 73 25826 DFFQSRX1 $T=723120 545965 0 0 $X=722690 $Y=545575
X761 25867 577 73 578 44 73 25827 DFFQSRX1 $T=723120 694925 1 0 $X=722690 $Y=690370
X762 25846 577 73 578 44 73 74 DFFQSRX1 $T=748320 710605 1 180 $X=722690 $Y=710215
X763 25995 577 73 578 44 73 75 DFFQSRX1 $T=748320 718445 1 180 $X=722690 $Y=718055
X764 25826 26479 578 73 44 73 25418 DFFQSRX1 $T=760640 561645 1 180 $X=735010 $Y=561255
X765 25900 26479 73 578 44 73 25476 DFFQSRX1 $T=762320 569485 0 180 $X=736690 $Y=564930
X766 26256 27181 73 578 44 73 25477 DFFQSRX1 $T=762320 671405 0 180 $X=736690 $Y=666850
X767 26122 27181 73 578 44 73 25547 DFFQSRX1 $T=764560 663565 1 180 $X=738930 $Y=663175
X768 26282 26479 73 578 44 73 26348 DFFQSRX1 $T=753920 545965 1 0 $X=753490 $Y=541410
X769 26283 26479 73 578 44 73 26337 DFFQSRX1 $T=753920 561645 1 0 $X=753490 $Y=557090
X770 26269 26479 73 578 44 73 26293 DFFQSRX1 $T=753920 593005 1 0 $X=753490 $Y=588450
X771 26215 26479 73 578 44 73 26217 DFFQSRX1 $T=753920 600845 0 0 $X=753490 $Y=600455
X772 26305 102 73 578 44 73 26389 DFFQSRX1 $T=756160 514605 1 0 $X=755730 $Y=510050
X773 26349 27324 73 578 44 73 26467 DFFQSRX1 $T=757280 655725 0 0 $X=756850 $Y=655335
X774 26444 27324 73 578 44 73 26485 DFFQSRX1 $T=758960 624365 1 0 $X=758530 $Y=619810
X775 26464 27324 73 578 44 73 26206 DFFQSRX1 $T=758960 632205 0 0 $X=758530 $Y=631815
X776 26411 27181 73 578 44 73 26339 DFFQSRX1 $T=759520 710605 1 0 $X=759090 $Y=706050
X777 26442 102 73 578 44 73 26230 DFFQSRX1 $T=786400 506765 0 180 $X=760770 $Y=502210
X778 26338 27181 73 578 44 73 97 DFFQSRX1 $T=762320 671405 1 0 $X=761890 $Y=666850
X779 26760 579 73 578 44 73 94 DFFQSRX1 $T=792000 726285 1 180 $X=766370 $Y=725895
X780 26562 26479 73 578 44 73 26581 DFFQSRX1 $T=767360 553805 0 0 $X=766930 $Y=553415
X781 26604 27181 73 578 44 73 26362 DFFQSRX1 $T=792560 679245 1 180 $X=766930 $Y=678855
X782 26616 26479 73 578 44 73 26618 DFFQSRX1 $T=770720 569485 1 0 $X=770290 $Y=564930
X783 26617 27616 73 578 44 73 26640 DFFQSRX1 $T=771280 585165 0 0 $X=770850 $Y=584775
X784 26672 27616 73 578 44 73 26649 DFFQSRX1 $T=771840 593005 0 0 $X=771410 $Y=592615
X785 26725 27646 73 578 44 73 26453 DFFQSRX1 $T=800960 538125 1 180 $X=775330 $Y=537735
X786 26859 27181 73 578 44 73 100 DFFQSRX1 $T=803200 702765 0 180 $X=777570 $Y=698210
X787 26882 27181 73 578 44 73 101 DFFQSRX1 $T=803760 710605 1 180 $X=778130 $Y=710215
X788 26625 27181 73 578 44 73 26327 DFFQSRX1 $T=803760 718445 1 180 $X=778130 $Y=718055
X789 26902 102 73 578 44 73 26807 DFFQSRX1 $T=779120 491085 0 0 $X=778690 $Y=490695
X790 26762 102 73 578 44 73 26771 DFFQSRX1 $T=779120 506765 0 0 $X=778690 $Y=506375
X791 26759 27324 73 578 44 73 26791 DFFQSRX1 $T=780240 663565 1 0 $X=779810 $Y=659010
X792 26715 27324 73 578 44 73 26554 DFFQSRX1 $T=780800 647885 1 0 $X=780370 $Y=643330
X793 26926 27181 73 578 44 73 26608 DFFQSRX1 $T=806560 671405 1 180 $X=780930 $Y=671015
X794 26925 27324 73 578 44 73 26839 DFFQSRX1 $T=781920 632205 1 0 $X=781490 $Y=627650
X795 26937 27324 73 578 44 73 107 DFFQSRX1 $T=784160 624365 1 0 $X=783730 $Y=619810
X796 26831 27616 73 578 44 73 26999 DFFQSRX1 $T=784720 577325 1 0 $X=784290 $Y=572770
X797 26860 27616 73 578 44 73 26975 DFFQSRX1 $T=784720 593005 1 0 $X=784290 $Y=588450
X798 26947 27616 73 578 44 73 26973 DFFQSRX1 $T=786960 600845 0 0 $X=786530 $Y=600455
X799 27068 27646 73 578 44 73 27054 DFFQSRX1 $T=787520 530285 0 0 $X=787090 $Y=529895
X800 26972 27646 73 578 44 73 26948 DFFQSRX1 $T=788080 545965 0 0 $X=787650 $Y=545575
X801 27282 27646 73 578 44 73 26990 DFFQSRX1 $T=794800 506765 1 0 $X=794370 $Y=502210
X802 27082 27646 73 578 44 73 26867 DFFQSRX1 $T=794800 514605 0 0 $X=794370 $Y=514215
X803 27171 27616 73 578 44 73 27041 DFFQSRX1 $T=796480 569485 0 0 $X=796050 $Y=569095
X804 27408 27616 73 578 44 73 27507 DFFQSRX1 $T=804880 585165 0 0 $X=804450 $Y=584775
X805 27420 27646 73 578 44 73 115 DFFQSRX1 $T=805440 498925 0 0 $X=805010 $Y=498535
X806 27508 27181 73 578 44 73 118 DFFQSRX1 $T=806000 679245 0 0 $X=805570 $Y=678855
X807 27544 27324 73 578 44 73 125 DFFQSRX1 $T=808240 663565 0 0 $X=807810 $Y=663175
X808 27522 27324 73 578 44 73 27424 DFFQSRX1 $T=809360 624365 1 0 $X=808930 $Y=619810
X809 27528 27616 73 578 44 73 27658 DFFQSRX1 $T=813280 577325 1 0 $X=812850 $Y=572770
X810 27671 29140 73 578 44 73 27043 DFFQSRX1 $T=839040 647885 0 180 $X=813410 $Y=643330
X811 27668 27646 73 578 44 73 27761 DFFQSRX1 $T=815520 514605 1 0 $X=815090 $Y=510050
X812 27465 27646 73 578 44 73 27553 DFFQSRX1 $T=815520 530285 1 0 $X=815090 $Y=525730
X813 27916 27646 73 578 44 73 27986 DFFQSRX1 $T=824480 538125 0 0 $X=824050 $Y=537735
X814 27955 27646 73 578 44 73 28032 DFFQSRX1 $T=826160 553805 1 0 $X=825730 $Y=549250
X815 27479 27646 73 578 44 73 27607 DFFQSRX1 $T=827280 545965 1 0 $X=826850 $Y=541410
X816 28034 27616 73 578 44 73 28124 DFFQSRX1 $T=831200 561645 1 0 $X=830770 $Y=557090
X817 28127 28697 73 578 44 73 26903 DFFQSRX1 $T=856960 585165 0 180 $X=831330 $Y=580610
X818 28213 129 73 578 44 73 144 DFFQSRX1 $T=834000 491085 1 0 $X=833570 $Y=486530
X819 28031 129 73 578 44 73 28122 DFFQSRX1 $T=834000 491085 0 0 $X=833570 $Y=490695
X820 28230 129 73 578 44 73 28317 DFFQSRX1 $T=834000 506765 1 0 $X=833570 $Y=502210
X821 28267 129 73 578 44 73 28353 DFFQSRX1 $T=834000 522445 0 0 $X=833570 $Y=522055
X822 28104 29140 73 578 44 73 28200 DFFQSRX1 $T=834000 593005 0 0 $X=833570 $Y=592615
X823 28105 29140 73 578 44 73 27763 DFFQSRX1 $T=834000 600845 0 0 $X=833570 $Y=600455
X824 28421 29140 73 578 44 73 27713 DFFQSRX1 $T=859200 608685 1 180 $X=833570 $Y=608295
X825 28243 29140 73 578 44 73 28330 DFFQSRX1 $T=834000 616525 0 0 $X=833570 $Y=616135
X826 28378 29140 73 578 44 73 27901 DFFQSRX1 $T=859200 624365 1 180 $X=833570 $Y=623975
X827 28339 29114 73 578 44 73 27902 DFFQSRX1 $T=859200 640045 1 180 $X=833570 $Y=639655
X828 28106 29140 73 578 44 73 28136 DFFQSRX1 $T=834000 671405 1 0 $X=833570 $Y=666850
X829 28625 28697 73 578 44 73 28767 DFFQSRX1 $T=861440 553805 1 0 $X=861010 $Y=549250
X830 28678 28697 73 578 44 73 28826 DFFQSRX1 $T=864800 577325 1 0 $X=864370 $Y=572770
X831 28802 29114 73 578 44 73 28768 DFFQSRX1 $T=864800 640045 0 0 $X=864370 $Y=639655
X832 29185 28697 73 578 44 73 29293 DFFQSRX1 $T=870960 585165 1 0 $X=870530 $Y=580610
X833 28726 28697 73 578 44 73 28725 DFFQSRX1 $T=872080 585165 0 0 $X=871650 $Y=584775
X834 29249 28697 73 578 44 73 29347 DFFQSRX1 $T=872080 608685 1 0 $X=871650 $Y=604130
X835 29294 29114 73 578 44 73 29319 DFFQSRX1 $T=874880 671405 0 0 $X=874450 $Y=671015
X836 29372 29114 73 578 44 73 29466 DFFQSRX1 $T=877680 647885 1 0 $X=877250 $Y=643330
X837 29478 29114 73 578 44 73 29455 DFFQSRX1 $T=877680 655725 1 0 $X=877250 $Y=651170
X838 29373 29114 73 578 44 73 29002 DFFQSRX1 $T=904000 687085 0 180 $X=878370 $Y=682530
X839 29436 29114 73 578 44 73 157 DFFQSRX1 $T=879360 702765 1 0 $X=878930 $Y=698210
X840 29572 29114 73 578 44 73 29602 DFFQSRX1 $T=881040 687085 0 0 $X=880610 $Y=686695
X841 29561 29114 73 578 44 73 29589 DFFQSRX1 $T=884400 663565 1 0 $X=883970 $Y=659010
X842 29645 29114 73 578 44 73 29790 DFFQSRX1 $T=886080 640045 1 0 $X=885650 $Y=635490
X843 29843 30451 73 578 44 73 28572 DFFQSRX1 $T=919120 616525 0 180 $X=893490 $Y=611970
X844 29775 28697 73 578 44 73 29858 DFFQSRX1 $T=894480 608685 0 0 $X=894050 $Y=608295
X845 29860 580 73 578 44 73 29879 DFFQSRX1 $T=898400 710605 1 0 $X=897970 $Y=706050
X846 30143 30451 73 578 44 73 29658 DFFQSRX1 $T=929760 632205 0 180 $X=904130 $Y=627650
X847 30144 30451 73 578 44 73 29678 DFFQSRX1 $T=930320 647885 0 180 $X=904690 $Y=643330
X848 30082 29114 73 578 44 73 30098 DFFQSRX1 $T=905120 655725 0 0 $X=904690 $Y=655335
X849 30165 30451 73 578 44 73 29821 DFFQSRX1 $T=931440 679245 0 180 $X=905810 $Y=674690
X850 30049 580 73 578 44 73 30060 DFFQSRX1 $T=906240 694925 1 0 $X=905810 $Y=690370
X851 30267 30451 73 578 44 73 29844 DFFQSRX1 $T=932560 687085 1 180 $X=906930 $Y=686695
X852 30209 580 73 578 44 73 30190 DFFQSRX1 $T=912960 702765 0 0 $X=912530 $Y=702375
X853 30095 30451 73 578 44 73 30181 DFFQSRX1 $T=915760 600845 1 0 $X=915330 $Y=596290
X854 30142 30451 73 578 44 73 29824 DFFQSRX1 $T=915760 624365 1 0 $X=915330 $Y=619810
X855 30365 30451 73 578 44 73 30126 DFFQSRX1 $T=944880 608685 1 180 $X=919250 $Y=608295
X856 30567 30451 73 578 44 73 30128 DFFQSRX1 $T=950480 640045 1 180 $X=924850 $Y=639655
X857 30431 30451 73 578 44 73 30314 DFFQSRX1 $T=925840 647885 0 0 $X=925410 $Y=647495
X858 30499 30451 73 578 44 73 30581 DFFQSRX1 $T=927520 608685 1 0 $X=927090 $Y=604130
X859 30658 30451 73 578 44 73 30189 DFFQSRX1 $T=934800 663565 1 0 $X=934370 $Y=659010
X860 30608 30451 73 578 44 73 30553 DFFQSRX1 $T=934800 687085 1 0 $X=934370 $Y=682530
X861 30779 307 73 578 44 73 30289 DFFQSRX1 $T=960000 694925 0 180 $X=934370 $Y=690370
X862 30819 307 73 578 44 73 30234 DFFQSRX1 $T=960560 671405 1 180 $X=934930 $Y=671015
X863 31437 33621 73 578 44 73 31556 DFFQSRX1 $T=976240 593005 0 0 $X=975810 $Y=592615
X864 32370 307 73 578 44 73 31030 DFFQSRX1 $T=976240 679245 0 0 $X=975810 $Y=678855
X865 32154 307 73 578 44 73 32284 DFFQSRX1 $T=986880 694925 1 0 $X=986450 $Y=690370
X866 32385 33621 73 578 44 73 32499 DFFQSRX1 $T=994720 608685 1 0 $X=994290 $Y=604130
X867 32680 33621 73 578 44 73 32794 DFFQSRX1 $T=1001440 616525 1 0 $X=1001010 $Y=611970
X868 32661 307 73 578 44 73 32712 DFFQSRX1 $T=1003680 702765 0 0 $X=1003250 $Y=702375
X869 32829 358 73 578 44 73 348 DFFQSRX1 $T=1028880 726285 1 180 $X=1003250 $Y=725895
X870 32697 307 73 578 44 73 366 DFFQSRX1 $T=1004240 718445 0 0 $X=1003810 $Y=718055
X871 33292 358 73 578 44 73 32630 DFFQSRX1 $T=1045120 702765 0 180 $X=1019490 $Y=698210
X872 33402 33621 73 578 44 73 33061 DFFQSRX1 $T=1051840 616525 0 180 $X=1026210 $Y=611970
X873 33302 358 73 578 44 73 378 DFFQSRX1 $T=1051840 718445 0 180 $X=1026210 $Y=713890
X874 33401 33621 73 578 44 73 33075 DFFQSRX1 $T=1052400 600845 1 180 $X=1026770 $Y=600455
X875 33290 358 73 578 44 73 396 DFFQSRX1 $T=1027200 726285 1 0 $X=1026770 $Y=721730
X876 33547 358 73 578 44 73 387 DFFQSRX1 $T=1059120 702765 1 180 $X=1033490 $Y=702375
X877 33600 33621 73 578 44 73 33272 DFFQSRX1 $T=1060800 600845 0 180 $X=1035170 $Y=596290
X878 33556 33621 73 578 44 73 33273 DFFQSRX1 $T=1060800 608685 1 180 $X=1035170 $Y=608295
X879 33684 358 73 578 44 73 420 DFFQSRX1 $T=1047360 710605 1 0 $X=1046930 $Y=706050
X880 33661 358 73 578 44 73 403 DFFQSRX1 $T=1072560 718445 1 180 $X=1046930 $Y=718055
X881 584 358 73 578 44 73 270 DFFQSRX1 $T=1072560 726285 1 180 $X=1046930 $Y=725895
X882 33976 35821 73 578 44 73 33536 DFFQSRX1 $T=1081520 600845 1 180 $X=1055890 $Y=600455
X883 34333 35821 73 578 44 73 30414 DFFQSRX1 $T=1081520 608685 0 180 $X=1055890 $Y=604130
X884 34000 448 73 578 44 73 33376 DFFQSRX1 $T=1081520 687085 1 180 $X=1055890 $Y=686695
X885 33956 448 73 578 44 73 33465 DFFQSRX1 $T=1081520 702765 0 180 $X=1055890 $Y=698210
X886 34131 448 73 578 44 73 414 DFFQSRX1 $T=1081520 710605 1 180 $X=1055890 $Y=710215
X887 34268 448 73 578 44 73 415 DFFQSRX1 $T=1081520 718445 0 180 $X=1055890 $Y=713890
X888 34382 448 73 578 44 73 33955 DFFQSRX1 $T=1097760 663565 1 180 $X=1072130 $Y=663175
X889 34427 448 73 578 44 73 33577 DFFQSRX1 $T=1097760 671405 0 180 $X=1072130 $Y=666850
X890 34685 35821 73 578 44 73 33914 DFFQSRX1 $T=1087120 616525 0 0 $X=1086690 $Y=616135
X891 34746 448 73 578 44 73 34231 DFFQSRX1 $T=1087120 710605 1 0 $X=1086690 $Y=706050
X892 35419 35821 73 578 44 73 35418 DFFQSRX1 $T=1106160 632205 1 0 $X=1105730 $Y=627650
X893 35342 35821 73 578 44 73 34807 DFFQSRX1 $T=1131920 624365 1 180 $X=1106290 $Y=623975
X894 35359 35561 73 578 44 73 34947 DFFQSRX1 $T=1131920 671405 1 180 $X=1106290 $Y=671015
X895 35329 35821 73 578 44 73 34460 DFFQSRX1 $T=1133040 608685 1 180 $X=1107410 $Y=608295
X896 585 448 73 578 44 73 457 DFFQSRX1 $T=1109520 718445 0 0 $X=1109090 $Y=718055
X897 35461 36394 73 578 44 73 29788 DFFQSRX1 $T=1135280 585165 1 180 $X=1109650 $Y=584775
X898 35460 36394 73 578 44 73 33118 DFFQSRX1 $T=1135840 569485 1 180 $X=1110210 $Y=569095
X899 35358 35561 73 578 44 73 35388 DFFQSRX1 $T=1111200 655725 0 0 $X=1110770 $Y=655335
X900 35631 36394 73 578 44 73 33315 DFFQSRX1 $T=1141440 577325 1 180 $X=1115810 $Y=576935
X901 35787 466 73 578 44 73 33242 DFFQSRX1 $T=1148720 553805 1 180 $X=1123090 $Y=553415
X902 35811 466 73 578 44 73 34684 DFFQSRX1 $T=1150400 545965 0 180 $X=1124770 $Y=541410
X903 35827 466 73 578 44 73 33415 DFFQSRX1 $T=1150960 538125 0 180 $X=1125330 $Y=533570
X904 35837 466 73 578 44 73 30607 DFFQSRX1 $T=1151520 530285 0 180 $X=1125890 $Y=525730
X905 35848 466 73 578 44 73 34639 DFFQSRX1 $T=1152080 514605 0 180 $X=1126450 $Y=510050
X906 35849 466 73 578 44 73 30415 DFFQSRX1 $T=1152080 514605 1 180 $X=1126450 $Y=514215
X907 35964 36394 73 578 44 73 35431 DFFQSRX1 $T=1152080 593005 0 180 $X=1126450 $Y=588450
X908 36269 466 73 578 44 73 262 DFFQSRX1 $T=1152640 491085 1 180 $X=1127010 $Y=490695
X909 35861 466 73 578 44 73 250 DFFQSRX1 $T=1152640 498925 1 180 $X=1127010 $Y=498535
X910 35748 468 73 578 44 73 341 DFFQSRX1 $T=1152640 710605 0 180 $X=1127010 $Y=706050
X911 587 466 73 578 44 73 175 DFFQSRX1 $T=1153760 491085 0 180 $X=1128130 $Y=486530
X912 35953 36394 73 578 44 73 35613 DFFQSRX1 $T=1157680 616525 1 180 $X=1132050 $Y=616135
X913 35661 35821 73 578 44 73 35751 DFFQSRX1 $T=1133040 608685 0 0 $X=1132610 $Y=608295
X914 36002 35561 73 578 44 73 35670 DFFQSRX1 $T=1159920 632205 0 180 $X=1134290 $Y=627650
X915 35913 468 73 578 44 73 469 DFFQSRX1 $T=1134720 718445 0 0 $X=1134290 $Y=718055
X916 35936 35561 73 578 44 73 35965 DFFQSRX1 $T=1138080 663565 0 0 $X=1137650 $Y=663175
X917 36174 36394 73 578 44 73 36204 DFFQSRX1 $T=1142000 577325 1 0 $X=1141570 $Y=572770
X918 36220 36394 73 578 44 73 35434 DFFQSRX1 $T=1167200 585165 1 180 $X=1141570 $Y=584775
X919 36234 35561 73 578 44 73 31802 DFFQSRX1 $T=1169440 655725 1 180 $X=1143810 $Y=655335
X920 36416 35561 73 578 44 73 30842 DFFQSRX1 $T=1171120 640045 0 180 $X=1145490 $Y=635490
X921 36260 468 73 578 44 73 464 DFFQSRX1 $T=1171120 679245 1 180 $X=1145490 $Y=678855
X922 36246 466 73 578 44 73 36270 DFFQSRX1 $T=1149840 569485 0 0 $X=1149410 $Y=569095
X923 36425 36394 73 578 44 73 35601 DFFQSRX1 $T=1175040 593005 1 180 $X=1149410 $Y=592615
X924 36460 468 73 578 44 73 36058 DFFQSRX1 $T=1177280 671405 0 180 $X=1151650 $Y=666850
X925 36307 468 73 578 44 73 473 DFFQSRX1 $T=1153200 726285 0 0 $X=1152770 $Y=725895
X926 36486 36706 73 578 44 73 36173 DFFQSRX1 $T=1181200 538125 1 180 $X=1155570 $Y=537735
X927 36465 36706 73 578 44 73 35772 DFFQSRX1 $T=1181200 545965 1 180 $X=1155570 $Y=545575
X928 36407 466 73 578 44 73 36341 DFFQSRX1 $T=1156000 561645 0 0 $X=1155570 $Y=561255
X929 36376 468 73 578 44 73 35984 DFFQSRX1 $T=1181200 687085 0 180 $X=1155570 $Y=682530
X930 36445 36706 73 578 44 73 36448 DFFQSRX1 $T=1159920 506765 1 0 $X=1159490 $Y=502210
X931 36623 36706 73 578 44 73 36598 DFFQSRX1 $T=1159920 514605 0 0 $X=1159490 $Y=514215
X932 36575 36706 73 578 44 73 36549 DFFQSRX1 $T=1160480 506765 0 0 $X=1160050 $Y=506375
X933 588 478 73 578 44 73 472 DFFQSRX1 $T=1186240 491085 0 180 $X=1160610 $Y=486530
X934 36624 36706 73 578 44 73 35826 DFFQSRX1 $T=1187920 522445 1 180 $X=1162290 $Y=522055
X935 36497 36394 73 578 44 73 36516 DFFQSRX1 $T=1162720 624365 1 0 $X=1162290 $Y=619810
X936 36951 36706 73 578 44 73 36415 DFFQSRX1 $T=1192400 530285 1 180 $X=1166770 $Y=529895
X937 36881 36706 73 578 44 73 35799 DFFQSRX1 $T=1192400 553805 0 180 $X=1166770 $Y=549250
X938 36780 36394 73 578 44 73 36839 DFFQSRX1 $T=1167200 577325 1 0 $X=1166770 $Y=572770
X939 36853 37291 73 578 44 73 35786 DFFQSRX1 $T=1192400 593005 0 180 $X=1166770 $Y=588450
X940 36882 35561 73 578 44 73 36540 DFFQSRX1 $T=1167200 632205 1 0 $X=1166770 $Y=627650
X941 36997 468 73 578 44 73 36959 DFFQSRX1 $T=1167200 687085 0 0 $X=1166770 $Y=686695
X942 36675 468 73 578 44 73 477 DFFQSRX1 $T=1167200 702765 0 0 $X=1166770 $Y=702375
X943 36538 37413 73 578 44 73 36578 DFFQSRX1 $T=1202480 671405 0 180 $X=1176850 $Y=666850
X944 37255 485 73 578 44 73 483 DFFQSRX1 $T=1198560 498925 0 0 $X=1198130 $Y=498535
X945 37375 485 73 578 44 73 35825 DFFQSRX1 $T=1198560 514605 1 0 $X=1198130 $Y=510050
X946 36831 37291 73 578 44 73 36830 DFFQSRX1 $T=1198560 600845 1 0 $X=1198130 $Y=596290
X947 37225 37413 73 578 44 73 37259 DFFQSRX1 $T=1198560 694925 1 0 $X=1198130 $Y=690370
X948 37210 37413 73 578 44 73 37243 DFFQSRX1 $T=1198560 710605 0 0 $X=1198130 $Y=710215
X949 37510 37291 73 578 44 73 29939 DFFQSRX1 $T=1199120 624365 1 0 $X=1198690 $Y=619810
X950 37702 37413 73 578 44 73 33912 DFFQSRX1 $T=1199680 640045 1 0 $X=1199250 $Y=635490
X951 37209 37413 73 578 44 73 37242 DFFQSRX1 $T=1202480 671405 1 0 $X=1202050 $Y=666850
X952 37764 37744 73 578 44 73 36274 DFFQSRX1 $T=1232720 593005 0 180 $X=1207090 $Y=588450
X953 37746 589 73 578 44 73 37465 DFFQSRX1 $T=1233280 687085 1 180 $X=1207650 $Y=686695
X954 37801 491 73 578 44 73 36333 DFFQSRX1 $T=1235520 530285 0 180 $X=1209890 $Y=525730
X955 37922 37744 73 578 44 73 489 DFFQSRX1 $T=1237200 577325 0 180 $X=1211570 $Y=572770
X956 37766 37413 73 578 44 73 37883 DFFQSRX1 $T=1212000 663565 1 0 $X=1211570 $Y=659010
X957 37831 491 73 578 44 73 35836 DFFQSRX1 $T=1237760 498925 0 180 $X=1212130 $Y=494370
X958 37855 37291 73 578 44 73 37820 DFFQSRX1 $T=1212560 600845 0 0 $X=1212130 $Y=600455
X959 37880 491 73 578 44 73 490 DFFQSRX1 $T=1238320 491085 0 180 $X=1212690 $Y=486530
X960 37797 485 73 578 44 73 37854 DFFQSRX1 $T=1214240 506765 0 0 $X=1213810 $Y=506375
X961 38170 37744 73 578 44 73 493 DFFQSRX1 $T=1244480 569485 1 180 $X=1218850 $Y=569095
X962 37936 491 73 578 44 73 38068 DFFQSRX1 $T=1223760 538125 0 0 $X=1223330 $Y=537735
X963 37908 589 73 578 44 73 37935 DFFQSRX1 $T=1223760 679245 0 0 $X=1223330 $Y=678855
X964 37909 589 73 578 44 73 497 DFFQSRX1 $T=1223760 694925 1 0 $X=1223330 $Y=690370
X965 38169 491 73 578 44 73 37796 DFFQSRX1 $T=1252880 506765 0 180 $X=1227250 $Y=502210
X966 37784 589 73 578 44 73 498 DFFQSRX1 $T=1228240 710605 1 0 $X=1227810 $Y=706050
X967 38244 589 73 578 44 73 501 DFFQSRX1 $T=1228240 718445 1 0 $X=1227810 $Y=713890
X968 38171 589 73 578 44 73 504 DFFQSRX1 $T=1228240 726285 1 0 $X=1227810 $Y=721730
X969 25418 37744 578 73 44 73 38152 DFFQSRX1 $T=1228800 600845 1 0 $X=1228370 $Y=596290
X970 38290 37744 73 578 44 73 38006 DFFQSRX1 $T=1259040 514605 1 180 $X=1233410 $Y=514215
X971 38664 37744 73 578 44 73 38309 DFFQSRX1 $T=1269120 514605 0 180 $X=1243490 $Y=510050
X972 38654 37744 73 578 44 73 37882 DFFQSRX1 $T=1243920 593005 1 0 $X=1243490 $Y=588450
X973 38835 37744 73 578 44 73 38326 DFFQSRX1 $T=1269680 522445 1 180 $X=1244050 $Y=522055
X974 503 37744 73 578 44 73 38517 DFFQSRX1 $T=1245040 577325 1 0 $X=1244610 $Y=572770
X975 38720 37744 73 578 44 73 38360 DFFQSRX1 $T=1270800 577325 1 180 $X=1245170 $Y=576935
X976 38974 37744 73 578 44 73 38516 DFFQSRX1 $T=1278080 569485 0 180 $X=1252450 $Y=564930
X977 39030 37744 73 578 44 73 38563 DFFQSRX1 $T=1278640 553805 1 180 $X=1253010 $Y=553415
X1170 24547 24418 24416 44 73 24691 MUX2X1 $T=709120 640045 1 0 $X=708690 $Y=635490
X1171 24861 24264 25031 44 73 24862 MUX2X1 $T=729280 608685 1 180 $X=723250 $Y=608295
X1172 25477 79 25828 44 73 25782 MUX2X1 $T=752240 694925 1 180 $X=746210 $Y=694535
X1173 25547 79 25827 44 73 25867 MUX2X1 $T=754480 679245 1 180 $X=748450 $Y=678855
X1174 26065 85 25991 44 73 25951 MUX2X1 $T=756720 522445 1 180 $X=750690 $Y=522055
X1175 26066 85 25476 44 73 25952 MUX2X1 $T=756720 585165 1 180 $X=750690 $Y=584775
X1176 26206 79 26173 44 73 26146 MUX2X1 $T=763440 679245 1 180 $X=757410 $Y=678855
X1177 26066 93 26217 44 73 26215 MUX2X1 $T=766240 593005 1 180 $X=760210 $Y=592615
X1178 26337 93 26284 44 73 26255 MUX2X1 $T=767920 569485 0 180 $X=761890 $Y=564930
X1179 26348 93 26293 44 73 26269 MUX2X1 $T=768480 585165 1 180 $X=762450 $Y=584775
X1180 26348 85 25824 44 73 26282 MUX2X1 $T=769040 538125 1 180 $X=763010 $Y=537735
X1181 26337 85 26084 44 73 26283 MUX2X1 $T=769040 553805 0 180 $X=763010 $Y=549250
X1182 26389 85 25914 44 73 26305 MUX2X1 $T=770160 522445 1 180 $X=764130 $Y=522055
X1183 26443 93 26216 44 73 26361 MUX2X1 $T=772960 569485 1 180 $X=766930 $Y=569095
X1184 26485 79 26339 44 73 26411 MUX2X1 $T=775200 702765 0 180 $X=769170 $Y=698210
X1185 26362 79 26326 44 73 26515 MUX2X1 $T=770160 687085 0 0 $X=769730 $Y=686695
X1186 98 93 26230 44 73 26442 MUX2X1 $T=776880 522445 0 180 $X=770850 $Y=517890
X1187 99 93 26483 44 73 26463 MUX2X1 $T=778000 491085 0 180 $X=771970 $Y=486530
X1188 26554 79 26327 44 73 26625 MUX2X1 $T=776320 718445 1 0 $X=775890 $Y=713890
X1189 103 93 26581 44 73 26562 MUX2X1 $T=783600 545965 1 180 $X=777570 $Y=545575
X1190 26389 93 26640 44 73 26617 MUX2X1 $T=786400 569485 1 180 $X=780370 $Y=569095
X1191 26698 85 26649 44 73 26624 MUX2X1 $T=786960 600845 1 180 $X=780930 $Y=600455
X1192 26443 85 26453 44 73 26738 MUX2X1 $T=781920 530285 0 0 $X=781490 $Y=529895
X1193 103 85 91 44 73 104 MUX2X1 $T=789760 491085 0 180 $X=783730 $Y=486530
X1194 26608 79 100 44 73 26859 MUX2X1 $T=787520 694925 0 0 $X=787090 $Y=694535
X1195 26839 79 94 44 73 26760 MUX2X1 $T=793680 718445 0 180 $X=787650 $Y=713890
X1196 26791 79 101 44 73 26882 MUX2X1 $T=788640 702765 0 0 $X=788210 $Y=702375
X1197 26698 93 26838 44 73 26815 MUX2X1 $T=796480 694925 0 180 $X=790450 $Y=690370
X1198 26467 79 106 44 73 105 MUX2X1 $T=797600 726285 1 180 $X=791570 $Y=725895
X1199 27041 93 26973 44 73 26947 MUX2X1 $T=802640 600845 0 180 $X=796610 $Y=596290
X1200 108 93 26948 44 73 26972 MUX2X1 $T=803760 545965 0 180 $X=797730 $Y=541410
X1201 27041 85 26946 44 73 27171 MUX2X1 $T=811600 561645 1 180 $X=805570 $Y=561255
X1202 114 85 26807 44 73 109 MUX2X1 $T=819440 491085 0 180 $X=813410 $Y=486530
X1203 27507 85 26999 44 73 27408 MUX2X1 $T=819440 577325 1 180 $X=813410 $Y=576935
X1204 115 85 26990 44 73 27420 MUX2X1 $T=820000 506765 1 180 $X=813970 $Y=506375
X1205 114 93 27443 44 73 27421 MUX2X1 $T=820000 593005 0 180 $X=813970 $Y=588450
X1206 27553 85 26771 44 73 27465 MUX2X1 $T=821680 522445 1 180 $X=815650 $Y=522055
X1207 115 93 27488 44 73 27466 MUX2X1 $T=821680 608685 0 180 $X=815650 $Y=604130
X1208 27553 93 27424 44 73 27522 MUX2X1 $T=823920 616525 1 180 $X=817890 $Y=616135
X1209 27761 85 26867 44 73 27668 MUX2X1 $T=830080 506765 0 180 $X=824050 $Y=502210
X1210 27762 85 27054 44 73 27669 MUX2X1 $T=830080 522445 1 180 $X=824050 $Y=522055
X1211 27507 93 27695 44 73 27670 MUX2X1 $T=830080 624365 1 180 $X=824050 $Y=623975
X1212 27624 27859 27751 44 73 27858 MUX2X1 $T=839600 694925 0 180 $X=833570 $Y=690370
X1213 27986 134 26348 44 73 27916 MUX2X1 $T=840160 538125 0 180 $X=834130 $Y=533570
X1214 28032 134 26389 44 73 27955 MUX2X1 $T=842400 545965 1 180 $X=836370 $Y=545575
X1215 28122 134 26443 44 73 28031 MUX2X1 $T=846320 498925 1 180 $X=840290 $Y=498535
X1216 28123 85 26903 44 73 28033 MUX2X1 $T=846320 569485 1 180 $X=840290 $Y=569095
X1217 28124 134 27041 44 73 28034 MUX2X1 $T=846320 577325 0 180 $X=840290 $Y=572770
X1218 28200 85 27658 44 73 28104 MUX2X1 $T=849680 593005 0 180 $X=843650 $Y=588450
X1219 27763 85 27713 44 73 28105 MUX2X1 $T=849680 600845 0 180 $X=843650 $Y=596290
X1220 28266 134 103 44 73 28189 MUX2X1 $T=853040 498925 1 180 $X=847010 $Y=498535
X1221 144 134 27762 44 73 28213 MUX2X1 $T=854160 498925 0 180 $X=848130 $Y=494370
X1222 28317 134 26337 44 73 28230 MUX2X1 $T=855280 522445 0 180 $X=849250 $Y=517890
X1223 28330 85 26975 44 73 28243 MUX2X1 $T=855840 616525 0 180 $X=849810 $Y=611970
X1224 28353 134 27553 44 73 28267 MUX2X1 $T=856960 530285 1 180 $X=850930 $Y=529895
X1225 27761 93 27901 44 73 28378 MUX2X1 $T=851360 632205 1 0 $X=850930 $Y=627650
X1226 28750 134 26065 44 73 28609 MUX2X1 $T=868720 530285 1 180 $X=862690 $Y=529895
X1227 28767 134 27761 44 73 28625 MUX2X1 $T=869280 545965 0 180 $X=863250 $Y=541410
X1228 28123 93 28768 44 73 28802 MUX2X1 $T=863680 632205 0 0 $X=863250 $Y=631815
X1229 28783 134 28123 44 73 28645 MUX2X1 $T=869840 561645 0 180 $X=863810 $Y=557090
X1230 28826 134 28725 44 73 28678 MUX2X1 $T=870960 585165 0 180 $X=864930 $Y=580610
X1231 28867 134 27507 44 73 28724 MUX2X1 $T=872080 569485 1 180 $X=866050 $Y=569095
X1232 28725 85 27607 44 73 28726 MUX2X1 $T=872080 585165 1 180 $X=866050 $Y=584775
X1233 29293 134 28200 44 73 29185 MUX2X1 $T=886080 593005 0 180 $X=880050 $Y=588450
X1234 29346 134 27763 44 73 29248 MUX2X1 $T=888320 593005 1 180 $X=882290 $Y=592615
X1235 29280 93 29319 44 73 29294 MUX2X1 $T=890000 663565 1 180 $X=883970 $Y=663175
X1236 28330 93 29455 44 73 29478 MUX2X1 $T=887200 647885 0 0 $X=886770 $Y=647495
X1237 29466 85 29309 44 73 29372 MUX2X1 $T=893360 632205 1 180 $X=887330 $Y=631815
X1238 29658 93 29589 44 73 29561 MUX2X1 $T=901200 647885 1 180 $X=895170 $Y=647495
X1239 29678 93 29602 44 73 29572 MUX2X1 $T=901760 679245 0 180 $X=895730 $Y=674690
X1240 29777 205 29655 44 73 29601 MUX2X1 $T=908480 545965 0 180 $X=902450 $Y=541410
X1241 29858 134 29466 44 73 29775 MUX2X1 $T=909600 608685 0 180 $X=903570 $Y=604130
X1242 29789 205 29777 44 73 29953 MUX2X1 $T=906800 538125 1 0 $X=906370 $Y=533570
X1243 29928 134 29821 44 73 29842 MUX2X1 $T=912960 600845 1 180 $X=906930 $Y=600455
X1244 29821 93 29879 44 73 29860 MUX2X1 $T=913520 702765 0 180 $X=907490 $Y=698210
X1245 29789 211 29878 44 73 29983 MUX2X1 $T=908480 538125 0 0 $X=908050 $Y=537735
X1246 29658 85 29790 44 73 30143 MUX2X1 $T=915200 640045 1 0 $X=914770 $Y=635490
X1247 29678 85 30098 44 73 30144 MUX2X1 $T=915200 640045 0 0 $X=914770 $Y=639655
X1248 235 205 227 44 73 30036 MUX2X1 $T=921360 530285 1 180 $X=915330 $Y=529895
X1249 30128 93 30060 44 73 30049 MUX2X1 $T=921360 694925 1 180 $X=915330 $Y=694535
X1250 30181 134 29658 44 73 30095 MUX2X1 $T=923600 608685 0 180 $X=917570 $Y=604130
X1251 30097 205 30141 44 73 29894 MUX2X1 $T=924720 553805 1 180 $X=918690 $Y=553415
X1252 29632 211 29688 44 73 30158 MUX2X1 $T=926400 569485 1 180 $X=920370 $Y=569095
X1253 30187 205 30051 44 73 29857 MUX2X1 $T=921360 530285 0 0 $X=920930 $Y=529895
X1254 30189 93 29844 44 73 30267 MUX2X1 $T=921360 694925 0 0 $X=920930 $Y=694535
X1255 30289 93 30190 44 73 30209 MUX2X1 $T=929200 702765 0 180 $X=923170 $Y=698210
X1256 30298 93 30245 44 73 30221 MUX2X1 $T=929760 710605 0 180 $X=923730 $Y=706050
X1257 30126 134 30289 44 73 30365 MUX2X1 $T=925840 616525 0 0 $X=925410 $Y=616135
X1258 30334 211 30232 44 73 30163 MUX2X1 $T=932000 569485 1 180 $X=925970 $Y=569095
X1259 29632 205 30200 44 73 30312 MUX2X1 $T=934240 561645 1 180 $X=928210 $Y=561255
X1260 29773 211 30399 44 73 30541 MUX2X1 $T=934240 569485 0 0 $X=933810 $Y=569095
X1261 30128 85 30314 44 73 30567 MUX2X1 $T=935360 647885 1 0 $X=934930 $Y=643330
X1262 30581 134 28330 44 73 30499 MUX2X1 $T=942640 616525 0 180 $X=936610 $Y=611970
X1263 29924 211 29773 44 73 30630 MUX2X1 $T=939840 569485 0 0 $X=939410 $Y=569095
X1264 30399 211 30594 44 73 30624 MUX2X1 $T=941520 561645 0 0 $X=941090 $Y=561255
X1265 30189 85 30234 44 73 30658 MUX2X1 $T=949920 655725 1 180 $X=943890 $Y=655335
X1266 30289 85 30553 44 73 30779 MUX2X1 $T=944880 679245 1 0 $X=944450 $Y=674690
X1267 30837 211 30569 44 73 30708 MUX2X1 $T=953840 561645 1 180 $X=947810 $Y=561255
X1268 29924 205 30569 44 73 30766 MUX2X1 $T=954960 569485 0 180 $X=948930 $Y=564930
X1269 30605 211 260 44 73 30918 MUX2X1 $T=952720 553805 0 0 $X=952290 $Y=553415
X1270 31119 30742 31191 44 73 31164 MUX2X1 $T=962240 616525 0 0 $X=961810 $Y=616135
X1271 30220 211 29677 44 73 31026 MUX2X1 $T=968400 538125 1 180 $X=962370 $Y=537735
X1272 29677 211 29710 44 73 31190 MUX2X1 $T=963360 522445 0 0 $X=962930 $Y=522055
X1273 30298 85 31195 44 73 31322 MUX2X1 $T=965600 687085 0 0 $X=965170 $Y=686695
X1274 31556 134 30128 44 73 31437 MUX2X1 $T=979600 608685 0 180 $X=973570 $Y=604130
X1275 31595 31555 31378 44 73 31468 MUX2X1 $T=980720 647885 1 180 $X=974690 $Y=647495
X1276 31858 134 30189 44 73 31728 MUX2X1 $T=988560 608685 0 180 $X=982530 $Y=604130
X1277 32499 134 32284 44 73 32385 MUX2X1 $T=1009280 608685 1 180 $X=1003250 $Y=608295
X1278 32712 85 32630 44 73 32661 MUX2X1 $T=1018800 694925 1 180 $X=1012770 $Y=694535
X1279 32794 134 32712 44 73 32680 MUX2X1 $T=1019360 616525 1 180 $X=1013330 $Y=616135
X1280 32712 93 348 44 73 32829 MUX2X1 $T=1013760 726285 1 0 $X=1013330 $Y=721730
X1281 366 85 31839 44 73 32697 MUX2X1 $T=1019920 710605 1 180 $X=1013890 $Y=710215
X1282 32902 205 365 44 73 32376 MUX2X1 $T=1022720 530285 1 180 $X=1016690 $Y=529895
X1283 377 205 373 44 73 32435 MUX2X1 $T=1027760 491085 0 180 $X=1021730 $Y=486530
X1284 33062 33091 33048 44 73 33012 MUX2X1 $T=1030560 655725 1 180 $X=1024530 $Y=655335
X1285 396 85 33105 44 73 33290 MUX2X1 $T=1041760 710605 0 180 $X=1035730 $Y=706050
X1286 33376 93 378 44 73 33302 MUX2X1 $T=1042320 718445 1 180 $X=1036290 $Y=718055
X1287 33075 134 33376 44 73 33401 MUX2X1 $T=1037280 608685 1 0 $X=1036850 $Y=604130
X1288 33061 134 387 44 73 33402 MUX2X1 $T=1037280 624365 1 0 $X=1036850 $Y=619810
X1289 398 205 33383 44 73 32679 MUX2X1 $T=1045680 553805 1 180 $X=1039650 $Y=553415
X1290 401 211 32627 44 73 33502 MUX2X1 $T=1042880 561645 0 0 $X=1042450 $Y=561255
X1291 33065 211 33369 44 73 33519 MUX2X1 $T=1044000 577325 1 0 $X=1043570 $Y=572770
X1292 387 85 33465 44 73 33547 MUX2X1 $T=1045120 702765 1 0 $X=1044690 $Y=698210
X1293 33273 134 33536 44 73 33556 MUX2X1 $T=1045680 616525 0 0 $X=1045250 $Y=616135
X1294 33272 134 33577 44 73 33600 MUX2X1 $T=1047920 608685 1 0 $X=1047490 $Y=604130
X1295 33577 93 403 44 73 33661 MUX2X1 $T=1050720 710605 0 0 $X=1050290 $Y=710215
X1296 407 205 32454 44 73 33649 MUX2X1 $T=1060800 569485 0 180 $X=1054770 $Y=564930
X1297 33536 93 420 44 73 33684 MUX2X1 $T=1062480 694925 1 180 $X=1056450 $Y=694535
X1298 33522 205 33784 44 73 32724 MUX2X1 $T=1059120 514605 0 0 $X=1058690 $Y=514215
X1299 33092 205 33077 44 73 33819 MUX2X1 $T=1060800 553805 0 0 $X=1060370 $Y=553415
X1300 32613 205 33779 44 73 33708 MUX2X1 $T=1066960 545965 1 180 $X=1060930 $Y=545575
X1301 356 205 33522 44 73 33864 MUX2X1 $T=1072560 514605 1 180 $X=1066530 $Y=514215
X1302 33536 85 33914 44 73 33976 MUX2X1 $T=1068080 616525 0 0 $X=1067650 $Y=616135
X1303 33671 134 33954 44 73 33986 MUX2X1 $T=1068640 600845 1 0 $X=1068210 $Y=596290
X1304 33376 85 33977 44 73 34000 MUX2X1 $T=1069200 687085 1 0 $X=1068770 $Y=682530
X1305 32845 211 419 44 73 34040 MUX2X1 $T=1071440 522445 0 0 $X=1071010 $Y=522055
X1306 33589 205 33615 44 73 34055 MUX2X1 $T=1071440 530285 0 0 $X=1071010 $Y=529895
X1307 32832 205 32618 44 73 34129 MUX2X1 $T=1074240 514605 1 0 $X=1073810 $Y=510050
X1308 34052 211 33435 44 73 34157 MUX2X1 $T=1075360 545965 0 0 $X=1074930 $Y=545575
X1309 33995 211 33615 44 73 33831 MUX2X1 $T=1082640 530285 1 180 $X=1076610 $Y=529895
X1310 33954 93 415 44 73 34268 MUX2X1 $T=1079280 710605 1 0 $X=1078850 $Y=706050
X1311 34231 93 414 44 73 34131 MUX2X1 $T=1084880 718445 1 180 $X=1078850 $Y=718055
X1312 30414 134 34305 44 73 34333 MUX2X1 $T=1081520 600845 0 0 $X=1081090 $Y=600455
X1313 34305 85 34410 44 73 34491 MUX2X1 $T=1087680 647885 1 0 $X=1087250 $Y=643330
X1314 34231 85 34640 44 73 34746 MUX2X1 $T=1096080 702765 1 0 $X=1095650 $Y=698210
X1315 32792 134 34807 44 73 34844 MUX2X1 $T=1098880 593005 0 0 $X=1098450 $Y=592615
X1316 35206 85 33955 44 73 35124 MUX2X1 $T=1118480 702765 0 180 $X=1112450 $Y=698210
X1317 35206 93 35275 44 73 35309 MUX2X1 $T=1114560 710605 1 0 $X=1114130 $Y=706050
X1318 34807 85 35308 44 73 35342 MUX2X1 $T=1115680 624365 1 0 $X=1115250 $Y=619810
X1319 34807 93 34947 44 73 35359 MUX2X1 $T=1116240 671405 1 0 $X=1115810 $Y=666850
X1320 34305 93 35330 44 73 35360 MUX2X1 $T=1116240 679245 0 0 $X=1115810 $Y=678855
X1321 31194 134 35418 44 73 35450 MUX2X1 $T=1119600 600845 0 0 $X=1119170 $Y=600455
X1322 33118 134 35430 44 73 35460 MUX2X1 $T=1120160 577325 1 0 $X=1119730 $Y=572770
X1323 29788 134 35431 44 73 35461 MUX2X1 $T=1120160 593005 1 0 $X=1119730 $Y=588450
X1324 35430 93 35388 44 73 35358 MUX2X1 $T=1126880 655725 0 180 $X=1120850 $Y=651170
X1325 35418 85 35434 44 73 35419 MUX2X1 $T=1129120 624365 0 180 $X=1123090 $Y=619810
X1326 35418 93 35523 44 73 35503 MUX2X1 $T=1132480 655725 0 180 $X=1126450 $Y=651170
X1327 33315 134 35601 44 73 35631 MUX2X1 $T=1128000 585165 1 0 $X=1127570 $Y=580610
X1328 456 134 35613 44 73 35660 MUX2X1 $T=1129120 569485 1 0 $X=1128690 $Y=564930
X1329 33242 134 35762 44 73 35787 MUX2X1 $T=1134720 569485 1 0 $X=1134290 $Y=564930
X1330 31326 134 35772 44 73 35800 MUX2X1 $T=1135280 561645 1 0 $X=1134850 $Y=557090
X1331 33415 134 35799 44 73 35827 MUX2X1 $T=1136400 530285 0 0 $X=1135970 $Y=529895
X1332 34639 134 35825 44 73 35848 MUX2X1 $T=1137520 506765 0 0 $X=1137090 $Y=506375
X1333 30415 134 35826 44 73 35849 MUX2X1 $T=1137520 522445 1 0 $X=1137090 $Y=517890
X1334 250 134 35836 44 73 35861 MUX2X1 $T=1138080 498925 1 0 $X=1137650 $Y=494370
X1335 35613 85 35294 44 73 35953 MUX2X1 $T=1142000 624365 1 0 $X=1141570 $Y=619810
X1336 35431 85 35590 44 73 35964 MUX2X1 $T=1142560 600845 0 0 $X=1142130 $Y=600455
X1337 35431 93 35670 44 73 36002 MUX2X1 $T=1144240 624365 0 0 $X=1143810 $Y=623975
X1338 35786 93 35965 44 73 35936 MUX2X1 $T=1152080 663565 0 180 $X=1146050 $Y=659010
X1339 262 134 470 44 73 36269 MUX2X1 $T=1154880 491085 0 0 $X=1154450 $Y=490695
X1340 35810 93 36270 44 73 36246 MUX2X1 $T=1164400 553805 1 180 $X=1158370 $Y=553415
X1341 35772 85 36446 44 73 36465 MUX2X1 $T=1164960 553805 0 0 $X=1164530 $Y=553415
X1342 35799 93 36341 44 73 36407 MUX2X1 $T=1172240 561645 0 180 $X=1166210 $Y=557090
X1343 474 93 36448 44 73 36445 MUX2X1 $T=1174480 498925 0 180 $X=1168450 $Y=494370
X1344 470 93 36549 44 73 36575 MUX2X1 $T=1170560 491085 0 0 $X=1170130 $Y=490695
X1345 35601 93 36516 44 73 36497 MUX2X1 $T=1177280 616525 0 180 $X=1171250 $Y=611970
X1346 472 93 36598 44 73 36623 MUX2X1 $T=1172800 514605 1 0 $X=1172370 $Y=510050
X1347 35826 85 36415 44 73 36624 MUX2X1 $T=1172800 538125 1 0 $X=1172370 $Y=533570
X1348 35984 79 475 44 73 36636 MUX2X1 $T=1184000 726285 1 180 $X=1177970 $Y=725895
X1349 35786 85 36830 44 73 36853 MUX2X1 $T=1182320 593005 0 0 $X=1181890 $Y=592615
X1350 35799 85 36839 44 73 36881 MUX2X1 $T=1183440 561645 1 0 $X=1183010 $Y=557090
X1351 30921 79 479 44 73 480 MUX2X1 $T=1184000 726285 0 0 $X=1183570 $Y=725895
X1352 30842 79 36959 44 73 36997 MUX2X1 $T=1187360 687085 1 0 $X=1186930 $Y=682530
X1353 483 85 484 44 73 37255 MUX2X1 $T=1194640 491085 0 0 $X=1194210 $Y=490695
X1354 35825 93 37085 44 73 37284 MUX2X1 $T=1195760 616525 1 0 $X=1195330 $Y=611970
X1355 36578 79 37243 44 73 37210 MUX2X1 $T=1203600 702765 1 180 $X=1197570 $Y=702375
X1356 483 93 37256 44 73 37223 MUX2X1 $T=1204160 530285 0 180 $X=1198130 $Y=525730
X1357 35836 93 37257 44 73 37224 MUX2X1 $T=1204160 553805 1 180 $X=1198130 $Y=553415
X1358 30500 79 37259 44 73 37225 MUX2X1 $T=1204160 687085 1 180 $X=1198130 $Y=686695
X1359 35825 85 37347 44 73 37375 MUX2X1 $T=1199680 506765 1 0 $X=1199250 $Y=502210
X1360 33912 79 37299 44 73 37276 MUX2X1 $T=1205840 679245 0 180 $X=1199810 $Y=674690
X1361 35762 85 36274 44 73 37602 MUX2X1 $T=1208640 585165 0 0 $X=1208210 $Y=584775
X1362 35762 93 37435 44 73 37710 MUX2X1 $T=1214800 593005 0 0 $X=1214370 $Y=592615
X1363 29939 79 37465 44 73 37746 MUX2X1 $T=1217040 679245 1 0 $X=1216610 $Y=674690
X1364 490 93 37709 44 73 37695 MUX2X1 $T=1224320 522445 1 180 $X=1218290 $Y=522055
X1365 490 85 37854 44 73 37880 MUX2X1 $T=1223200 491085 0 0 $X=1222770 $Y=490695
X1366 489 85 37882 44 73 37922 MUX2X1 $T=1224880 585165 1 0 $X=1224450 $Y=580610
X1367 37883 79 37884 44 73 37881 MUX2X1 $T=1233840 671405 0 180 $X=1227810 $Y=666850
X1368 37821 79 37935 44 73 37908 MUX2X1 $T=1234960 679245 0 180 $X=1228930 $Y=674690
X1369 37603 79 497 44 73 37909 MUX2X1 $T=1234960 694925 1 180 $X=1228930 $Y=694535
X1370 36564 34347 38688 44 73 38636 MUX2X1 $T=1263520 655725 1 180 $X=1257490 $Y=655335
X1371 38992 38546 38899 44 73 38452 MUX2X1 $T=1269120 655725 0 180 $X=1263090 $Y=651170
X1372 39171 38520 39063 44 73 38836 MUX2X1 $T=1274160 640045 1 180 $X=1268130 $Y=639655
X1373 39422 36564 36949 44 73 39355 MUX2X1 $T=1287600 616525 1 180 $X=1281570 $Y=616135
X1374 24237 24264 44 73 24057 NAND2X1 $T=701840 640045 1 0 $X=701410 $Y=635490
X1375 24564 24077 44 73 24510 NAND2X1 $T=711920 608685 0 180 $X=708690 $Y=604130
X1376 24861 24751 44 73 24375 NAND2X1 $T=718080 608685 0 0 $X=717650 $Y=608295
X1377 24813 24861 44 73 24260 NAND2X1 $T=719200 647885 1 0 $X=718770 $Y=643330
X1378 24815 24813 44 73 24814 NAND2X1 $T=719200 655725 1 0 $X=718770 $Y=651170
X1379 24998 24796 44 73 25158 NAND2X1 $T=729280 624365 1 180 $X=726050 $Y=623975
X1380 25385 24143 44 73 25437 NAND2X1 $T=737680 640045 1 180 $X=734450 $Y=639655
X1381 25783 25849 44 73 25846 NAND2X1 $T=746640 710605 1 0 $X=746210 $Y=706050
X1382 78 25991 44 73 25966 NAND2X1 $T=751120 506765 1 0 $X=750690 $Y=502210
X1383 78 25824 44 73 25950 NAND2X1 $T=751120 530285 1 0 $X=750690 $Y=525730
X1384 82 25477 44 73 25992 NAND2X1 $T=753920 671405 1 180 $X=750690 $Y=671015
X1385 90 26295 44 73 92 NAND2X1 $T=762320 726285 0 0 $X=761890 $Y=725895
X1386 83 26326 44 73 25849 NAND2X1 $T=764000 702765 1 0 $X=763570 $Y=698210
X1387 83 26327 44 73 26176 NAND2X1 $T=764000 726285 1 0 $X=763570 $Y=721730
X1388 89 26293 44 73 26325 NAND2X1 $T=765680 616525 1 0 $X=765250 $Y=611970
X1389 26378 26258 44 73 95 NAND2X1 $T=769040 491085 0 180 $X=765810 $Y=486530
X1390 89 26230 44 73 26452 NAND2X1 $T=774080 616525 1 180 $X=770850 $Y=616135
X1391 96 97 44 73 26241 NAND2X1 $T=772400 679245 1 0 $X=771970 $Y=674690
X1392 80 26771 44 73 26749 NAND2X1 $T=786960 514605 0 0 $X=786530 $Y=514215
X1393 82 26554 44 73 26733 NAND2X1 $T=790320 640045 0 180 $X=787090 $Y=635490
X1394 82 26791 44 73 26806 NAND2X1 $T=791440 655725 1 0 $X=791010 $Y=651170
X1395 26858 96 44 73 26881 NAND2X1 $T=793680 655725 0 0 $X=793250 $Y=655335
X1396 78 26903 44 73 26739 NAND2X1 $T=797040 561645 0 180 $X=793810 $Y=557090
X1397 89 27043 44 73 26938 NAND2X1 $T=799280 655725 1 0 $X=798850 $Y=651170
X1398 78 27054 44 73 27099 NAND2X1 $T=805440 530285 0 180 $X=802210 $Y=525730
X1399 78 110 44 73 27442 NAND2X1 $T=813840 538125 1 0 $X=813410 $Y=533570
X1400 27510 27531 44 73 27509 NAND2X1 $T=817200 718445 0 0 $X=816770 $Y=718055
X1401 89 27488 44 73 27489 NAND2X1 $T=818320 632205 1 0 $X=817890 $Y=627650
X1402 80 27607 44 73 27491 NAND2X1 $T=820560 545965 0 0 $X=820130 $Y=545575
X1403 27685 27423 44 73 27673 NAND2X1 $T=826160 561645 1 180 $X=822930 $Y=561255
X1404 78 27713 44 73 27685 NAND2X1 $T=824480 593005 1 0 $X=824050 $Y=588450
X1405 119 27711 44 73 27659 NAND2X1 $T=826160 710605 0 0 $X=825730 $Y=710215
X1406 82 112 44 73 27784 NAND2X1 $T=827840 655725 0 0 $X=827410 $Y=655335
X1407 131 27604 44 73 130 NAND2X1 $T=835680 726285 1 180 $X=832450 $Y=725895
X1408 28135 28107 44 73 28127 NAND2X1 $T=846320 585165 1 180 $X=843090 $Y=584775
X1409 142 27765 44 73 27531 NAND2X1 $T=853040 718445 0 0 $X=852610 $Y=718055
X1410 27820 28133 44 73 28174 NAND2X1 $T=856400 710605 1 0 $X=855970 $Y=706050
X1411 28540 28078 44 73 28402 NAND2X1 $T=860880 694925 0 0 $X=860450 $Y=694535
X1412 89 26838 44 73 29054 NAND2X1 $T=877680 702765 1 180 $X=874450 $Y=702375
X1413 82 163 44 73 29374 NAND2X1 $T=891680 718445 1 180 $X=888450 $Y=718055
X1414 165 28353 44 73 29456 NAND2X1 $T=892800 522445 1 180 $X=889570 $Y=522055
X1415 165 28122 44 73 29507 NAND2X1 $T=895040 498925 0 180 $X=891810 $Y=494370
X1416 78 27607 44 73 29535 NAND2X1 $T=896160 616525 1 180 $X=892930 $Y=616135
X1417 89 29455 44 73 29536 NAND2X1 $T=896160 710605 1 180 $X=892930 $Y=710215
X1418 158 28867 44 73 171 NAND2X1 $T=893920 514605 0 0 $X=893490 $Y=514215
X1419 29334 29506 44 73 172 NAND2X1 $T=894480 506765 1 0 $X=894050 $Y=502210
X1420 29571 29574 44 73 176 NAND2X1 $T=895600 506765 0 0 $X=895170 $Y=506375
X1421 89 29602 44 73 182 NAND2X1 $T=897280 718445 0 0 $X=896850 $Y=718055
X1422 165 28867 44 73 29644 NAND2X1 $T=900640 522445 1 180 $X=897410 $Y=522055
X1423 165 29347 44 73 29661 NAND2X1 $T=898400 530285 0 0 $X=897970 $Y=529895
X1424 29709 29507 44 73 186 NAND2X1 $T=902880 491085 0 180 $X=899650 $Y=486530
X1425 174 181 44 73 29697 NAND2X1 $T=904000 545965 1 180 $X=900770 $Y=545575
X1426 29322 29787 44 73 180 NAND2X1 $T=902880 498925 0 0 $X=902450 $Y=498535
X1427 29772 29421 44 73 29777 NAND2X1 $T=905680 522445 0 180 $X=902450 $Y=517890
X1428 29422 29421 44 73 191 NAND2X1 $T=906240 530285 0 180 $X=903010 $Y=525730
X1429 199 29688 44 73 29735 NAND2X1 $T=907920 569485 0 180 $X=904690 $Y=564930
X1430 29711 29643 44 73 202 NAND2X1 $T=909040 498925 0 180 $X=905810 $Y=494370
X1431 29856 29456 44 73 204 NAND2X1 $T=909040 506765 1 180 $X=905810 $Y=506375
X1432 29859 29738 44 73 29843 NAND2X1 $T=909040 624365 0 180 $X=905810 $Y=619810
X1433 29877 29422 44 73 207 NAND2X1 $T=910160 522445 1 180 $X=906930 $Y=522055
X1434 29661 29711 44 73 213 NAND2X1 $T=909040 498925 1 0 $X=908610 $Y=494370
X1435 29998 29906 44 73 29957 NAND2X1 $T=914640 577325 1 180 $X=911410 $Y=576935
X1436 29983 220 44 73 30000 NAND2X1 $T=912400 553805 1 0 $X=911970 $Y=549250
X1437 30048 30028 44 73 29955 NAND2X1 $T=916880 585165 0 180 $X=913650 $Y=580610
X1438 185 230 44 73 29954 NAND2X1 $T=915760 545965 0 0 $X=915330 $Y=545575
X1439 184 231 44 73 29992 NAND2X1 $T=915760 561645 1 0 $X=915330 $Y=557090
X1440 29894 220 44 73 30081 NAND2X1 $T=916320 553805 0 0 $X=915890 $Y=553415
X1441 80 30098 44 73 30072 NAND2X1 $T=916320 655725 1 0 $X=915890 $Y=651170
X1442 29375 29506 44 73 30093 NAND2X1 $T=919680 498925 1 180 $X=916450 $Y=498535
X1443 30127 30159 44 73 30145 NAND2X1 $T=919120 663565 0 0 $X=918690 $Y=663175
X1444 29856 29506 44 73 241 NAND2X1 $T=923600 506765 1 180 $X=920370 $Y=506375
X1445 239 29655 44 73 30139 NAND2X1 $T=920800 522445 1 0 $X=920370 $Y=517890
X1446 29390 29644 44 73 30141 NAND2X1 $T=921360 522445 0 0 $X=920930 $Y=522055
X1447 243 30097 44 73 30035 NAND2X1 $T=924160 545965 1 180 $X=920930 $Y=545575
X1448 217 244 44 73 233 NAND2X1 $T=923040 491085 1 0 $X=922610 $Y=486530
X1449 243 30141 44 73 30211 NAND2X1 $T=924160 545965 0 0 $X=923730 $Y=545575
X1450 30069 220 44 73 30255 NAND2X1 $T=927520 585165 0 180 $X=924290 $Y=580610
X1451 29390 30231 44 73 248 NAND2X1 $T=925280 498925 0 0 $X=924850 $Y=498535
X1452 165 250 44 73 29999 NAND2X1 $T=926960 506765 1 0 $X=926530 $Y=502210
X1453 243 29773 44 73 30297 NAND2X1 $T=926960 553805 1 0 $X=926530 $Y=549250
X1454 243 30187 44 73 30106 NAND2X1 $T=930880 522445 1 180 $X=927650 $Y=522055
X1455 30158 215 44 73 30233 NAND2X1 $T=928080 577325 0 0 $X=927650 $Y=576935
X1456 30312 215 44 73 30372 NAND2X1 $T=930320 569485 1 0 $X=929890 $Y=564930
X1457 29856 30167 44 73 30200 NAND2X1 $T=930880 522445 0 0 $X=930450 $Y=522055
X1458 258 254 44 73 260 NAND2X1 $T=932560 491085 1 0 $X=932130 $Y=486530
X1459 30443 236 44 73 29998 NAND2X1 $T=935360 585165 0 180 $X=932130 $Y=580610
X1460 78 30146 44 73 30447 NAND2X1 $T=935920 679245 1 180 $X=932690 $Y=678855
X1461 29878 263 44 73 30404 NAND2X1 $T=934240 506765 0 0 $X=933810 $Y=506375
X1462 196 260 44 73 30485 NAND2X1 $T=936480 553805 0 0 $X=936050 $Y=553415
X1463 30552 30285 44 73 30531 NAND2X1 $T=940960 577325 1 180 $X=937730 $Y=576935
X1464 80 30553 44 73 30545 NAND2X1 $T=938160 679245 1 0 $X=937730 $Y=674690
X1465 29390 264 44 73 276 NAND2X1 $T=938720 498925 1 0 $X=938290 $Y=494370
X1466 30595 236 44 73 30582 NAND2X1 $T=942640 577325 0 180 $X=939410 $Y=572770
X1467 279 29644 44 73 282 NAND2X1 $T=943760 514605 1 180 $X=940530 $Y=514215
X1468 165 30607 44 73 30167 NAND2X1 $T=944880 522445 1 180 $X=941650 $Y=522055
X1469 30624 272 44 73 30521 NAND2X1 $T=942080 593005 1 0 $X=941650 $Y=588450
X1470 30528 29481 44 73 287 NAND2X1 $T=948240 498925 1 180 $X=945010 $Y=498535
X1471 30708 272 44 73 30570 NAND2X1 $T=946000 577325 0 0 $X=945570 $Y=576935
X1472 171 30743 44 73 291 NAND2X1 $T=946560 491085 1 0 $X=946130 $Y=486530
X1473 226 30187 44 73 30741 NAND2X1 $T=948800 522445 1 0 $X=948370 $Y=517890
X1474 253 30743 44 73 298 NAND2X1 $T=949920 498925 1 0 $X=949490 $Y=494370
X1475 297 30820 44 73 30816 NAND2X1 $T=949920 710605 1 0 $X=949490 $Y=706050
X1476 302 30187 44 73 30834 NAND2X1 $T=954960 514605 1 180 $X=951730 $Y=514215
X1477 302 30837 44 73 30799 NAND2X1 $T=955520 530285 1 180 $X=952290 $Y=529895
X1478 30766 272 44 73 30879 NAND2X1 $T=952720 577325 0 0 $X=952290 $Y=576935
X1479 30839 308 44 73 304 NAND2X1 $T=953280 718445 0 0 $X=952850 $Y=718055
X1480 30916 30464 44 73 30902 NAND2X1 $T=956640 538125 1 180 $X=953410 $Y=537735
X1481 30334 211 44 73 30917 NAND2X1 $T=954400 577325 1 0 $X=953970 $Y=572770
X1482 312 29677 44 73 30835 NAND2X1 $T=955520 530285 0 0 $X=955090 $Y=529895
X1483 185 287 44 73 30744 NAND2X1 $T=958880 545965 1 180 $X=955650 $Y=545575
X1484 300 249 44 73 30956 NAND2X1 $T=956640 498925 1 0 $X=956210 $Y=494370
X1485 315 313 44 73 30808 NAND2X1 $T=959440 718445 0 180 $X=956210 $Y=713890
X1486 243 231 44 73 30971 NAND2X1 $T=962800 561645 1 180 $X=959570 $Y=561255
X1487 312 30837 44 73 31042 NAND2X1 $T=960560 530285 1 0 $X=960130 $Y=525730
X1488 319 321 44 73 30685 NAND2X1 $T=961120 491085 1 0 $X=960690 $Y=486530
X1489 289 249 44 73 31057 NAND2X1 $T=963920 491085 1 180 $X=960690 $Y=490695
X1490 30820 323 44 73 322 NAND2X1 $T=962800 726285 0 0 $X=962370 $Y=725895
X1491 327 30141 44 73 31146 NAND2X1 $T=967840 553805 1 180 $X=964610 $Y=553415
X1492 30918 206 44 73 31163 NAND2X1 $T=965600 569485 1 0 $X=965170 $Y=564930
X1493 31059 220 44 73 31224 NAND2X1 $T=966160 577325 1 0 $X=965730 $Y=572770
X1494 31101 331 44 73 30957 NAND2X1 $T=966720 514605 0 0 $X=966290 $Y=514215
X1495 78 29309 44 73 31244 NAND2X1 $T=969520 679245 0 180 $X=966290 $Y=674690
X1496 31167 315 44 73 31270 NAND2X1 $T=967280 718445 1 0 $X=966850 $Y=713890
X1497 31286 30929 44 73 31269 NAND2X1 $T=970640 663565 0 180 $X=967410 $Y=659010
X1498 31027 31117 44 73 31165 NAND2X1 $T=971200 632205 1 180 $X=967970 $Y=631815
X1499 165 31326 44 73 30743 NAND2X1 $T=968960 530285 1 0 $X=968530 $Y=525730
X1500 31190 272 44 73 31373 NAND2X1 $T=971760 522445 1 0 $X=971330 $Y=517890
X1501 78 30553 44 73 31557 NAND2X1 $T=979600 687085 1 180 $X=976370 $Y=686695
X1502 31493 30742 44 73 31635 NAND2X1 $T=979040 632205 0 0 $X=978610 $Y=631815
X1503 80 31839 44 73 31820 NAND2X1 $T=984640 687085 1 0 $X=984210 $Y=682530
X1504 31414 31781 44 73 31220 NAND2X1 $T=987440 647885 0 0 $X=987010 $Y=647495
X1505 331 31091 44 73 289 NAND2X1 $T=989680 491085 0 0 $X=989250 $Y=490695
X1506 31863 30815 44 73 31995 NAND2X1 $T=993040 671405 0 180 $X=989810 $Y=666850
X1507 32080 31166 44 73 32062 NAND2X1 $T=995280 640045 0 180 $X=992050 $Y=635490
X1508 31625 31166 44 73 32117 NAND2X1 $T=996400 663565 1 0 $X=995970 $Y=659010
X1509 32319 32285 44 73 32303 NAND2X1 $T=1002560 671405 0 180 $X=999330 $Y=666850
X1510 32369 337 44 73 32359 NAND2X1 $T=1004240 498925 1 180 $X=1001010 $Y=498535
X1511 80 31030 44 73 32360 NAND2X1 $T=1004240 679245 1 180 $X=1001010 $Y=678855
X1512 32386 32360 44 73 32370 NAND2X1 $T=1004800 687085 0 180 $X=1001570 $Y=682530
X1513 199 32454 44 73 32484 NAND2X1 $T=1005360 530285 0 0 $X=1004930 $Y=529895
X1514 355 327 44 73 32586 NAND2X1 $T=1012080 514605 0 180 $X=1008850 $Y=510050
X1515 78 32630 44 73 32386 NAND2X1 $T=1010400 687085 1 0 $X=1009970 $Y=682530
X1516 353 333 44 73 32864 NAND2X1 $T=1018800 491085 0 0 $X=1018370 $Y=490695
X1517 32880 32846 44 73 32865 NAND2X1 $T=1021600 561645 1 180 $X=1018370 $Y=561255
X1518 32834 236 44 73 32880 NAND2X1 $T=1019920 553805 0 0 $X=1019490 $Y=553415
X1519 302 374 44 73 32838 NAND2X1 $T=1021600 506765 1 0 $X=1021170 $Y=502210
X1520 196 33065 44 73 33028 NAND2X1 $T=1024960 561645 1 0 $X=1024530 $Y=557090
X1521 165 28032 44 73 33046 NAND2X1 $T=1024960 569485 1 0 $X=1024530 $Y=564930
X1522 312 33092 44 73 33043 NAND2X1 $T=1030000 514605 1 180 $X=1026770 $Y=514215
X1523 33029 33046 44 73 370 NAND2X1 $T=1030000 561645 1 180 $X=1026770 $Y=561255
X1524 286 381 44 73 33076 NAND2X1 $T=1029440 506765 1 0 $X=1029010 $Y=502210
X1525 216 33093 44 73 385 NAND2X1 $T=1035040 506765 1 180 $X=1031810 $Y=506375
X1526 33212 33266 44 73 389 NAND2X1 $T=1033360 530285 1 0 $X=1032930 $Y=525730
X1527 33171 33266 44 73 33077 NAND2X1 $T=1033360 553805 1 0 $X=1032930 $Y=549250
X1528 33254 33279 44 73 32534 NAND2X1 $T=1033920 514605 0 0 $X=1033490 $Y=514215
X1529 33276 33316 44 73 33198 NAND2X1 $T=1035600 679245 1 0 $X=1035170 $Y=674690
X1530 33254 33337 44 73 355 NAND2X1 $T=1036720 514605 1 0 $X=1036290 $Y=510050
X1531 158 33273 44 73 33271 NAND2X1 $T=1039520 538125 0 180 $X=1036290 $Y=533570
X1532 32628 33315 44 73 33334 NAND2X1 $T=1037280 585165 1 0 $X=1036850 $Y=580610
X1533 78 31839 44 73 33349 NAND2X1 $T=1040640 694925 0 180 $X=1037410 $Y=690370
X1534 33343 33046 44 73 33369 NAND2X1 $T=1041760 569485 0 180 $X=1038530 $Y=564930
X1535 165 33061 44 73 33385 NAND2X1 $T=1042880 561645 1 180 $X=1039650 $Y=561255
X1536 33369 205 44 73 33412 NAND2X1 $T=1041200 577325 1 0 $X=1040770 $Y=572770
X1537 33400 400 44 73 384 NAND2X1 $T=1041760 498925 0 0 $X=1041330 $Y=498535
X1538 33434 32864 44 73 33423 NAND2X1 $T=1045120 498925 0 180 $X=1041890 $Y=494370
X1539 158 27986 44 73 33429 NAND2X1 $T=1042320 522445 0 0 $X=1041890 $Y=522055
X1540 165 33415 44 73 33279 NAND2X1 $T=1043440 530285 0 0 $X=1043010 $Y=529895
X1541 33225 33453 44 73 401 NAND2X1 $T=1043440 538125 0 0 $X=1043010 $Y=537735
X1542 33429 400 44 73 374 NAND2X1 $T=1047360 506765 0 180 $X=1044130 $Y=502210
X1543 33446 33383 44 73 383 NAND2X1 $T=1047360 514605 1 180 $X=1044130 $Y=514215
X1544 33383 33485 44 73 363 NAND2X1 $T=1047360 514605 0 0 $X=1046930 $Y=514215
X1545 165 33118 44 73 33446 NAND2X1 $T=1047360 553805 1 0 $X=1046930 $Y=549250
X1546 33475 33541 44 73 362 NAND2X1 $T=1051840 538125 0 180 $X=1048610 $Y=533570
X1547 199 33065 44 73 33516 NAND2X1 $T=1052400 577325 0 180 $X=1049170 $Y=572770
X1548 33464 33386 44 73 33048 NAND2X1 $T=1053520 655725 1 180 $X=1050290 $Y=655335
X1549 33400 33368 44 73 33591 NAND2X1 $T=1054080 530285 0 180 $X=1050850 $Y=525730
X1550 199 32627 44 73 33627 NAND2X1 $T=1055760 569485 1 180 $X=1052530 $Y=569095
X1551 185 413 44 73 33634 NAND2X1 $T=1056880 553805 0 180 $X=1053650 $Y=549250
X1552 174 33151 44 73 33697 NAND2X1 $T=1060240 530285 0 180 $X=1057010 $Y=525730
X1553 199 407 44 73 33727 NAND2X1 $T=1061360 561645 1 180 $X=1058130 $Y=561255
X1554 158 28266 44 73 424 NAND2X1 $T=1062480 498925 0 180 $X=1059250 $Y=494370
X1555 174 33347 44 73 33744 NAND2X1 $T=1062480 538125 1 180 $X=1059250 $Y=537735
X1556 158 33118 44 73 33682 NAND2X1 $T=1060240 545965 1 0 $X=1059810 $Y=541410
X1557 184 32613 44 73 33800 NAND2X1 $T=1062480 538125 0 0 $X=1062050 $Y=537735
X1558 158 28750 44 73 33830 NAND2X1 $T=1068080 522445 0 180 $X=1064850 $Y=517890
X1559 33834 33328 44 73 33823 NAND2X1 $T=1065840 647885 0 0 $X=1065410 $Y=647495
X1560 426 428 44 73 33779 NAND2X1 $T=1069760 506765 1 180 $X=1066530 $Y=506375
X1561 217 421 44 73 33886 NAND2X1 $T=1069760 545965 0 180 $X=1066530 $Y=541410
X1562 33844 33745 44 73 33891 NAND2X1 $T=1070320 663565 0 180 $X=1067090 $Y=659010
X1563 33901 33328 44 73 33064 NAND2X1 $T=1070320 671405 1 180 $X=1067090 $Y=671015
X1564 351 263 44 73 33908 NAND2X1 $T=1071440 498925 0 180 $X=1068210 $Y=494370
X1565 185 433 44 73 33913 NAND2X1 $T=1071440 538125 0 180 $X=1068210 $Y=533570
X1566 33649 215 44 73 33775 NAND2X1 $T=1068640 577325 0 0 $X=1068210 $Y=576935
X1567 33832 33227 44 73 33910 NAND2X1 $T=1069200 647885 1 0 $X=1068770 $Y=643330
X1568 33929 33312 44 73 33920 NAND2X1 $T=1072000 655725 0 180 $X=1068770 $Y=651170
X1569 33856 33883 44 73 33901 NAND2X1 $T=1072000 679245 1 180 $X=1068770 $Y=678855
X1570 33768 33931 44 73 33929 NAND2X1 $T=1070320 663565 1 0 $X=1069890 $Y=659010
X1571 33784 196 44 73 33944 NAND2X1 $T=1070880 538125 0 0 $X=1070450 $Y=537735
X1572 33953 215 44 73 33948 NAND2X1 $T=1073680 585165 0 180 $X=1070450 $Y=580610
X1573 196 33779 44 73 33952 NAND2X1 $T=1074240 514605 0 180 $X=1071010 $Y=510050
X1574 217 33347 44 73 439 NAND2X1 $T=1074800 491085 1 180 $X=1071570 $Y=490695
X1575 33996 33830 44 73 33692 NAND2X1 $T=1075360 514605 1 180 $X=1072130 $Y=514215
X1576 33502 215 44 73 33999 NAND2X1 $T=1073120 577325 1 0 $X=1072690 $Y=572770
X1577 34024 33899 44 73 369 NAND2X1 $T=1077600 491085 0 180 $X=1074370 $Y=486530
X1578 196 33077 44 73 34158 NAND2X1 $T=1082080 553805 1 180 $X=1078850 $Y=553415
X1579 216 33314 44 73 34172 NAND2X1 $T=1082640 514605 0 180 $X=1079410 $Y=510050
X1580 34157 183 44 73 34142 NAND2X1 $T=1083760 545965 1 180 $X=1080530 $Y=545575
X1581 196 33591 44 73 34288 NAND2X1 $T=1083760 545965 0 0 $X=1083330 $Y=545575
X1582 34024 436 44 73 34174 NAND2X1 $T=1085440 491085 1 0 $X=1085010 $Y=486530
X1583 33349 34369 44 73 34348 NAND2X1 $T=1086000 687085 0 0 $X=1085570 $Y=686695
X1584 34303 236 44 73 34366 NAND2X1 $T=1086560 561645 0 0 $X=1086130 $Y=561255
X1585 34381 34176 44 73 34367 NAND2X1 $T=1089360 569485 1 180 $X=1086130 $Y=569095
X1586 243 374 44 73 34377 NAND2X1 $T=1089920 498925 0 180 $X=1086690 $Y=494370
X1587 34129 206 44 73 34229 NAND2X1 $T=1088240 514605 0 0 $X=1087810 $Y=514215
X1588 34366 33833 44 73 34352 NAND2X1 $T=1091040 577325 0 180 $X=1087810 $Y=572770
X1589 34520 34490 44 73 34507 NAND2X1 $T=1094960 632205 0 180 $X=1091730 $Y=627650
X1590 80 34410 44 73 34490 NAND2X1 $T=1094960 640045 1 180 $X=1091730 $Y=639655
X1591 80 33955 44 73 34397 NAND2X1 $T=1092160 655725 0 0 $X=1091730 $Y=655335
X1592 216 453 44 73 34522 NAND2X1 $T=1095520 530285 0 180 $X=1092290 $Y=525730
X1593 34487 236 44 73 34602 NAND2X1 $T=1098320 561645 0 180 $X=1095090 $Y=557090
X1594 158 456 44 73 34024 NAND2X1 $T=1096640 491085 1 0 $X=1096210 $Y=486530
X1595 34569 96 44 73 34651 NAND2X1 $T=1097200 726285 1 0 $X=1096770 $Y=721730
X1596 158 34684 44 73 437 NAND2X1 $T=1097760 514605 1 0 $X=1097330 $Y=510050
X1597 78 34408 44 73 35033 NAND2X1 $T=1111200 655725 1 180 $X=1107970 $Y=655335
X1598 80 35308 44 73 35207 NAND2X1 $T=1120160 640045 0 0 $X=1119730 $Y=639655
X1599 35389 35237 44 73 35370 NAND2X1 $T=1123520 687085 1 180 $X=1120290 $Y=686695
X1600 35033 35674 44 73 35661 NAND2X1 $T=1133040 600845 0 0 $X=1132610 $Y=600455
X1601 82 30921 44 73 35778 NAND2X1 $T=1140320 687085 1 0 $X=1139890 $Y=682530
X1602 89 35965 44 73 465 NAND2X1 $T=1145920 694925 0 0 $X=1145490 $Y=694535
X1603 78 35308 44 73 36049 NAND2X1 $T=1153200 624365 0 180 $X=1149970 $Y=619810
X1604 89 35912 44 73 36218 NAND2X1 $T=1157120 687085 0 0 $X=1156690 $Y=686695
X1605 89 36173 44 73 36272 NAND2X1 $T=1158800 663565 1 0 $X=1158370 $Y=659010
X1606 82 471 44 73 36275 NAND2X1 $T=1158800 702765 1 0 $X=1158370 $Y=698210
X1607 89 36448 44 73 36426 NAND2X1 $T=1167200 608685 0 0 $X=1166770 $Y=608295
X1608 82 36058 44 73 36441 NAND2X1 $T=1170560 663565 1 180 $X=1167330 $Y=663175
X1609 89 36516 44 73 36531 NAND2X1 $T=1175600 624365 0 0 $X=1175170 $Y=623975
X1610 96 34368 44 73 36560 NAND2X1 $T=1175600 655725 0 0 $X=1175170 $Y=655335
X1611 36049 36840 44 73 36831 NAND2X1 $T=1185120 600845 0 0 $X=1184690 $Y=600455
X1612 80 36839 44 73 36798 NAND2X1 $T=1189040 569485 1 180 $X=1185810 $Y=569095
X1613 78 36839 44 73 36902 NAND2X1 $T=1190720 545965 1 180 $X=1187490 $Y=545575
X1614 96 30842 44 73 36903 NAND2X1 $T=1190720 624365 0 180 $X=1187490 $Y=619810
X1615 89 37085 44 73 37065 NAND2X1 $T=1192960 616525 1 0 $X=1192530 $Y=611970
X1616 78 481 44 73 482 NAND2X1 $T=1197440 491085 0 180 $X=1194210 $Y=486530
X1617 80 36446 44 73 37283 NAND2X1 $T=1202480 545965 0 180 $X=1199250 $Y=541410
X1618 80 36758 44 73 37278 NAND2X1 $T=1203600 577325 1 0 $X=1203170 $Y=572770
X1619 78 37347 44 73 37387 NAND2X1 $T=1208080 506765 0 180 $X=1204850 $Y=502210
X1620 82 29939 44 73 37535 NAND2X1 $T=1215920 632205 0 180 $X=1212690 $Y=627650
X1621 89 37435 44 73 37686 NAND2X1 $T=1219840 616525 1 180 $X=1216610 $Y=616135
X1622 37773 37685 44 73 37764 NAND2X1 $T=1224880 585165 1 180 $X=1221650 $Y=584775
X1623 37798 96 44 73 37663 NAND2X1 $T=1226000 624365 1 180 $X=1222770 $Y=623975
X1624 37817 37708 44 73 37801 NAND2X1 $T=1226560 522445 0 180 $X=1223330 $Y=517890
X1625 89 37820 44 73 37755 NAND2X1 $T=1223760 616525 0 0 $X=1223330 $Y=616135
X1626 78 37796 44 73 37817 NAND2X1 $T=1226560 522445 1 0 $X=1226130 $Y=517890
X1627 82 37883 44 73 37818 NAND2X1 $T=1226560 640045 0 0 $X=1226130 $Y=639655
X1628 37675 496 44 73 499 NAND2X1 $T=1232160 726285 0 0 $X=1231730 $Y=725895
X1629 37900 38022 44 73 38169 NAND2X1 $T=1241120 514605 0 180 $X=1237890 $Y=510050
X1630 38190 37689 44 73 38171 NAND2X1 $T=1241120 718445 1 180 $X=1237890 $Y=718055
X1631 38310 38279 44 73 38290 NAND2X1 $T=1245040 530285 0 180 $X=1241810 $Y=525730
X1632 38545 38520 44 73 38401 NAND2X1 $T=1253440 655725 0 180 $X=1250210 $Y=651170
X1633 38350 38448 44 73 38531 NAND2X1 $T=1251200 545965 1 0 $X=1250770 $Y=541410
X1634 38600 34480 44 73 38462 NAND2X1 $T=1255680 616525 0 180 $X=1252450 $Y=611970
X1635 38821 38854 44 73 38974 NAND2X1 $T=1268560 561645 1 180 $X=1265330 $Y=561255
X1636 39191 38913 44 73 39103 NAND2X1 $T=1274160 632205 0 180 $X=1270930 $Y=627650
X1637 39261 39117 44 73 39009 NAND2X1 $T=1275840 616525 0 180 $X=1272610 $Y=611970
X1638 39589 36949 44 73 39349 NAND2X1 $T=1286480 632205 1 180 $X=1283250 $Y=631815
X1639 39423 39650 44 73 38635 NAND2X1 $T=1284240 624365 1 0 $X=1283810 $Y=619810
X1640 38715 39628 44 73 39805 NAND2X1 $T=1291520 655725 0 180 $X=1288290 $Y=651170
X1641 39841 38462 44 73 39820 NAND2X1 $T=1292080 632205 1 180 $X=1288850 $Y=631815
X1981 44 73 24143 24195 24145 ICV_68 $T=698480 616525 0 0 $X=698050 $Y=616135
X1982 44 73 24375 24700 24831 ICV_68 $T=716960 632205 1 0 $X=716530 $Y=627650
X1983 44 73 25158 24195 25459 ICV_68 $T=733760 624365 0 0 $X=733330 $Y=623975
X1984 44 73 80 25824 25869 ICV_68 $T=750000 545965 1 0 $X=749570 $Y=541410
X1985 44 73 78 26453 26292 ICV_68 $T=769040 538125 0 0 $X=768610 $Y=537735
X1986 44 73 96 26467 26109 ICV_68 $T=769600 663565 1 0 $X=769170 $Y=659010
X1987 44 73 89 26640 26699 ICV_68 $T=783600 616525 1 0 $X=783170 $Y=611970
X1988 44 73 89 26948 26936 ICV_68 $T=794240 608685 0 0 $X=793810 $Y=608295
X1989 44 73 89 27695 27819 ICV_68 $T=830080 647885 0 0 $X=829650 $Y=647495
X1990 44 73 27807 28050 27966 ICV_68 $T=838480 702765 0 0 $X=838050 $Y=702375
X1991 44 73 78 28572 28135 ICV_68 $T=859200 608685 0 0 $X=858770 $Y=608295
X1992 44 73 89 28244 148 ICV_68 $T=867040 679245 0 0 $X=866610 $Y=678855
X1993 44 73 29467 96 29493 ICV_68 $T=890560 718445 1 0 $X=890130 $Y=713890
X1994 44 73 184 29655 29761 ICV_68 $T=900640 561645 1 0 $X=900210 $Y=557090
X1995 44 73 158 29824 29709 ICV_68 $T=903440 577325 1 0 $X=903010 $Y=572770
X1996 44 73 29857 206 29870 ICV_68 $T=906240 530285 1 0 $X=905810 $Y=525730
X1997 44 73 165 29824 29787 ICV_68 $T=911840 569485 0 0 $X=911410 $Y=569095
X1998 44 73 29953 183 30026 ICV_68 $T=912400 538125 1 0 $X=911970 $Y=533570
X1999 44 73 30429 30459 30444 ICV_68 $T=932000 585165 0 0 $X=931570 $Y=584775
X2000 44 73 30507 272 30364 ICV_68 $T=935920 545965 1 0 $X=935490 $Y=541410
X2001 44 73 30476 29644 273 ICV_68 $T=937040 522445 1 0 $X=936610 $Y=517890
X2002 44 73 30630 272 30732 ICV_68 $T=945440 585165 0 0 $X=945010 $Y=584775
X2003 44 73 290 294 30632 ICV_68 $T=945440 718445 0 0 $X=945010 $Y=718055
X2004 44 73 78 31030 30413 ICV_68 $T=957200 679245 1 0 $X=956770 $Y=674690
X2005 44 73 31117 29250 31414 ICV_68 $T=971200 640045 0 0 $X=970770 $Y=639655
X2006 44 73 31285 337 31412 ICV_68 $T=972320 498925 0 0 $X=971890 $Y=498535
X2007 44 73 32317 32439 350 ICV_68 $T=1002560 569485 1 0 $X=1002130 $Y=564930
X2008 44 73 32414 349 32436 ICV_68 $T=1003120 530285 1 0 $X=1002690 $Y=525730
X2009 44 73 32415 32547 32552 ICV_68 $T=1007040 553805 1 0 $X=1006610 $Y=549250
X2010 44 73 31148 28124 32519 ICV_68 $T=1009280 585165 0 0 $X=1008850 $Y=584775
X2011 44 73 80 33105 32833 ICV_68 $T=1025520 694925 1 0 $X=1025090 $Y=690370
X2012 44 73 33131 33171 381 ICV_68 $T=1028880 538125 0 0 $X=1028450 $Y=537735
X2013 44 73 217 384 33167 ICV_68 $T=1030560 498925 0 0 $X=1030130 $Y=498535
X2014 44 73 33256 33219 33276 ICV_68 $T=1032800 671405 1 0 $X=1032370 $Y=666850
X2015 44 73 33104 33327 32695 ICV_68 $T=1035040 506765 0 0 $X=1034610 $Y=506375
X2016 44 73 33048 33494 33486 ICV_68 $T=1044560 663565 1 0 $X=1044130 $Y=659010
X2017 44 73 312 33615 33546 ICV_68 $T=1050720 506765 0 0 $X=1050290 $Y=506375
X2018 44 73 174 421 33710 ICV_68 $T=1056320 545965 1 0 $X=1055890 $Y=541410
X2019 44 73 33668 33731 33732 ICV_68 $T=1057440 506765 1 0 $X=1057010 $Y=502210
X2020 44 73 34025 169 33959 ICV_68 $T=1073680 593005 1 0 $X=1073250 $Y=588450
X2021 44 73 33972 243 34159 ICV_68 $T=1078160 498925 0 0 $X=1077730 $Y=498535
X2022 44 73 243 34052 34178 ICV_68 $T=1082640 522445 1 0 $X=1082210 $Y=517890
X2023 44 73 78 34410 32319 ICV_68 $T=1086560 663565 1 0 $X=1086130 $Y=659010
X2024 44 73 35158 35207 35192 ICV_68 $T=1112880 640045 0 0 $X=1112450 $Y=639655
X2025 44 73 89 35275 460 ICV_68 $T=1115680 726285 1 0 $X=1115250 $Y=721730
X2026 44 73 96 341 35864 ICV_68 $T=1140880 702765 0 0 $X=1140450 $Y=702375
X2027 44 73 36350 96 36366 ICV_68 $T=1162160 694925 1 0 $X=1161730 $Y=690370
X2028 44 73 82 30500 36738 ICV_68 $T=1185120 640045 1 0 $X=1184690 $Y=635490
X2029 44 73 38544 38574 38451 ICV_68 $T=1250640 632205 1 0 $X=1250210 $Y=627650
X2030 44 73 38505 38600 38544 ICV_68 $T=1251760 624365 0 0 $X=1251330 $Y=623975
X2031 44 24033 24077 23959 73 ICV_69 $T=695120 632205 1 0 $X=694690 $Y=627650
X2032 44 24123 24143 24075 73 ICV_69 $T=697360 608685 1 0 $X=696930 $Y=604130
X2033 44 24195 24264 24180 73 ICV_69 $T=699600 632205 1 0 $X=699170 $Y=627650
X2034 44 24077 24125 24482 73 ICV_69 $T=705760 655725 0 0 $X=705330 $Y=655335
X2035 44 24631 24459 24567 73 ICV_69 $T=710240 655725 0 0 $X=709810 $Y=655335
X2036 44 24284 24861 24882 73 ICV_69 $T=719760 640045 0 0 $X=719330 $Y=639655
X2037 44 24077 24195 25384 73 ICV_69 $T=730960 632205 1 0 $X=730530 $Y=627650
X2038 44 78 25914 25899 73 ICV_69 $T=746640 491085 1 0 $X=746210 $Y=486530
X2039 44 83 26339 26295 73 ICV_69 $T=762880 718445 1 0 $X=762450 $Y=713890
X2040 44 89 26581 26606 73 ICV_69 $T=777440 632205 1 0 $X=777010 $Y=627650
X2041 44 26837 26868 26860 73 ICV_69 $T=789760 585165 1 0 $X=789330 $Y=580610
X2042 44 82 26839 26900 73 ICV_69 $T=791440 640045 0 0 $X=791010 $Y=639655
X2043 44 80 26867 27071 73 ICV_69 $T=799280 514605 1 0 $X=798850 $Y=510050
X2044 44 27442 27547 27528 73 ICV_69 $T=816080 561645 0 0 $X=815650 $Y=561255
X2045 44 119 113 28036 73 ICV_69 $T=837360 687085 1 0 $X=836930 $Y=682530
X2046 44 27918 27751 28137 73 ICV_69 $T=841840 687085 1 0 $X=841410 $Y=682530
X2047 44 89 29589 177 73 ICV_69 $T=893920 710605 1 0 $X=893490 $Y=706050
X2048 44 158 29788 29772 73 ICV_69 $T=901200 514605 0 0 $X=900770 $Y=514215
X2049 44 29661 29422 29773 73 ICV_69 $T=901200 530285 0 0 $X=900770 $Y=529895
X2050 44 193 198 195 73 ICV_69 $T=902880 491085 1 0 $X=902450 $Y=486530
X2051 44 29425 29877 209 73 ICV_69 $T=905680 522445 1 0 $X=905250 $Y=517890
X2052 44 29711 29787 29924 73 ICV_69 $T=907920 569485 1 0 $X=907490 $Y=564930
X2053 44 196 30399 30287 73 ICV_69 $T=929200 530285 0 0 $X=928770 $Y=529895
X2054 44 243 29924 30396 73 ICV_69 $T=929760 553805 1 0 $X=929330 $Y=549250
X2055 44 165 30415 29877 73 ICV_69 $T=933680 514605 0 0 $X=933250 $Y=514215
X2056 44 196 29773 30622 73 ICV_69 $T=939840 569485 1 0 $X=939410 $Y=564930
X2057 44 30708 183 30162 73 ICV_69 $T=944320 569485 1 0 $X=943890 $Y=564930
X2058 44 30624 259 30735 73 ICV_69 $T=944880 593005 1 0 $X=944450 $Y=588450
X2059 44 30766 183 30656 73 ICV_69 $T=947680 569485 0 0 $X=947250 $Y=569095
X2060 44 78 31195 30838 73 ICV_69 $T=962800 671405 0 0 $X=962370 $Y=671015
X2061 44 31213 30815 31306 73 ICV_69 $T=966720 671405 1 0 $X=966290 $Y=666850
X2062 44 32484 32587 32582 73 ICV_69 $T=1007040 530285 1 0 $X=1006610 $Y=525730
X2063 44 31193 363 32626 73 ICV_69 $T=1012640 522445 1 0 $X=1012210 $Y=517890
X2064 44 31557 32833 32809 73 ICV_69 $T=1015440 687085 0 0 $X=1015010 $Y=686695
X2065 44 300 368 32790 73 ICV_69 $T=1016000 498925 1 0 $X=1015570 $Y=494370
X2066 44 165 28124 33157 73 ICV_69 $T=1027760 569485 1 0 $X=1027330 $Y=564930
X2067 44 33171 33169 388 73 ICV_69 $T=1031120 545965 0 0 $X=1030690 $Y=545575
X2068 44 217 33151 390 73 ICV_69 $T=1032240 491085 1 0 $X=1031810 $Y=486530
X2069 44 165 33075 33266 73 ICV_69 $T=1032800 577325 1 0 $X=1032370 $Y=572770
X2070 44 33130 397 32845 73 ICV_69 $T=1036720 514605 0 0 $X=1036290 $Y=514215
X2071 44 33274 33386 33374 73 ICV_69 $T=1037840 655725 0 0 $X=1037410 $Y=655335
X2072 44 33405 33312 33451 73 ICV_69 $T=1042320 647885 0 0 $X=1041890 $Y=647495
X2073 44 33424 220 33503 73 ICV_69 $T=1044560 585165 1 0 $X=1044130 $Y=580610
X2074 44 33486 33440 33426 73 ICV_69 $T=1044560 663565 0 0 $X=1044130 $Y=663175
X2075 44 289 32613 33554 73 ICV_69 $T=1047920 498925 0 0 $X=1047490 $Y=498535
X2076 44 33443 33580 33139 73 ICV_69 $T=1048480 624365 0 0 $X=1048050 $Y=623975
X2077 44 33453 33213 409 73 ICV_69 $T=1050160 561645 1 0 $X=1049730 $Y=557090
X2078 44 82 270 422 73 ICV_69 $T=1056880 726285 1 0 $X=1056450 $Y=721730
X2079 44 33681 33485 425 73 ICV_69 $T=1058560 522445 0 0 $X=1058130 $Y=522055
X2080 44 33708 220 33785 73 ICV_69 $T=1059680 577325 0 0 $X=1059250 $Y=576935
X2081 44 185 33314 33945 73 ICV_69 $T=1069200 561645 1 0 $X=1068770 $Y=557090
X2082 44 158 34639 432 73 ICV_69 $T=1094960 498925 0 0 $X=1094530 $Y=498535
X2083 44 165 34684 426 73 ICV_69 $T=1097200 506765 1 0 $X=1096770 $Y=502210
X2084 44 78 36333 36233 73 ICV_69 $T=1159360 585165 1 0 $X=1158930 $Y=580610
X2085 44 96 36058 36252 73 ICV_69 $T=1162720 702765 0 0 $X=1162290 $Y=702375
X2086 44 36217 36798 36780 73 ICV_69 $T=1181760 577325 0 0 $X=1181330 $Y=576935
X2087 44 36674 96 36868 73 ICV_69 $T=1185120 647885 0 0 $X=1184690 $Y=647495
X2088 44 82 37821 37719 73 ICV_69 $T=1222080 647885 0 0 $X=1221650 $Y=647495
X2089 44 38392 38420 38298 73 ICV_69 $T=1244480 616525 0 0 $X=1244050 $Y=616135
X2090 44 38600 38666 38721 73 ICV_69 $T=1255680 624365 0 0 $X=1255250 $Y=623975
X2091 44 38901 39068 39027 73 ICV_69 $T=1266320 663565 1 0 $X=1265890 $Y=659010
X2092 44 39395 34347 38572 73 ICV_69 $T=1276400 663565 0 0 $X=1275970 $Y=663175
X2093 44 34347 34118 39192 73 ICV_69 $T=1278080 655725 0 0 $X=1277650 $Y=655335
X2094 23986 23934 44 73 23965 NOR2X1 $T=697360 647885 0 180 $X=694130 $Y=643330
X2095 24180 24260 44 73 24261 NOR2X1 $T=701280 640045 0 0 $X=700850 $Y=639655
X2096 24125 24307 44 73 24154 NOR2X1 $T=702400 647885 1 0 $X=701970 $Y=643330
X2097 24285 24261 44 73 24307 NOR2X1 $T=702960 647885 0 0 $X=702530 $Y=647495
X2098 24329 24375 44 73 24213 NOR2X1 $T=704080 600845 0 0 $X=703650 $Y=600455
X2099 24417 24125 44 73 24237 NOR2X1 $T=708000 640045 0 180 $X=704770 $Y=635490
X2100 24347 24437 44 73 24285 NOR2X1 $T=705760 647885 0 0 $X=705330 $Y=647495
X2101 24375 24480 44 73 24457 NOR2X1 $T=706880 600845 1 0 $X=706450 $Y=596290
X2102 24457 24503 44 73 24479 NOR2X1 $T=707440 593005 1 0 $X=707010 $Y=588450
X2103 24039 24125 44 73 24330 NOR2X1 $T=710800 624365 0 180 $X=707570 $Y=619810
X2104 24546 24587 44 73 24480 NOR2X1 $T=709680 600845 1 0 $X=709250 $Y=596290
X2105 24417 24751 44 73 24813 NOR2X1 $T=719200 624365 0 180 $X=715970 $Y=619810
X2106 24417 24375 44 73 24944 NOR2X1 $T=722560 624365 1 180 $X=719330 $Y=623975
X2107 24882 24961 44 73 24214 NOR2X1 $T=719760 632205 0 0 $X=719330 $Y=631815
X2108 24861 24588 44 73 24960 NOR2X1 $T=723120 608685 0 180 $X=719890 $Y=604130
X2109 24962 24998 44 73 24437 NOR2X1 $T=720880 647885 0 0 $X=720450 $Y=647495
X2110 24700 24284 44 73 24963 NOR2X1 $T=724800 647885 0 180 $X=721570 $Y=643330
X2111 24796 24329 44 73 24143 NOR2X1 $T=726480 600845 1 0 $X=726050 $Y=596290
X2112 24861 24284 44 73 24077 NOR2X1 $T=730960 616525 0 180 $X=727730 $Y=611970
X2113 24077 24961 44 73 25214 NOR2X1 $T=730960 632205 0 180 $X=727730 $Y=627650
X2114 24077 24340 44 73 25217 NOR2X1 $T=730960 632205 1 180 $X=727730 $Y=631815
X2115 25137 25191 44 73 25231 NOR2X1 $T=728160 647885 0 0 $X=727730 $Y=647495
X2116 25217 25214 44 73 25253 NOR2X1 $T=729280 640045 0 0 $X=728850 $Y=639655
X2117 24700 24861 44 73 24962 NOR2X1 $T=729280 647885 1 0 $X=728850 $Y=643330
X2118 24143 25253 44 73 25323 NOR2X1 $T=734880 640045 1 180 $X=731650 $Y=639655
X2119 25323 25322 44 73 25345 NOR2X1 $T=732080 647885 1 0 $X=731650 $Y=643330
X2120 24264 24329 44 73 24776 NOR2X1 $T=733760 600845 0 0 $X=733330 $Y=600455
X2121 24264 24195 44 73 24038 NOR2X1 $T=735440 616525 1 0 $X=735010 $Y=611970
X2122 25214 25458 44 73 25493 NOR2X1 $T=737680 640045 1 0 $X=737250 $Y=635490
X2123 24839 25566 44 73 25584 NOR2X1 $T=739360 655725 1 0 $X=738930 $Y=651170
X2124 25643 24101 44 73 25713 NOR2X1 $T=742720 640045 0 0 $X=742290 $Y=639655
X2125 24700 24751 44 73 25539 NOR2X1 $T=746640 632205 1 180 $X=743410 $Y=631815
X2126 27530 27511 44 73 116 NOR2X1 $T=820000 726285 1 180 $X=816770 $Y=725895
X2127 27624 27654 44 73 27625 NOR2X1 $T=822240 694925 1 0 $X=821810 $Y=690370
X2128 27655 27625 44 73 27537 NOR2X1 $T=825040 702765 0 180 $X=821810 $Y=698210
X2129 119 27736 44 73 27725 NOR2X1 $T=825600 687085 1 0 $X=825170 $Y=682530
X2130 126 27710 44 73 27736 NOR2X1 $T=828960 687085 1 180 $X=825730 $Y=686695
X2131 27765 27604 44 73 27511 NOR2X1 $T=829520 718445 1 180 $X=826290 $Y=718055
X2132 27624 27751 44 73 119 NOR2X1 $T=827280 694925 1 0 $X=826850 $Y=690370
X2133 27765 27710 44 73 27807 NOR2X1 $T=831760 710605 1 180 $X=828530 $Y=710215
X2134 27820 27725 44 73 27838 NOR2X1 $T=832880 687085 0 180 $X=829650 $Y=682530
X2135 122 27531 44 73 128 NOR2X1 $T=830080 726285 0 0 $X=829650 $Y=725895
X2136 27604 126 44 73 27801 NOR2X1 $T=834560 710605 1 180 $X=831330 $Y=710215
X2137 27839 127 44 73 27917 NOR2X1 $T=836240 718445 1 180 $X=833010 $Y=718055
X2138 27917 27838 44 73 27934 NOR2X1 $T=837360 687085 0 180 $X=834130 $Y=682530
X2139 27765 27945 44 73 27655 NOR2X1 $T=834560 710605 0 0 $X=834130 $Y=710215
X2140 117 27934 44 73 27913 NOR2X1 $T=837920 687085 1 180 $X=834690 $Y=686695
X2141 27711 27859 44 73 27891 NOR2X1 $T=839040 702765 1 0 $X=838610 $Y=698210
X2142 28006 28018 44 73 135 NOR2X1 $T=839040 726285 1 0 $X=838610 $Y=721730
X2143 28231 27751 44 73 142 NOR2X1 $T=850800 702765 0 180 $X=847570 $Y=698210
X2144 27624 136 44 73 139 NOR2X1 $T=850800 702765 1 0 $X=850370 $Y=698210
X2145 28319 27511 44 73 143 NOR2X1 $T=855280 726285 0 180 $X=852050 $Y=721730
X2146 28133 122 44 73 28078 NOR2X1 $T=863680 702765 1 180 $X=860450 $Y=702375
X2147 126 27859 44 73 28319 NOR2X1 $T=860880 718445 1 0 $X=860450 $Y=713890
X2148 29871 29925 44 73 29906 NOR2X1 $T=909040 569485 0 0 $X=908610 $Y=569095
X2149 30047 29981 44 73 29903 NOR2X1 $T=916880 561645 1 180 $X=913650 $Y=561255
X2150 30027 30094 44 73 30110 NOR2X1 $T=918560 545965 0 0 $X=918130 $Y=545575
X2151 30125 30244 44 73 30264 NOR2X1 $T=926400 538125 1 0 $X=925970 $Y=533570
X2152 30335 30311 44 73 29548 NOR2X1 $T=930880 538125 1 180 $X=927650 $Y=537735
X2153 30427 30068 44 73 30474 NOR2X1 $T=934800 514605 1 0 $X=934370 $Y=510050
X2154 30469 30470 44 73 30477 NOR2X1 $T=937600 561645 1 180 $X=934370 $Y=561255
X2155 30378 30490 44 73 30475 NOR2X1 $T=934800 593005 0 0 $X=934370 $Y=592615
X2156 30530 30428 44 73 30459 NOR2X1 $T=939840 577325 0 180 $X=936610 $Y=572770
X2157 30510 269 44 73 29590 NOR2X1 $T=937040 718445 0 0 $X=936610 $Y=718055
X2158 236 30474 44 73 30527 NOR2X1 $T=940400 514605 0 180 $X=937170 $Y=510050
X2159 30527 30606 44 73 30554 NOR2X1 $T=940400 514605 1 0 $X=939970 $Y=510050
X2160 30673 30457 44 73 30657 NOR2X1 $T=946000 530285 0 180 $X=942770 $Y=525730
X2161 30686 30615 44 73 30635 NOR2X1 $T=946560 600845 0 180 $X=943330 $Y=596290
X2162 30707 30731 44 73 30120 NOR2X1 $T=946000 538125 1 0 $X=945570 $Y=533570
X2163 30855 30397 44 73 30880 NOR2X1 $T=952160 593005 0 0 $X=951730 $Y=592615
X2164 280 285 44 73 308 NOR2X1 $T=953840 718445 1 0 $X=953410 $Y=713890
X2165 30890 30936 44 73 30552 NOR2X1 $T=954400 514605 1 0 $X=953970 $Y=510050
X2166 30820 313 44 73 310 NOR2X1 $T=954400 710605 0 0 $X=953970 $Y=710215
X2167 30947 30337 44 73 30958 NOR2X1 $T=956080 569485 1 0 $X=955650 $Y=564930
X2168 236 30958 44 73 30963 NOR2X1 $T=956080 577325 0 0 $X=955650 $Y=576935
X2169 30948 30963 44 73 30977 NOR2X1 $T=956640 593005 1 0 $X=956210 $Y=588450
X2170 313 292 44 73 297 NOR2X1 $T=959440 710605 1 0 $X=959010 $Y=706050
X2171 31074 30544 44 73 30959 NOR2X1 $T=962800 647885 0 180 $X=959570 $Y=643330
X2172 30544 31166 44 73 31027 NOR2X1 $T=965040 640045 0 0 $X=964610 $Y=639655
X2173 318 329 44 73 315 NOR2X1 $T=966160 726285 0 0 $X=965730 $Y=725895
X2174 31206 30742 44 73 31028 NOR2X1 $T=968400 624365 0 0 $X=967970 $Y=623975
X2175 29250 31166 44 73 30929 NOR2X1 $T=971200 640045 1 180 $X=967970 $Y=639655
X2176 31206 31327 44 73 31255 NOR2X1 $T=970640 632205 1 0 $X=970210 $Y=627650
X2177 31289 31117 44 73 31065 NOR2X1 $T=974000 632205 1 180 $X=970770 $Y=631815
X2178 311 320 44 73 336 NOR2X1 $T=975680 726285 0 180 $X=972450 $Y=721730
X2179 31455 31489 44 73 31469 NOR2X1 $T=974000 663565 0 0 $X=973570 $Y=663175
X2180 31492 31226 44 73 30919 NOR2X1 $T=978480 608685 1 180 $X=975250 $Y=608295
X2181 31555 31492 44 73 31638 NOR2X1 $T=979040 624365 0 0 $X=978610 $Y=623975
X2182 30544 31450 44 73 31636 NOR2X1 $T=979040 640045 0 0 $X=978610 $Y=639655
X2183 30544 30742 44 73 31625 NOR2X1 $T=982960 616525 1 180 $X=979730 $Y=616135
X2184 31450 31327 44 73 31538 NOR2X1 $T=982960 624365 0 180 $X=979730 $Y=619810
X2185 29250 31074 44 73 31577 NOR2X1 $T=986320 640045 1 180 $X=983090 $Y=639655
X2186 211 158 44 73 31147 NOR2X1 $T=991360 577325 1 0 $X=990930 $Y=572770
X2187 211 165 44 73 31148 NOR2X1 $T=993600 577325 0 0 $X=993170 $Y=576935
X2188 31073 32079 44 73 32260 NOR2X1 $T=998080 624365 0 0 $X=997650 $Y=623975
X2189 31859 32213 44 73 32244 NOR2X1 $T=998080 632205 0 0 $X=997650 $Y=631815
X2190 30920 31972 44 73 32261 NOR2X1 $T=998640 655725 0 0 $X=998210 $Y=655335
X2191 205 165 44 73 32377 NOR2X1 $T=1005360 569485 0 0 $X=1004930 $Y=569095
X2192 32563 32594 44 73 32583 NOR2X1 $T=1009280 538125 0 0 $X=1008850 $Y=537735
X2193 327 32627 44 73 32563 NOR2X1 $T=1010400 545965 1 0 $X=1009970 $Y=541410
X2194 158 205 44 73 32628 NOR2X1 $T=1013200 577325 1 0 $X=1012770 $Y=572770
X2195 32762 364 44 73 31240 NOR2X1 $T=1016000 491085 0 0 $X=1015570 $Y=490695
X2196 32805 32580 44 73 32791 NOR2X1 $T=1019360 514605 0 180 $X=1016130 $Y=510050
X2197 32980 33009 44 73 32993 NOR2X1 $T=1023280 553805 1 0 $X=1022850 $Y=549250
X2198 32981 33010 44 73 375 NOR2X1 $T=1023280 608685 1 0 $X=1022850 $Y=604130
X2199 33011 33047 44 73 33031 NOR2X1 $T=1024400 632205 0 0 $X=1023970 $Y=631815
X2200 33062 33031 44 73 33033 NOR2X1 $T=1027760 663565 0 180 $X=1024530 $Y=659010
X2201 33063 33033 44 73 33020 NOR2X1 $T=1027760 663565 1 180 $X=1024530 $Y=663175
X2202 33102 33012 44 73 33094 NOR2X1 $T=1029440 655725 0 180 $X=1026210 $Y=651170
X2203 33091 33114 44 73 33011 NOR2X1 $T=1027200 632205 1 0 $X=1026770 $Y=627650
X2204 33094 33158 44 73 33101 NOR2X1 $T=1029440 640045 0 0 $X=1029010 $Y=639655
X2205 33274 33219 44 73 33102 NOR2X1 $T=1036720 640045 0 180 $X=1033490 $Y=635490
X2206 33173 33256 44 73 33241 NOR2X1 $T=1034480 655725 1 0 $X=1034050 $Y=651170
X2207 33312 33336 44 73 33063 NOR2X1 $T=1036720 671405 1 0 $X=1036290 $Y=666850
X2208 33091 33227 44 73 33338 NOR2X1 $T=1037280 655725 1 0 $X=1036850 $Y=651170
X2209 33256 33336 44 73 33348 NOR2X1 $T=1037840 671405 0 0 $X=1037410 $Y=671015
X2210 33338 33378 44 73 33256 NOR2X1 $T=1040080 655725 1 0 $X=1039650 $Y=651170
X2211 33425 33406 44 73 33116 NOR2X1 $T=1044560 671405 0 180 $X=1041330 $Y=666850
X2212 33427 33407 44 73 33406 NOR2X1 $T=1044560 679245 0 180 $X=1041330 $Y=674690
X2213 33360 33436 44 73 33425 NOR2X1 $T=1042320 655725 0 0 $X=1041890 $Y=655335
X2214 33201 33386 44 73 33405 NOR2X1 $T=1047360 647885 0 180 $X=1044130 $Y=643330
X2215 33091 33427 44 73 33514 NOR2X1 $T=1050160 679245 0 180 $X=1046930 $Y=674690
X2216 33535 33442 44 73 33524 NOR2X1 $T=1050720 593005 0 180 $X=1047490 $Y=588450
X2217 33328 33227 44 73 33464 NOR2X1 $T=1050720 647885 0 180 $X=1047490 $Y=643330
X2218 33538 33514 44 73 33525 NOR2X1 $T=1050720 679245 1 180 $X=1047490 $Y=678855
X2219 33539 33348 44 73 33526 NOR2X1 $T=1050720 687085 0 180 $X=1047490 $Y=682530
X2220 33488 33361 44 73 33539 NOR2X1 $T=1049040 671405 0 0 $X=1048610 $Y=671015
X2221 33476 33240 44 73 33219 NOR2X1 $T=1050160 632205 0 0 $X=1049730 $Y=631815
X2222 33578 33557 44 73 33567 NOR2X1 $T=1052960 655725 0 180 $X=1049730 $Y=651170
X2223 33473 33609 44 73 33610 NOR2X1 $T=1051840 585165 0 0 $X=1051410 $Y=584775
X2224 33607 33523 44 73 33616 NOR2X1 $T=1055200 577325 1 180 $X=1051970 $Y=576935
X2225 33629 33567 44 73 33270 NOR2X1 $T=1053520 655725 0 0 $X=1053090 $Y=655335
X2226 33650 33578 44 73 33488 NOR2X1 $T=1056320 671405 0 180 $X=1053090 $Y=666850
X2227 33630 33324 44 73 33639 NOR2X1 $T=1053520 687085 0 0 $X=1053090 $Y=686695
X2228 33660 33188 44 73 33557 NOR2X1 $T=1056880 663565 0 180 $X=1053650 $Y=659010
X2229 33091 33386 44 73 33140 NOR2X1 $T=1057440 640045 1 180 $X=1054210 $Y=639655
X2230 33580 33626 44 73 33673 NOR2X1 $T=1058000 632205 0 180 $X=1054770 $Y=627650
X2231 33219 33683 44 73 33690 NOR2X1 $T=1059120 640045 0 180 $X=1055890 $Y=635490
X2232 33476 33650 44 73 33660 NOR2X1 $T=1056880 663565 1 0 $X=1056450 $Y=659010
X2233 33690 33611 44 73 33711 NOR2X1 $T=1060240 640045 1 180 $X=1057010 $Y=639655
X2234 33443 33673 44 73 33683 NOR2X1 $T=1058000 632205 1 0 $X=1057570 $Y=627650
X2235 33700 33717 44 73 33833 NOR2X1 $T=1064160 577325 1 0 $X=1063730 $Y=572770
X2236 33555 33900 44 73 33958 NOR2X1 $T=1071440 561645 0 0 $X=1071010 $Y=561255
X2237 33909 34099 44 73 34100 NOR2X1 $T=1077040 585165 0 0 $X=1076610 $Y=584775
X2238 33843 34053 44 73 34176 NOR2X1 $T=1079840 569485 1 0 $X=1079410 $Y=564930
X2239 169 34251 44 73 33759 NOR2X1 $T=1082080 585165 0 0 $X=1081650 $Y=584775
X2240 33778 34267 44 73 34250 NOR2X1 $T=1082640 577325 1 0 $X=1082210 $Y=572770
X2241 34219 34345 44 73 34335 NOR2X1 $T=1085440 522445 0 0 $X=1085010 $Y=522055
X2242 34380 33975 44 73 34295 NOR2X1 $T=1089360 545965 1 180 $X=1086130 $Y=545575
X2243 34364 34171 44 73 34378 NOR2X1 $T=1087120 522445 1 0 $X=1086690 $Y=517890
X2244 34519 34448 44 73 34433 NOR2X1 $T=1096080 553805 0 180 $X=1092850 $Y=549250
X2245 34407 34486 44 73 34540 NOR2X1 $T=1093840 506765 0 0 $X=1093410 $Y=506375
X2246 83 134 44 73 77 NOR2X1 $T=1170560 679245 0 180 $X=1167330 $Y=674690
X2247 496 37944 44 73 37901 NOR2X1 $T=1229360 553805 0 0 $X=1228930 $Y=553415
X2248 496 38049 44 73 500 NOR2X1 $T=1237760 694925 1 180 $X=1234530 $Y=694535
X2249 38151 38188 44 73 85 NOR2X1 $T=1238320 553805 1 0 $X=1237890 $Y=549250
X2250 38152 38189 44 73 38170 NOR2X1 $T=1238320 577325 0 0 $X=1237890 $Y=576935
X2251 38003 38063 44 73 38291 NOR2X1 $T=1245040 545965 1 180 $X=1241810 $Y=545575
X2252 496 38311 44 73 78 NOR2X1 $T=1242240 569485 1 0 $X=1241810 $Y=564930
X2253 38287 38370 44 73 502 NOR2X1 $T=1244480 600845 0 0 $X=1244050 $Y=600455
X2254 25418 38370 44 73 38049 NOR2X1 $T=1244480 608685 0 0 $X=1244050 $Y=608295
X2255 38068 38006 44 73 38369 NOR2X1 $T=1245040 545965 0 0 $X=1244610 $Y=545575
X2256 38485 38449 44 73 38337 NOR2X1 $T=1251200 624365 0 180 $X=1247970 $Y=619810
X2257 38309 38350 44 73 38528 NOR2X1 $T=1250640 530285 0 0 $X=1250210 $Y=529895
X2258 496 38563 44 73 38543 NOR2X1 $T=1251200 561645 1 0 $X=1250770 $Y=557090
X2259 38565 38589 44 73 38445 NOR2X1 $T=1252320 647885 0 0 $X=1251890 $Y=647495
X2260 503 38516 44 73 38588 NOR2X1 $T=1252880 569485 0 0 $X=1252450 $Y=569095
X2261 38608 38572 44 73 38450 NOR2X1 $T=1255680 632205 1 180 $X=1252450 $Y=631815
X2262 38478 38350 44 73 38609 NOR2X1 $T=1256240 530285 1 180 $X=1253010 $Y=529895
X2263 38309 38326 44 73 38587 NOR2X1 $T=1255120 538125 0 0 $X=1254690 $Y=537735
X2264 38516 38557 44 73 38702 NOR2X1 $T=1256800 553805 1 0 $X=1256370 $Y=549250
X2265 38700 38735 44 73 38023 NOR2X1 $T=1257360 640045 1 0 $X=1256930 $Y=635490
X2266 36564 38529 44 73 38771 NOR2X1 $T=1261840 671405 0 180 $X=1258610 $Y=666850
X2267 38771 38505 44 73 38772 NOR2X1 $T=1261840 671405 1 180 $X=1258610 $Y=671015
X2268 38802 38836 44 73 38822 NOR2X1 $T=1260720 640045 1 0 $X=1260290 $Y=635490
X2269 38763 38555 44 73 38802 NOR2X1 $T=1264640 647885 0 180 $X=1261410 $Y=643330
X2270 38715 39130 44 73 38756 NOR2X1 $T=1269680 647885 1 0 $X=1269250 $Y=643330
X2271 39129 39090 44 73 36158 NOR2X1 $T=1272480 679245 0 180 $X=1269250 $Y=674690
X2272 39221 39192 44 73 39171 NOR2X1 $T=1275280 647885 0 180 $X=1272050 $Y=643330
X2273 39234 39117 44 73 39130 NOR2X1 $T=1275280 655725 0 180 $X=1272050 $Y=651170
X2274 38929 39302 44 73 39245 NOR2X1 $T=1278080 647885 1 180 $X=1274850 $Y=647495
X2275 38765 39355 44 73 39276 NOR2X1 $T=1275840 616525 1 0 $X=1275410 $Y=611970
X2276 32913 38763 44 73 38929 NOR2X1 $T=1280320 640045 0 0 $X=1279890 $Y=639655
X2277 38763 39493 44 73 39407 NOR2X1 $T=1283680 632205 1 180 $X=1280450 $Y=631815
X2278 34118 38715 44 73 39589 NOR2X1 $T=1282560 647885 1 0 $X=1282130 $Y=643330
X2279 39626 39302 44 73 39482 NOR2X1 $T=1285920 608685 0 180 $X=1282690 $Y=604130
X2280 39650 34118 44 73 39395 NOR2X1 $T=1286480 647885 1 180 $X=1283250 $Y=647495
X2281 36564 36949 44 73 39626 NOR2X1 $T=1287040 608685 1 180 $X=1283810 $Y=608295
X2282 36564 39650 44 73 39063 NOR2X1 $T=1289280 632205 1 180 $X=1286050 $Y=631815
X2283 39779 39623 44 73 39333 NOR2X1 $T=1289840 671405 0 180 $X=1286610 $Y=666850
X2284 39628 34347 44 73 39117 NOR2X1 $T=1290400 663565 0 180 $X=1287170 $Y=659010
X2285 32913 39628 44 73 39779 NOR2X1 $T=1288160 663565 0 0 $X=1287730 $Y=663175
X2286 38763 39422 44 73 39302 NOR2X1 $T=1288720 616525 1 0 $X=1288290 $Y=611970
X2287 44 73 78 26084 25866 ICV_81 $T=751680 545965 0 0 $X=751250 $Y=545575
X2288 44 73 82 26485 26428 ICV_81 $T=772400 632205 1 0 $X=771970 $Y=627650
X2289 44 73 96 107 26912 ICV_81 $T=797040 663565 0 0 $X=796610 $Y=663175
X2290 44 73 80 27054 27042 ICV_81 $T=797600 530285 1 0 $X=797170 $Y=525730
X2291 44 73 82 125 27593 ICV_81 $T=822800 655725 0 0 $X=822370 $Y=655335
X2292 44 73 27801 28231 28543 ICV_81 $T=858080 702765 1 0 $X=857650 $Y=698210
X2293 44 73 29619 29646 181 ICV_81 $T=895040 514605 1 0 $X=894610 $Y=510050
X2294 44 73 78 30234 28434 ICV_81 $T=920800 640045 1 0 $X=920370 $Y=635490
X2295 44 73 30247 30744 30734 ICV_81 $T=944320 561645 1 0 $X=943890 $Y=557090
X2296 44 73 30476 271 30232 ICV_81 $T=961680 530285 0 0 $X=961250 $Y=529895
X2297 44 73 31226 31117 31370 ICV_81 $T=968960 608685 0 0 $X=968530 $Y=608295
X2298 44 73 32793 259 32968 ICV_81 $T=1019920 593005 1 0 $X=1019490 $Y=588450
X2299 44 73 33299 33328 33210 ICV_81 $T=1033920 624365 0 0 $X=1033490 $Y=623975
X2300 44 73 32628 33075 33239 ICV_81 $T=1035600 593005 0 0 $X=1035170 $Y=592615
X2301 44 73 312 33589 33565 ICV_81 $T=1050160 514605 1 0 $X=1049730 $Y=510050
X2302 44 73 184 32845 33743 ICV_81 $T=1057440 522445 1 0 $X=1057010 $Y=517890
X2303 44 73 32724 259 33898 ICV_81 $T=1066400 553805 0 0 $X=1065970 $Y=553415
X2304 44 73 184 34174 34152 ICV_81 $T=1077600 561645 1 0 $X=1077170 $Y=557090
X2305 44 73 196 32618 34307 ICV_81 $T=1082080 498925 1 0 $X=1081650 $Y=494370
X2306 44 73 165 34639 33996 ICV_81 $T=1093840 498925 1 0 $X=1093410 $Y=494370
X2307 44 73 34682 35274 35293 ICV_81 $T=1115680 655725 1 0 $X=1115250 $Y=651170
X2308 44 73 82 469 35966 ICV_81 $T=1148720 702765 0 0 $X=1148290 $Y=702375
X2309 44 73 78 36274 35341 ICV_81 $T=1156000 600845 0 0 $X=1155570 $Y=600455
X2310 44 73 89 36270 36332 ICV_81 $T=1159360 647885 0 0 $X=1158930 $Y=647495
X2311 44 73 96 30921 36371 ICV_81 $T=1164400 694925 0 0 $X=1163970 $Y=694535
X2312 44 73 77 492 37566 ICV_81 $T=1213120 726285 1 0 $X=1212690 $Y=721730
X2313 44 73 37960 38068 37921 ICV_81 $T=1232160 545965 0 0 $X=1231730 $Y=545575
X2314 44 73 38530 38684 38664 ICV_81 $T=1253440 530285 1 0 $X=1253010 $Y=525730
X2315 44 73 24284 24329 24306 ICV_76 $T=702400 616525 0 0 $X=701970 $Y=616135
X2316 44 73 24329 24039 24547 ICV_76 $T=713040 616525 1 0 $X=712610 $Y=611970
X2317 44 73 24260 24700 24610 ICV_76 $T=713040 647885 0 0 $X=712610 $Y=647495
X2318 44 73 24691 25660 25643 ICV_76 $T=740480 640045 1 0 $X=740050 $Y=635490
X2319 44 73 25825 25869 25845 ICV_76 $T=746640 545965 1 0 $X=746210 $Y=541410
X2320 44 73 25901 26008 25995 ICV_76 $T=750560 718445 1 0 $X=750130 $Y=713890
X2321 44 73 83 26173 88 ICV_76 $T=758400 718445 0 0 $X=757970 $Y=718055
X2322 44 73 26097 96 26365 ICV_76 $T=765680 647885 1 0 $X=765250 $Y=643330
X2323 44 73 96 26485 26471 ICV_76 $T=774640 640045 0 0 $X=774210 $Y=639655
X2324 44 73 96 26554 26587 ICV_76 $T=778000 663565 0 0 $X=777570 $Y=663175
X2325 44 73 89 26618 26603 ICV_76 $T=778560 616525 0 0 $X=778130 $Y=616135
X2326 44 73 78 26771 26814 ICV_76 $T=794240 530285 1 0 $X=793810 $Y=525730
X2327 44 73 78 26990 26890 ICV_76 $T=796480 498925 0 0 $X=796050 $Y=498535
X2328 44 73 80 26807 26917 ICV_76 $T=798720 491085 1 0 $X=798290 $Y=486530
X2329 44 73 80 27658 27547 ICV_76 $T=821680 569485 0 0 $X=821250 $Y=569095
X2330 44 73 27626 27659 27569 ICV_76 $T=821680 718445 1 0 $X=821250 $Y=713890
X2331 44 73 27674 28097 28050 ICV_76 $T=842400 702765 0 0 $X=841970 $Y=702375
X2332 44 73 28078 28319 28245 ICV_76 $T=851360 702765 0 0 $X=850930 $Y=702375
X2333 44 73 27751 28133 28302 ICV_76 $T=852480 679245 1 0 $X=852050 $Y=674690
X2334 44 73 113 27801 28366 ICV_76 $T=855280 710605 0 0 $X=854850 $Y=710215
X2335 44 73 89 28768 28904 ICV_76 $T=869840 663565 1 0 $X=869410 $Y=659010
X2336 44 73 89 29002 149 ICV_76 $T=872080 702765 1 0 $X=871650 $Y=698210
X2337 44 73 89 29319 29307 ICV_76 $T=883840 710605 1 0 $X=883410 $Y=706050
X2338 44 73 96 157 29331 ICV_76 $T=884400 710605 0 0 $X=883970 $Y=710215
X2339 44 73 29601 183 29620 ICV_76 $T=896160 538125 0 0 $X=895730 $Y=537735
X2340 44 73 29535 29662 29645 ICV_76 $T=897280 624365 0 0 $X=896850 $Y=623975
X2341 44 73 29774 29805 192 ICV_76 $T=902880 585165 1 0 $X=902450 $Y=580610
X2342 44 73 29375 29845 200 ICV_76 $T=905120 491085 0 0 $X=904690 $Y=490695
X2343 44 73 89 29879 214 ICV_76 $T=909040 718445 0 0 $X=908610 $Y=718055
X2344 44 73 30086 30120 28523 ICV_76 $T=916880 569485 1 0 $X=916450 $Y=564930
X2345 44 73 158 30126 238 ICV_76 $T=919680 506765 1 0 $X=919250 $Y=502210
X2346 44 73 80 30146 30159 ICV_76 $T=923040 663565 1 0 $X=922610 $Y=659010
X2347 44 73 89 30245 246 ICV_76 $T=924160 718445 0 0 $X=923730 $Y=718055
X2348 44 73 165 30181 254 ICV_76 $T=930320 514605 0 0 $X=929890 $Y=514215
X2349 44 73 30413 30446 30431 ICV_76 $T=932000 663565 0 0 $X=931570 $Y=663175
X2350 44 73 254 30476 30313 ICV_76 $T=933680 522445 0 0 $X=933250 $Y=522055
X2351 44 73 286 282 30730 ICV_76 $T=945440 522445 1 0 $X=945010 $Y=517890
X2352 44 73 30891 30923 30903 ICV_76 $T=953280 624365 0 0 $X=952850 $Y=623975
X2353 44 73 312 260 30946 ICV_76 $T=958320 530285 0 0 $X=957890 $Y=529895
X2354 44 73 31044 31076 31066 ICV_76 $T=959440 647885 0 0 $X=959010 $Y=647495
X2355 44 73 30929 31074 31044 ICV_76 $T=959440 655725 1 0 $X=959010 $Y=651170
X2356 44 73 293 31193 326 ICV_76 $T=963920 491085 0 0 $X=963490 $Y=490695
X2357 44 73 158 31194 309 ICV_76 $T=963920 522445 1 0 $X=963490 $Y=517890
X2358 44 73 30220 330 31254 ICV_76 $T=966160 498925 1 0 $X=965730 $Y=494370
X2359 44 73 31255 31289 31238 ICV_76 $T=967280 632205 1 0 $X=966850 $Y=627650
X2360 44 73 328 311 31287 ICV_76 $T=967840 718445 0 0 $X=967410 $Y=718055
X2361 44 73 30544 31327 31191 ICV_76 $T=968400 616525 1 0 $X=967970 $Y=611970
X2362 44 73 32283 183 32322 ICV_76 $T=999760 545965 0 0 $X=999330 $Y=545575
X2363 44 73 32377 32792 32727 ICV_76 $T=1016000 577325 1 0 $X=1015570 $Y=572770
X2364 44 73 302 376 32957 ICV_76 $T=1022160 498925 0 0 $X=1021730 $Y=498535
X2365 44 73 243 32832 32979 ICV_76 $T=1022160 522445 0 0 $X=1021730 $Y=522055
X2366 44 73 158 30581 33029 ICV_76 $T=1023840 577325 1 0 $X=1023410 $Y=572770
X2367 44 73 217 33093 32965 ICV_76 $T=1025520 538125 0 0 $X=1025090 $Y=537735
X2368 44 73 33113 33188 33147 ICV_76 $T=1029440 663565 0 0 $X=1029010 $Y=663175
X2369 44 73 33104 33279 391 ICV_76 $T=1033360 514605 1 0 $X=1032930 $Y=510050
X2370 44 73 33327 33429 399 ICV_76 $T=1041200 506765 1 0 $X=1040770 $Y=502210
X2371 44 73 33404 33274 33403 ICV_76 $T=1041200 632205 1 0 $X=1040770 $Y=627650
X2372 44 73 78 33465 33301 ICV_76 $T=1043440 694925 0 0 $X=1043010 $Y=694535
X2373 44 73 302 356 33474 ICV_76 $T=1044560 498925 0 0 $X=1044130 $Y=498535
X2374 44 73 302 33522 33513 ICV_76 $T=1046800 514605 1 0 $X=1046370 $Y=510050
X2375 44 73 33393 33541 407 ICV_76 $T=1047920 545965 0 0 $X=1047490 $Y=545575
X2376 44 73 33212 408 33589 ICV_76 $T=1050160 514605 0 0 $X=1049730 $Y=514215
X2377 44 73 165 33242 408 ICV_76 $T=1054080 530285 1 0 $X=1053650 $Y=525730
X2378 44 73 289 33692 33680 ICV_76 $T=1055200 514605 1 0 $X=1054770 $Y=510050
X2379 44 73 424 430 32613 ICV_76 $T=1062480 498925 1 0 $X=1062050 $Y=494370
X2380 44 73 33767 33823 33807 ICV_76 $T=1062480 647885 0 0 $X=1062050 $Y=647495
X2381 44 73 165 28750 33728 ICV_76 $T=1063040 522445 0 0 $X=1062610 $Y=522055
X2382 44 73 33188 33386 33844 ICV_76 $T=1064160 663565 1 0 $X=1063730 $Y=659010
X2383 44 73 33524 33959 438 ICV_76 $T=1070320 593005 1 0 $X=1069890 $Y=588450
X2384 44 73 184 33435 33997 ICV_76 $T=1072000 553805 1 0 $X=1071570 $Y=549250
X2385 44 73 33519 220 34093 ICV_76 $T=1076480 577325 0 0 $X=1076050 $Y=576935
X2386 44 73 33649 220 34116 ICV_76 $T=1077040 569485 0 0 $X=1076610 $Y=569095
X2387 44 73 196 33995 34308 ICV_76 $T=1083760 506765 1 0 $X=1083330 $Y=502210
X2388 44 73 34129 183 34450 ICV_76 $T=1089360 506765 0 0 $X=1088930 $Y=506375
X2389 44 73 80 34408 34353 ICV_76 $T=1090480 687085 1 0 $X=1090050 $Y=682530
X2390 44 73 78 34640 33978 ICV_76 $T=1095520 687085 0 0 $X=1095090 $Y=686695
X2391 44 73 89 34947 34932 ICV_76 $T=1106160 718445 0 0 $X=1105730 $Y=718055
X2392 44 73 80 35294 35274 ICV_76 $T=1116800 640045 0 0 $X=1116370 $Y=639655
X2393 44 73 89 35330 35504 ICV_76 $T=1125200 702765 1 0 $X=1124770 $Y=698210
X2394 44 73 78 35590 34520 ICV_76 $T=1129120 624365 1 0 $X=1128690 $Y=619810
X2395 44 73 80 35751 35674 ICV_76 $T=1135840 600845 0 0 $X=1135410 $Y=600455
X2396 44 73 82 35984 36397 ICV_76 $T=1172800 694925 1 0 $X=1172370 $Y=690370
X2397 44 73 89 36549 36686 ICV_76 $T=1178960 608685 0 0 $X=1178530 $Y=608295
X2398 44 73 82 36578 36593 ICV_76 $T=1181760 663565 1 0 $X=1181330 $Y=659010
X2399 44 73 83 37243 486 ICV_76 $T=1200800 726285 1 0 $X=1200370 $Y=721730
X2400 44 73 80 37347 37260 ICV_76 $T=1203040 522445 0 0 $X=1202610 $Y=522055
X2401 44 73 89 37257 37496 ICV_76 $T=1208080 616525 0 0 $X=1207650 $Y=616135
X2402 44 73 37921 37945 37936 ICV_76 $T=1228800 545965 0 0 $X=1228370 $Y=545575
X2403 44 73 83 37935 37991 ICV_76 $T=1231600 702765 1 0 $X=1231170 $Y=698210
X2404 44 73 77 501 38081 ICV_76 $T=1234960 702765 0 0 $X=1234530 $Y=702375
X2405 44 73 38497 38531 38391 ICV_76 $T=1249520 538125 1 0 $X=1249090 $Y=533570
X2406 44 73 78 38528 38530 ICV_76 $T=1250080 530285 1 0 $X=1249650 $Y=525730
X2407 44 73 36949 38666 38608 ICV_76 $T=1254560 632205 1 0 $X=1254130 $Y=627650
X2408 44 73 39234 38929 39277 ICV_76 $T=1275280 655725 1 0 $X=1274850 $Y=651170
X2409 44 73 39117 32913 39794 ICV_76 $T=1287600 616525 0 0 $X=1287170 $Y=616135
X2410 44 73 39820 39865 39149 ICV_76 $T=1288720 624365 0 0 $X=1288290 $Y=623975
X2411 24076 24009 23959 44 73 23934 NAND3X1 $T=699600 624365 1 180 $X=695250 $Y=623975
X2412 24190 24013 24075 44 73 24101 NAND3X1 $T=702400 608685 1 180 $X=698050 $Y=608295
X2413 23987 24180 24237 44 73 24215 NAND3X1 $T=699040 647885 0 0 $X=698610 $Y=647495
X2414 24330 24385 24417 44 73 24416 NAND3X1 $T=704080 632205 1 0 $X=703650 $Y=627650
X2415 24180 24347 24284 44 73 24418 NAND3X1 $T=704080 640045 0 0 $X=703650 $Y=639655
X2416 24565 24510 24459 44 73 24458 NAND3X1 $T=711920 616525 1 180 $X=707570 $Y=616135
X2417 24481 24530 24264 44 73 24565 NAND3X1 $T=708000 632205 1 0 $X=707570 $Y=627650
X2418 23965 24479 24589 44 73 24566 NAND3X1 $T=708000 647885 1 0 $X=707570 $Y=643330
X2419 24750 24599 24653 44 73 24503 NAND3X1 $T=716960 593005 0 180 $X=712610 $Y=588450
X2420 24330 24531 24264 44 73 24792 NAND3X1 $T=714160 608685 0 0 $X=713730 $Y=608295
X2421 24752 24814 24215 44 73 24839 NAND3X1 $T=715280 655725 1 0 $X=714850 $Y=651170
X2422 24862 24813 24530 44 73 24076 NAND3X1 $T=719760 624365 1 180 $X=715410 $Y=623975
X2423 24673 24831 24882 44 73 24840 NAND3X1 $T=715840 640045 0 0 $X=715410 $Y=639655
X2424 24751 24329 24796 44 73 24923 NAND3X1 $T=723680 600845 1 180 $X=719330 $Y=600455
X2425 24862 24813 24195 44 73 25083 NAND3X1 $T=722560 624365 0 0 $X=722130 $Y=623975
X2426 25031 25061 24796 44 73 25154 NAND3X1 $T=724800 600845 0 0 $X=724370 $Y=600455
X2427 25251 24284 24039 44 73 25213 NAND3X1 $T=731520 616525 1 180 $X=727170 $Y=616135
X2428 24746 25213 25364 44 73 25303 NAND3X1 $T=731520 616525 0 0 $X=731090 $Y=616135
X2429 25345 25231 25365 44 73 25419 NAND3X1 $T=732640 655725 1 0 $X=732210 $Y=651170
X2430 25251 24038 24751 44 73 25511 NAND3X1 $T=735440 616525 0 0 $X=735010 $Y=616135
X2431 25511 24792 25321 44 73 25458 NAND3X1 $T=739920 608685 0 180 $X=735570 $Y=604130
X2432 24862 25539 24530 44 73 25540 NAND3X1 $T=737120 632205 1 0 $X=736690 $Y=627650
X2433 25992 26241 26231 44 73 26256 NAND3X1 $T=759520 671405 0 0 $X=759090 $Y=671015
X2434 26240 26356 26325 44 73 26338 NAND3X1 $T=769600 663565 0 180 $X=765250 $Y=659010
X2435 26365 26370 26314 44 73 26349 NAND3X1 $T=770160 647885 1 180 $X=765810 $Y=647495
X2436 26304 26428 26452 44 73 26444 NAND3X1 $T=768480 632205 1 0 $X=768050 $Y=627650
X2437 26445 26471 26474 44 73 26464 NAND3X1 $T=770720 640045 0 0 $X=770290 $Y=639655
X2438 26714 26733 26699 44 73 26715 NAND3X1 $T=789200 640045 1 180 $X=784850 $Y=639655
X2439 26806 26779 26606 44 73 26759 NAND3X1 $T=791440 655725 0 180 $X=787090 $Y=651170
X2440 26881 26900 26936 44 73 26925 NAND3X1 $T=793120 640045 1 0 $X=792690 $Y=635490
X2441 26787 26912 26938 44 73 26926 NAND3X1 $T=793120 663565 0 0 $X=792690 $Y=663175
X2442 26677 26865 26974 44 73 26937 NAND3X1 $T=794800 624365 0 0 $X=794370 $Y=623975
X2443 27441 27398 27365 44 73 26740 NAND3X1 $T=816080 694925 1 180 $X=811730 $Y=694535
X2444 27425 27415 27378 44 73 27388 NAND3X1 $T=816640 640045 1 180 $X=812290 $Y=639655
X2445 27529 27501 27468 44 73 27455 NAND3X1 $T=820000 710605 0 180 $X=815650 $Y=706050
X2446 27554 27524 27489 44 73 27508 NAND3X1 $T=821120 671405 1 180 $X=816770 $Y=671015
X2447 27593 27439 27444 44 73 27544 NAND3X1 $T=822800 655725 1 180 $X=818450 $Y=655335
X2448 27686 27579 27604 44 73 27510 NAND3X1 $T=826160 718445 1 180 $X=821810 $Y=718055
X2449 27654 27858 27711 44 73 27881 NAND3X1 $T=830080 694925 1 0 $X=829650 $Y=690370
X2450 27890 27784 27819 44 73 27837 NAND3X1 $T=834560 655725 1 180 $X=830210 $Y=655335
X2451 27891 27751 27820 44 73 27578 NAND3X1 $T=834560 702765 0 180 $X=830210 $Y=698210
X2452 27966 27943 27779 44 73 132 NAND3X1 $T=838480 702765 1 180 $X=834130 $Y=702375
X2453 27956 28026 28067 44 73 28018 NAND3X1 $T=838480 710605 0 0 $X=838050 $Y=710215
X2454 27918 119 27859 44 73 28059 NAND3X1 $T=839600 694925 1 0 $X=839170 $Y=690370
X2455 28087 28059 28017 44 73 28006 NAND3X1 $T=844080 694925 1 180 $X=839730 $Y=694535
X2456 28086 27881 28153 44 73 27880 NAND3X1 $T=842400 679245 0 0 $X=841970 $Y=678855
X2457 28154 27918 136 44 73 137 NAND3X1 $T=846880 726285 0 180 $X=842530 $Y=721730
X2458 28154 28078 136 44 73 27468 NAND3X1 $T=847440 710605 1 180 $X=843090 $Y=710215
X2459 139 113 126 44 73 138 NAND3X1 $T=847440 726285 1 180 $X=843090 $Y=725895
X2460 28181 27918 126 44 73 28086 NAND3X1 $T=850240 679245 1 180 $X=845890 $Y=678855
X2461 28154 28078 27945 44 73 28026 NAND3X1 $T=851360 710605 1 180 $X=847010 $Y=710215
X2462 28197 113 27751 44 73 28017 NAND3X1 $T=852480 687085 0 180 $X=848130 $Y=682530
X2463 28174 142 27859 44 73 28073 NAND3X1 $T=853040 718445 1 180 $X=848690 $Y=718055
X2464 122 28133 27859 44 73 27674 NAND3X1 $T=855280 710605 1 180 $X=850930 $Y=710215
X2465 113 28319 28231 44 73 28340 NAND3X1 $T=858080 702765 0 180 $X=853730 $Y=698210
X2466 28402 28371 28340 44 73 28005 NAND3X1 $T=858640 694925 0 180 $X=854290 $Y=690370
X2467 28413 28328 28366 44 73 28379 NAND3X1 $T=859760 718445 0 180 $X=855410 $Y=713890
X2468 29295 29104 29054 44 73 155 NAND3X1 $T=885520 726285 0 180 $X=881170 $Y=721730
X2469 29374 29331 29307 44 73 159 NAND3X1 $T=888880 718445 1 180 $X=884530 $Y=718055
X2470 29493 29441 28904 44 73 29436 NAND3X1 $T=893920 710605 0 180 $X=889570 $Y=706050
X2471 29534 173 179 44 73 29547 NAND3X1 $T=893920 530285 1 0 $X=893490 $Y=525730
X2472 29657 29697 29735 44 73 29722 NAND3X1 $T=898960 577325 0 0 $X=898530 $Y=576935
X2473 29620 29716 29747 44 73 29597 NAND3X1 $T=899520 538125 0 0 $X=899090 $Y=537735
X2474 29748 29761 29802 44 73 29803 NAND3X1 $T=902320 561645 0 0 $X=901890 $Y=561255
X2475 29806 201 29536 44 73 208 NAND3X1 $T=905120 726285 0 0 $X=904690 $Y=725895
X2476 29923 29891 29834 44 73 29871 NAND3X1 $T=911840 561645 0 180 $X=907490 $Y=557090
X2477 29870 29922 29997 44 73 29981 NAND3X1 $T=910160 522445 0 0 $X=909730 $Y=522055
X2478 30000 29992 29954 44 73 29925 NAND3X1 $T=915760 561645 0 180 $X=911410 $Y=557090
X2479 222 29982 229 44 73 30068 NAND3X1 $T=914080 506765 0 0 $X=913650 $Y=506375
X2480 30046 233 30119 44 73 30094 NAND3X1 $T=916320 538125 1 0 $X=915890 $Y=533570
X2481 228 30078 30139 44 73 30125 NAND3X1 $T=916880 522445 1 0 $X=916450 $Y=517890
X2482 30156 247 30287 44 73 30275 NAND3X1 $T=924160 522445 0 0 $X=923730 $Y=522055
X2483 29938 30297 30344 44 73 30336 NAND3X1 $T=926960 545965 0 0 $X=926530 $Y=545575
X2484 30364 30081 30296 44 73 30311 NAND3X1 $T=932000 545965 0 180 $X=927650 $Y=541410
X2485 30229 30404 30441 44 73 30427 NAND3X1 $T=930880 514605 1 0 $X=930450 $Y=510050
X2486 30372 30299 30442 44 73 30428 NAND3X1 $T=930880 577325 1 0 $X=930450 $Y=572770
X2487 256 30435 30468 44 73 30457 NAND3X1 $T=932000 530285 1 0 $X=931570 $Y=525730
X2488 30508 30458 30396 44 73 30469 NAND3X1 $T=938720 545965 1 180 $X=934370 $Y=545575
X2489 30509 30485 29984 44 73 30470 NAND3X1 $T=938720 561645 0 180 $X=934370 $Y=557090
X2490 29941 30521 30543 44 73 30490 NAND3X1 $T=935920 585165 0 0 $X=935490 $Y=584775
X2491 30573 30566 30649 44 73 30623 NAND3X1 $T=940400 561645 1 0 $X=939970 $Y=557090
X2492 30631 30599 30272 44 73 30615 NAND3X1 $T=944320 593005 1 180 $X=939970 $Y=592615
X2493 30633 281 30568 44 73 30510 NAND3X1 $T=944320 726285 1 180 $X=939970 $Y=725895
X2494 30685 284 30580 44 73 30530 NAND3X1 $T=946560 491085 0 180 $X=942210 $Y=486530
X2495 30657 30656 30622 44 73 30595 NAND3X1 $T=946560 577325 0 180 $X=942210 $Y=572770
X2496 289 30440 30593 44 73 30674 NAND3X1 $T=948240 545965 1 180 $X=943890 $Y=545575
X2497 30678 288 30730 44 73 30731 NAND3X1 $T=944880 522445 0 0 $X=944450 $Y=522055
X2498 30777 30752 30716 44 73 30686 NAND3X1 $T=951040 553805 0 180 $X=946690 $Y=549250
X2499 30790 295 292 44 73 30568 NAND3X1 $T=951600 726285 1 180 $X=947250 $Y=725895
X2500 30759 30799 30835 44 73 30335 NAND3X1 $T=948800 530285 0 0 $X=948370 $Y=529895
X2501 30582 30800 30674 44 73 30814 NAND3X1 $T=948800 577325 0 0 $X=948370 $Y=576935
X2502 294 30808 30816 44 73 30839 NAND3X1 $T=949360 718445 0 0 $X=948930 $Y=718055
X2503 30834 30872 30715 44 73 30890 NAND3X1 $T=951600 506765 0 0 $X=951170 $Y=506375
X2504 30902 30873 30776 44 73 30855 NAND3X1 $T=956080 545965 1 180 $X=951730 $Y=545575
X2505 30892 30929 30959 44 73 30938 NAND3X1 $T=953840 640045 0 0 $X=953410 $Y=639655
X2506 30999 30971 30768 44 73 30947 NAND3X1 $T=960000 561645 1 180 $X=955650 $Y=561255
X2507 31000 30843 30879 44 73 30948 NAND3X1 $T=960000 585165 0 180 $X=955650 $Y=580610
X2508 30956 30853 30997 44 73 31009 NAND3X1 $T=956640 506765 1 0 $X=956210 $Y=502210
X2509 31010 30983 30946 44 73 30707 NAND3X1 $T=960560 538125 1 180 $X=956210 $Y=537735
X2510 317 30934 30852 44 73 30976 NAND3X1 $T=961120 491085 0 180 $X=956770 $Y=486530
X2511 30976 30854 31042 44 73 30998 NAND3X1 $T=957200 522445 0 0 $X=956770 $Y=522055
X2512 31012 31052 31011 44 73 31073 NAND3X1 $T=958880 632205 1 0 $X=958450 $Y=627650
X2513 31043 31051 30836 44 73 31058 NAND3X1 $T=963360 553805 0 180 $X=959010 $Y=549250
X2514 285 280 313 44 73 31061 NAND3X1 $T=963360 718445 0 180 $X=959010 $Y=713890
X2515 31089 31127 31163 44 73 30443 NAND3X1 $T=961680 569485 1 0 $X=961250 $Y=564930
X2516 30655 31108 325 44 73 31127 NAND3X1 $T=962240 545965 0 0 $X=961810 $Y=545575
X2517 30917 31132 31133 44 73 31059 NAND3X1 $T=962240 577325 1 0 $X=961810 $Y=572770
X2518 31189 31157 31099 44 73 30606 NAND3X1 $T=967280 506765 1 180 $X=962930 $Y=506375
X2519 31134 31040 296 44 73 31167 NAND3X1 $T=967280 718445 0 180 $X=962930 $Y=713890
X2520 31224 31178 31146 44 73 30856 NAND3X1 $T=968400 561645 1 180 $X=964050 $Y=561255
X2521 31239 31206 31166 44 73 31076 NAND3X1 $T=968960 647885 0 180 $X=964610 $Y=643330
X2522 31268 31233 31081 44 73 31213 NAND3X1 $T=970080 655725 1 180 $X=965730 $Y=655335
X2523 31287 31258 31179 44 73 31358 NAND3X1 $T=968960 710605 1 0 $X=968530 $Y=706050
X2524 31412 31373 31321 44 73 30936 NAND3X1 $T=974560 514605 0 180 $X=970210 $Y=510050
X2525 31413 31370 31206 44 73 31268 NAND3X1 $T=974560 616525 1 180 $X=970210 $Y=616135
X2526 31202 31028 31327 44 73 31415 NAND3X1 $T=970640 663565 1 0 $X=970210 $Y=659010
X2527 31269 31415 31559 44 73 31455 NAND3X1 $T=974560 663565 1 0 $X=974130 $Y=659010
X2528 31555 31074 31399 44 73 31488 NAND3X1 $T=979040 640045 1 180 $X=974690 $Y=639655
X2529 297 320 30820 44 73 342 NAND3X1 $T=981840 726285 0 180 $X=977490 $Y=721730
X2530 31220 31625 31399 44 73 31559 NAND3X1 $T=982400 663565 0 180 $X=978050 $Y=659010
X2531 31552 31775 30815 44 73 31782 NAND3X1 $T=982400 663565 1 0 $X=981970 $Y=659010
X2532 31487 31832 31634 44 73 31859 NAND3X1 $T=984080 616525 1 0 $X=983650 $Y=611970
X2533 31809 31206 31289 44 73 31801 NAND3X1 $T=988560 632205 0 180 $X=984210 $Y=627650
X2534 343 31508 31834 44 73 346 NAND3X1 $T=985200 726285 1 0 $X=984770 $Y=721730
X2535 31538 31781 30815 44 73 31994 NAND3X1 $T=988560 640045 1 0 $X=988130 $Y=635490
X2536 31989 31992 29250 44 73 31993 NAND3X1 $T=994720 616525 1 180 $X=990370 $Y=616135
X2537 31993 31801 32054 44 73 32079 NAND3X1 $T=991360 624365 0 0 $X=990930 $Y=623975
X2538 31577 31625 30815 44 73 32054 NAND3X1 $T=995280 632205 1 180 $X=990930 $Y=631815
X2539 31635 32062 31994 44 73 32213 NAND3X1 $T=995280 640045 1 0 $X=994850 $Y=635490
X2540 32259 32135 158 44 73 32212 NAND3X1 $T=1000880 577325 1 180 $X=996530 $Y=576935
X2541 32212 32225 32302 44 73 32283 NAND3X1 $T=997520 569485 0 0 $X=997090 $Y=569095
X2542 32243 32291 165 44 73 32318 NAND3X1 $T=998640 585165 1 0 $X=998210 $Y=580610
X2543 32261 32101 31782 44 73 32343 NAND3X1 $T=999200 663565 0 0 $X=998770 $Y=663175
X2544 32282 32333 32301 44 73 32317 NAND3X1 $T=999760 561645 1 0 $X=999330 $Y=557090
X2545 32452 32408 236 44 73 32332 NAND3X1 $T=1007040 553805 0 180 $X=1002690 $Y=549250
X2546 32400 32443 211 44 73 32433 NAND3X1 $T=1003680 491085 0 0 $X=1003250 $Y=490695
X2547 32433 352 32517 44 73 32369 NAND3X1 $T=1004800 498925 1 0 $X=1004370 $Y=494370
X2548 32646 32434 32561 44 73 32580 NAND3X1 $T=1013760 506765 1 180 $X=1009410 $Y=506375
X2549 357 32359 32562 44 73 32581 NAND3X1 $T=1013760 522445 1 180 $X=1009410 $Y=522055
X2550 32471 32647 32696 44 73 32439 NAND3X1 $T=1010960 553805 0 0 $X=1010530 $Y=553415
X2551 32322 32769 32725 44 73 32774 NAND3X1 $T=1014880 545965 0 0 $X=1014450 $Y=545575
X2552 32807 32648 32727 44 73 32518 NAND3X1 $T=1019360 569485 0 180 $X=1015010 $Y=564930
X2553 32775 32519 32629 44 73 32793 NAND3X1 $T=1019920 593005 0 180 $X=1015570 $Y=588450
X2554 32843 32801 211 44 73 32775 NAND3X1 $T=1020480 577325 1 180 $X=1016130 $Y=576935
X2555 32879 32838 32790 44 73 32805 NAND3X1 $T=1021600 506765 0 180 $X=1017250 $Y=502210
X2556 32843 32929 158 44 73 32966 NAND3X1 $T=1020480 577325 0 0 $X=1020050 $Y=576935
X2557 32998 32957 32912 44 73 32762 NAND3X1 $T=1025520 491085 1 180 $X=1021170 $Y=490695
X2558 32946 32769 33028 44 73 32980 NAND3X1 $T=1022160 545965 0 0 $X=1021730 $Y=545575
X2559 32967 33004 33041 44 73 33010 NAND3X1 $T=1022720 600845 1 0 $X=1022290 $Y=596290
X2560 33044 33005 32934 44 73 32978 NAND3X1 $T=1027200 514605 1 180 $X=1022850 $Y=514215
X2561 32982 33020 33064 44 73 29846 NAND3X1 $T=1023280 679245 1 0 $X=1022850 $Y=674690
X2562 32966 32648 33090 44 73 33030 NAND3X1 $T=1024400 577325 0 0 $X=1023970 $Y=576935
X2563 33101 33055 33032 44 73 28035 NAND3X1 $T=1029440 640045 1 180 $X=1025090 $Y=639655
X2564 33074 33168 33195 44 73 33197 NAND3X1 $T=1029440 530285 0 0 $X=1029010 $Y=529895
X2565 33210 33179 33139 44 73 33158 NAND3X1 $T=1033920 624365 1 180 $X=1029570 $Y=623975
X2566 33255 32520 33186 44 73 33226 NAND3X1 $T=1035600 585165 1 180 $X=1031250 $Y=584775
X2567 33298 33378 33405 44 73 33391 NAND3X1 $T=1038960 647885 1 0 $X=1038530 $Y=643330
X2568 33412 33344 33334 44 73 33424 NAND3X1 $T=1045680 577325 1 180 $X=1041330 $Y=576935
X2569 33126 33416 33358 44 73 33442 NAND3X1 $T=1041760 593005 1 0 $X=1041330 $Y=588450
X2570 33386 33240 33201 44 73 33436 NAND3X1 $T=1043440 640045 0 0 $X=1043010 $Y=639655
X2571 317 33359 405 44 73 33493 NAND3X1 $T=1046240 491085 1 0 $X=1045810 $Y=486530
X2572 33493 33513 33546 44 73 33535 NAND3X1 $T=1046800 506765 0 0 $X=1046370 $Y=506375
X2573 33590 33563 33515 44 73 32981 NAND3X1 $T=1053520 561645 1 180 $X=1049170 $Y=561255
X2574 33566 33391 33628 44 73 33611 NAND3X1 $T=1050720 647885 1 0 $X=1050290 $Y=643330
X2575 33537 33557 33578 44 73 33566 NAND3X1 $T=1052960 655725 1 0 $X=1052530 $Y=651170
X2576 33672 33526 33612 44 73 33630 NAND3X1 $T=1057440 687085 0 180 $X=1053090 $Y=682530
X2577 32552 33670 33669 44 73 33717 NAND3X1 $T=1056320 561645 1 0 $X=1055890 $Y=557090
X2578 33718 33697 33608 44 73 33700 NAND3X1 $T=1060240 577325 0 180 $X=1055890 $Y=572770
X2579 33219 33386 33091 44 73 33628 NAND3X1 $T=1060800 647885 0 180 $X=1056450 $Y=643330
X2580 33082 33748 33374 44 73 33767 NAND3X1 $T=1059120 655725 1 0 $X=1058690 $Y=651170
X2581 33173 33091 33476 44 73 33745 NAND3X1 $T=1059120 663565 0 0 $X=1058690 $Y=663175
X2582 33732 33743 33766 44 73 33778 NAND3X1 $T=1059680 514605 1 0 $X=1059250 $Y=510050
X2583 33657 33775 33785 44 73 33758 NAND3X1 $T=1060240 577325 1 0 $X=1059810 $Y=572770
X2584 33786 33763 33721 44 73 33746 NAND3X1 $T=1064160 671405 1 180 $X=1059810 $Y=671015
X2585 33854 33710 33727 44 73 33839 NAND3X1 $T=1067520 569485 0 180 $X=1063170 $Y=564930
X2586 33865 33744 33627 44 73 33843 NAND3X1 $T=1068080 569485 1 180 $X=1063730 $Y=569095
X2587 33719 33800 33913 44 73 33909 NAND3X1 $T=1066960 538125 0 0 $X=1066530 $Y=537735
X2588 33998 33997 33945 44 73 34053 NAND3X1 $T=1073680 561645 1 0 $X=1073250 $Y=557090
X2589 34083 442 33952 44 73 34025 NAND3X1 $T=1078720 506765 1 180 $X=1074370 $Y=506375
X2590 34130 34093 33948 44 73 34099 NAND3X1 $T=1080400 585165 0 180 $X=1076050 $Y=580610
X2591 34114 33974 33908 44 73 34171 NAND3X1 $T=1078160 498925 1 0 $X=1077730 $Y=494370
X2592 34115 34148 33893 44 73 34173 NAND3X1 $T=1078160 530285 1 0 $X=1077730 $Y=525730
X2593 34041 34152 34056 44 73 34175 NAND3X1 $T=1078160 561645 0 0 $X=1077730 $Y=561255
X2594 34142 34039 34218 44 73 33009 NAND3X1 $T=1079280 545965 1 0 $X=1078850 $Y=541410
X2595 34229 385 441 44 73 34302 NAND3X1 $T=1082640 514605 1 0 $X=1082210 $Y=510050
X2596 34304 33999 34116 44 73 34267 NAND3X1 $T=1086560 569485 1 180 $X=1082210 $Y=569095
X2597 439 34172 34301 44 73 34345 NAND3X1 $T=1086560 514605 1 0 $X=1086130 $Y=510050
X2598 34459 451 34288 44 73 34448 NAND3X1 $T=1093280 553805 0 180 $X=1088930 $Y=549250
X2599 34376 34377 452 44 73 34486 NAND3X1 $T=1089920 491085 0 0 $X=1089490 $Y=490695
X2600 450 34449 34307 44 73 34487 NAND3X1 $T=1089920 498925 1 0 $X=1089490 $Y=494370
X2601 34446 34456 34281 44 73 34364 NAND3X1 $T=1093840 522445 0 180 $X=1089490 $Y=517890
X2602 34419 34346 34522 44 73 34519 NAND3X1 $T=1091040 545965 1 0 $X=1090610 $Y=541410
X2603 34651 458 34932 44 73 459 NAND3X1 $T=1102800 726285 1 0 $X=1102370 $Y=721730
X2604 462 35598 35569 44 73 461 NAND3X1 $T=1134160 718445 0 180 $X=1129810 $Y=713890
X2605 35801 35769 35504 44 73 35748 NAND3X1 $T=1141440 702765 0 180 $X=1137090 $Y=698210
X2606 35812 35778 35747 44 73 35763 NAND3X1 $T=1142000 679245 1 180 $X=1137650 $Y=678855
X2607 35966 35864 35888 44 73 35913 NAND3X1 $T=1148720 702765 1 180 $X=1144370 $Y=702375
X2608 36071 36212 36247 44 73 36234 NAND3X1 $T=1155440 647885 0 0 $X=1155010 $Y=647495
X2609 36088 36242 36272 44 73 36260 NAND3X1 $T=1156560 671405 0 0 $X=1156130 $Y=671015
X2610 36275 36252 36218 44 73 36235 NAND3X1 $T=1161600 710605 0 180 $X=1157250 $Y=706050
X2611 36397 36371 36332 44 73 36376 NAND3X1 $T=1167200 687085 1 180 $X=1162850 $Y=686695
X2612 36359 36271 36426 44 73 36416 NAND3X1 $T=1164400 624365 0 0 $X=1163970 $Y=623975
X2613 36366 36441 36331 44 73 36460 NAND3X1 $T=1166640 663565 1 0 $X=1166210 $Y=659010
X2614 36593 36560 36531 44 73 36538 NAND3X1 $T=1177280 663565 1 180 $X=1172930 $Y=663175
X2615 36685 36738 36686 44 73 36713 NAND3X1 $T=1185120 640045 0 180 $X=1180770 $Y=635490
X2616 36934 36903 36866 44 73 36882 NAND3X1 $T=1191840 624365 1 180 $X=1187490 $Y=623975
X2617 36868 36759 37065 44 73 37061 NAND3X1 $T=1191280 647885 0 0 $X=1190850 $Y=647495
X2618 37478 37348 37360 44 73 37417 NAND3X1 $T=1209760 640045 1 180 $X=1205410 $Y=639655
X2619 37565 37535 37496 44 73 37510 NAND3X1 $T=1213120 632205 0 180 $X=1208770 $Y=627650
X2620 37663 37672 37686 44 73 37702 NAND3X1 $T=1216480 624365 0 0 $X=1216050 $Y=623975
X2621 37719 37645 37673 44 73 37688 NAND3X1 $T=1221520 647885 0 180 $X=1217170 $Y=643330
X2622 37818 37687 37755 44 73 37766 NAND3X1 $T=1226560 640045 1 180 $X=1222210 $Y=639655
X2623 78 38063 37944 44 73 37945 NAND3X1 $T=1238320 553805 0 180 $X=1233970 $Y=549250
X2624 38337 38298 38261 44 73 37981 NAND3X1 $T=1246160 624365 0 180 $X=1241810 $Y=619810
X2625 38369 38003 25418 44 73 38151 NAND3X1 $T=1247280 553805 1 180 $X=1242930 $Y=553415
X2626 78 38350 38291 44 73 38310 NAND3X1 $T=1247840 530285 1 180 $X=1243490 $Y=529895
X2627 38479 38445 38401 44 73 38024 NAND3X1 $T=1251200 647885 1 180 $X=1246850 $Y=647495
X2628 38587 38557 38516 44 73 38188 NAND3X1 $T=1255120 553805 0 180 $X=1250770 $Y=549250
X2629 38588 38360 38517 44 73 38370 NAND3X1 $T=1255120 585165 0 180 $X=1250770 $Y=580610
X2630 38564 38572 38635 44 73 38392 NAND3X1 $T=1252320 616525 0 0 $X=1251890 $Y=616135
X2631 38590 38525 38572 44 73 38545 NAND3X1 $T=1253440 655725 1 0 $X=1253010 $Y=651170
X2632 38679 38733 38600 44 73 38683 NAND3X1 $T=1261280 608685 0 180 $X=1256930 $Y=604130
X2633 38770 38731 38683 44 73 38589 NAND3X1 $T=1261280 647885 1 180 $X=1256930 $Y=647495
X2634 38679 38763 34480 44 73 38789 NAND3X1 $T=1257920 616525 1 0 $X=1257490 $Y=611970
X2635 38505 38764 38721 44 73 38790 NAND3X1 $T=1257920 632205 1 0 $X=1257490 $Y=627650
X2636 78 38811 38557 44 73 38788 NAND3X1 $T=1264080 545965 1 180 $X=1259730 $Y=545575
X2637 78 38701 38609 44 73 38820 NAND3X1 $T=1265200 530285 1 180 $X=1260850 $Y=529895
X2638 38822 38863 38789 44 73 38700 NAND3X1 $T=1265760 632205 1 180 $X=1261410 $Y=631815
X2639 38847 38929 34347 44 73 38770 NAND3X1 $T=1268000 647885 1 180 $X=1263650 $Y=647495
X2640 38891 39117 38600 44 73 39148 NAND3X1 $T=1269120 616525 1 0 $X=1268690 $Y=611970
X2641 39149 39095 38991 44 73 38735 NAND3X1 $T=1273040 632205 1 180 $X=1268690 $Y=631815
X2642 39172 39104 38886 44 73 39090 NAND3X1 $T=1273600 671405 1 180 $X=1269250 $Y=671015
X2643 39214 39165 39103 44 73 39129 NAND3X1 $T=1274720 624365 1 180 $X=1270370 $Y=623975
X2644 38520 38929 34118 44 73 39301 NAND3X1 $T=1275280 640045 0 0 $X=1274850 $Y=639655
X2645 38782 39333 39277 44 73 39089 NAND3X1 $T=1279200 671405 0 180 $X=1274850 $Y=666850
X2646 39394 39349 39301 44 73 38945 NAND3X1 $T=1279760 624365 1 180 $X=1275410 $Y=623975
X2647 38462 39423 32913 44 73 39394 NAND3X1 $T=1280320 624365 1 0 $X=1279890 $Y=619810
X2648 39568 39805 39650 44 73 39841 NAND3X1 $T=1287600 647885 0 0 $X=1287170 $Y=647495
X2649 39627 39794 39422 44 73 39865 NAND3X1 $T=1288720 624365 1 0 $X=1288290 $Y=619810
X2650 24213 24153 44 73 23984 OR2X1 $T=702400 600845 0 180 $X=698610 $Y=596290
X2651 24214 24154 44 73 23986 OR2X1 $T=702400 647885 0 180 $X=698610 $Y=643330
X2652 24284 24351 44 73 24355 OR2X1 $T=703520 608685 0 0 $X=703090 $Y=608295
X2653 24306 24340 44 73 24191 OR2X1 $T=706880 624365 1 180 $X=703090 $Y=623975
X2654 24588 24077 44 73 24305 OR2X1 $T=711920 608685 1 180 $X=708130 $Y=608295
X2655 24385 24621 44 73 24459 OR2X1 $T=710800 640045 0 0 $X=710370 $Y=639655
X2656 24547 24644 44 73 24599 OR2X1 $T=714720 593005 1 180 $X=710930 $Y=592615
X2657 24417 24459 44 73 24746 OR2X1 $T=713040 624365 1 0 $X=712610 $Y=619810
X2658 24547 24340 44 73 24793 OR2X1 $T=715280 640045 1 0 $X=714850 $Y=635490
X2659 24330 24673 44 73 24815 OR2X1 $T=720320 663565 0 180 $X=716530 $Y=659010
X2660 24588 24923 44 73 24978 OR2X1 $T=719200 600845 1 0 $X=718770 $Y=596290
X2661 24351 24923 44 73 24653 OR2X1 $T=723120 593005 1 180 $X=719330 $Y=592615
X2662 24796 24351 44 73 24340 OR2X1 $T=724240 624365 0 180 $X=720450 $Y=619810
X2663 24963 24813 44 73 25034 OR2X1 $T=721440 655725 0 0 $X=721010 $Y=655335
X2664 24960 24944 44 73 25080 OR2X1 $T=722560 616525 0 0 $X=722130 $Y=616135
X2665 24351 24882 44 73 25100 OR2X1 $T=723120 632205 0 0 $X=722690 $Y=631815
X2666 26247 25968 44 73 26240 OR2X1 $T=764560 663565 0 180 $X=760770 $Y=659010
X2667 26247 26277 44 73 26304 OR2X1 $T=761760 632205 1 0 $X=761330 $Y=627650
X2668 26247 26661 44 73 26677 OR2X1 $T=781360 640045 0 0 $X=780930 $Y=639655
X2669 26247 26641 44 73 26714 OR2X1 $T=783040 663565 0 0 $X=782610 $Y=663175
X2670 117 27537 44 73 27365 OR2X1 $T=821120 694925 1 180 $X=817330 $Y=694535
X2671 27764 27710 44 73 27603 OR2X1 $T=828960 702765 0 180 $X=825170 $Y=698210
X2672 27710 27636 44 73 27779 OR2X1 $T=826160 710605 1 0 $X=825730 $Y=706050
X2673 27880 27913 44 73 27931 OR2X1 $T=832880 679245 0 0 $X=832450 $Y=678855
X2674 27839 27674 44 73 27993 OR2X1 $T=836240 718445 0 0 $X=835810 $Y=718055
X2675 28302 28219 44 73 28153 OR2X1 $T=853600 679245 1 180 $X=849810 $Y=678855
X2676 27765 27674 44 73 28328 OR2X1 $T=851360 718445 1 0 $X=850930 $Y=713890
X2677 27901 82 44 73 28376 OR2X1 $T=853600 663565 1 0 $X=853170 $Y=659010
X2678 28174 27531 44 73 28413 OR2X1 $T=855280 726285 1 0 $X=854850 $Y=721730
X2679 147 89 44 73 28610 OR2X1 $T=869840 663565 0 180 $X=866050 $Y=659010
X2680 169 29903 44 73 29774 OR2X1 $T=911840 577325 1 180 $X=908050 $Y=576935
X2681 236 30110 44 73 30086 OR2X1 $T=920800 569485 1 180 $X=917010 $Y=569095
X2682 236 30264 44 73 30285 OR2X1 $T=924720 577325 0 0 $X=924290 $Y=576935
X2683 29632 174 44 73 30440 OR2X1 $T=931440 545965 0 0 $X=931010 $Y=545575
X2684 30200 174 44 73 30464 OR2X1 $T=932560 545965 1 0 $X=932130 $Y=541410
X2685 169 30477 44 73 30429 OR2X1 $T=938160 577325 1 180 $X=934370 $Y=576935
X2686 241 199 44 73 30593 OR2X1 $T=938720 545965 0 0 $X=938290 $Y=545575
X2687 196 241 44 73 30655 OR2X1 $T=941520 553805 1 0 $X=941090 $Y=549250
X2688 244 300 44 73 30852 OR2X1 $T=949920 491085 1 0 $X=949490 $Y=486530
X2689 276 286 44 73 30934 OR2X1 $T=953280 491085 1 0 $X=952850 $Y=486530
X2690 298 199 44 73 30935 OR2X1 $T=953280 506765 1 0 $X=952850 $Y=502210
X2691 280 316 44 73 31040 OR2X1 $T=957760 718445 0 0 $X=957330 $Y=718055
X2692 31028 31113 44 73 31081 OR2X1 $T=965040 663565 0 180 $X=961250 $Y=659010
X2693 29710 217 44 73 31108 OR2X1 $T=966160 545965 0 180 $X=962370 $Y=541410
X2694 320 31061 44 73 31258 OR2X1 $T=971760 710605 1 180 $X=967970 $Y=710215
X2695 31061 294 44 73 335 OR2X1 $T=970080 718445 1 0 $X=969650 $Y=713890
X2696 339 31285 44 73 31305 OR2X1 $T=976800 491085 1 180 $X=973010 $Y=490695
X2697 31255 31027 44 73 31555 OR2X1 $T=975120 632205 1 0 $X=974690 $Y=627650
X2698 323 294 44 73 340 OR2X1 $T=975120 726285 0 0 $X=974690 $Y=725895
X2699 31117 31538 44 73 31413 OR2X1 $T=975680 616525 0 0 $X=975250 $Y=616135
X2700 31636 31028 44 73 31552 OR2X1 $T=980720 655725 0 180 $X=976930 $Y=651170
X2701 31450 31414 44 73 31595 OR2X1 $T=984640 647885 0 180 $X=980850 $Y=643330
X2702 31438 31552 44 73 31797 OR2X1 $T=982400 655725 1 0 $X=981970 $Y=651170
X2703 31286 31754 44 73 31616 OR2X1 $T=985760 671405 0 180 $X=981970 $Y=666850
X2704 31206 31538 44 73 31887 OR2X1 $T=985200 624365 1 0 $X=984770 $Y=619810
X2705 31809 31863 44 73 31754 OR2X1 $T=989120 663565 1 180 $X=985330 $Y=663175
X2706 31492 31863 44 73 31989 OR2X1 $T=988560 624365 1 0 $X=988130 $Y=619810
X2707 31781 31892 44 73 32075 OR2X1 $T=991360 640045 0 0 $X=990930 $Y=639655
X2708 31556 31148 44 73 32135 OR2X1 $T=993040 585165 0 0 $X=992610 $Y=584775
X2709 31166 31577 44 73 31950 OR2X1 $T=996960 655725 0 180 $X=993170 $Y=651170
X2710 30581 31147 44 73 32243 OR2X1 $T=996960 585165 0 0 $X=996530 $Y=584775
X2711 349 32376 44 73 32333 OR2X1 $T=1005360 530285 1 180 $X=1001570 $Y=529895
X2712 28266 32377 44 73 32259 OR2X1 $T=1005360 569485 1 180 $X=1001570 $Y=569095
X2713 353 351 44 73 32400 OR2X1 $T=1007600 491085 0 180 $X=1003810 $Y=486530
X2714 32613 327 44 73 32547 OR2X1 $T=1012080 545965 1 180 $X=1008290 $Y=545575
X2715 330 32618 44 73 32443 OR2X1 $T=1013760 498925 0 180 $X=1009970 $Y=494370
X2716 32792 32628 44 73 32291 OR2X1 $T=1018240 585165 1 180 $X=1014450 $Y=584775
X2717 372 32774 44 73 32834 OR2X1 $T=1022160 545965 1 180 $X=1018370 $Y=545575
X2718 30581 31148 44 73 32929 OR2X1 $T=1019360 585165 0 0 $X=1018930 $Y=584775
X2719 236 32993 44 73 32828 OR2X1 $T=1022720 553805 0 0 $X=1022290 $Y=553415
X2720 33093 286 44 73 33054 OR2X1 $T=1029440 506765 0 180 $X=1025650 $Y=502210
X2721 33115 33082 44 73 33055 OR2X1 $T=1029440 647885 0 180 $X=1025650 $Y=643330
X2722 33118 32628 44 73 32801 OR2X1 $T=1031680 577325 1 180 $X=1027890 $Y=576935
X2723 300 33151 44 73 382 OR2X1 $T=1028880 491085 1 0 $X=1028450 $Y=486530
X2724 365 33112 44 73 33195 OR2X1 $T=1029440 538125 1 0 $X=1029010 $Y=533570
X2725 33061 32377 44 73 32843 OR2X1 $T=1035040 577325 1 180 $X=1031250 $Y=576935
X2726 33062 33270 44 73 33275 OR2X1 $T=1033920 663565 1 0 $X=1033490 $Y=659010
X2727 33360 33082 44 73 33309 OR2X1 $T=1041200 663565 0 180 $X=1037410 $Y=659010
X2728 33360 33374 44 73 33375 OR2X1 $T=1044560 663565 0 180 $X=1040770 $Y=659010
X2729 406 286 44 73 33491 OR2X1 $T=1050160 498925 0 180 $X=1046370 $Y=494370
X2730 368 199 44 73 33553 OR2X1 $T=1047920 530285 0 0 $X=1047490 $Y=529895
X2731 33476 33361 44 73 33494 OR2X1 $T=1049040 663565 0 0 $X=1048610 $Y=663175
X2732 363 174 44 73 33636 OR2X1 $T=1051840 491085 1 0 $X=1051410 $Y=486530
X2733 398 331 44 73 33585 OR2X1 $T=1055200 545965 1 180 $X=1051410 $Y=545575
X2734 33440 33525 44 73 33612 OR2X1 $T=1051840 679245 0 0 $X=1051410 $Y=678855
X2735 419 174 44 73 33601 OR2X1 $T=1058560 522445 1 180 $X=1054770 $Y=522055
X2736 33591 174 44 73 33648 OR2X1 $T=1056320 538125 0 0 $X=1055890 $Y=537735
X2737 33476 33578 44 73 33580 OR2X1 $T=1056320 624365 0 0 $X=1055890 $Y=623975
X2738 33173 33440 44 73 33674 OR2X1 $T=1059680 679245 1 180 $X=1055890 $Y=678855
X2739 406 199 44 73 33731 OR2X1 $T=1057440 498925 0 0 $X=1057010 $Y=498535
X2740 425 199 44 73 33705 OR2X1 $T=1061360 530285 1 180 $X=1057570 $Y=529895
X2741 33758 33759 44 73 33709 OR2X1 $T=1063600 593005 0 180 $X=1059810 $Y=588450
X2742 33734 33580 44 73 33763 OR2X1 $T=1060240 624365 0 0 $X=1059810 $Y=623975
X2743 33328 33140 44 73 33749 OR2X1 $T=1064160 632205 1 180 $X=1060370 $Y=631815
X2744 33650 33374 44 73 33786 OR2X1 $T=1064160 671405 0 0 $X=1063730 $Y=671015
X2745 263 33784 44 73 33972 OR2X1 $T=1070320 506765 0 0 $X=1069890 $Y=506375
X2746 169 34295 44 73 34130 OR2X1 $T=1087120 585165 0 180 $X=1083330 $Y=580610
X2747 236 34433 44 73 33918 OR2X1 $T=1092720 561645 1 180 $X=1088930 $Y=561255
X2748 169 34378 44 73 34381 OR2X1 $T=1093280 569485 1 180 $X=1089490 $Y=569095
X2749 169 34540 44 73 34304 OR2X1 $T=1092720 569485 1 0 $X=1092290 $Y=564930
X2750 26247 35983 44 73 36071 OR2X1 $T=1149840 655725 1 0 $X=1149410 $Y=651170
X2751 26247 36382 44 73 36359 OR2X1 $T=1167200 632205 0 180 $X=1163410 $Y=627650
X2752 26247 36659 44 73 36685 OR2X1 $T=1177840 640045 1 0 $X=1177410 $Y=635490
X2753 37901 80 44 73 37960 OR2X1 $T=1228800 553805 1 0 $X=1228370 $Y=549250
X2754 38152 25418 44 73 38287 OR2X1 $T=1240560 593005 1 0 $X=1240130 $Y=588450
X2755 38543 38694 44 73 38732 OR2X1 $T=1256240 561645 0 0 $X=1255810 $Y=561255
X2756 38462 38765 44 73 38574 OR2X1 $T=1261840 632205 1 180 $X=1258050 $Y=631815
X2757 38666 38782 44 73 38731 OR2X1 $T=1259040 655725 1 0 $X=1258610 $Y=651170
X2758 38546 38772 44 73 38886 OR2X1 $T=1267440 671405 0 180 $X=1263650 $Y=666850
X2759 38891 38765 44 73 38912 OR2X1 $T=1268000 616525 1 180 $X=1264210 $Y=616135
X2760 38967 38546 44 73 38863 OR2X1 $T=1268000 640045 1 180 $X=1264210 $Y=639655
X2761 38763 38765 44 73 38967 OR2X1 $T=1269680 647885 0 180 $X=1265890 $Y=643330
X2762 39215 39117 44 73 39010 OR2X1 $T=1274160 663565 0 180 $X=1270370 $Y=659010
X2763 39192 39245 44 73 39172 OR2X1 $T=1276400 663565 1 180 $X=1272610 $Y=663175
X2764 38929 38520 44 73 39356 OR2X1 $T=1275280 640045 1 0 $X=1274850 $Y=635490
X2765 34347 39380 44 73 38765 OR2X1 $T=1280320 647885 0 180 $X=1276530 $Y=643330
X2766 38929 39192 44 73 39568 OR2X1 $T=1280320 647885 0 0 $X=1279890 $Y=647495
X2767 39706 39589 44 73 39191 OR2X1 $T=1287600 632205 0 180 $X=1283810 $Y=627650
X2768 44 73 78 25476 25825 ICV_74 $T=748320 545965 0 0 $X=747890 $Y=545575
X2769 44 73 83 25828 26008 ICV_74 $T=751120 702765 0 0 $X=750690 $Y=702375
X2770 44 73 26292 26186 26281 ICV_74 $T=761760 538125 1 0 $X=761330 $Y=533570
X2771 44 73 26768 26749 26762 ICV_74 $T=786400 506765 1 0 $X=785970 $Y=502210
X2772 44 73 78 26975 26991 ICV_74 $T=797040 553805 0 0 $X=796610 $Y=553415
X2773 44 73 27751 27624 27710 ICV_74 $T=825600 694925 0 0 $X=825170 $Y=694535
X2774 44 73 27801 27820 27636 ICV_74 $T=830080 702765 0 0 $X=829650 $Y=702375
X2775 44 73 89 28136 140 ICV_74 $T=844640 679245 1 0 $X=844210 $Y=674690
X2776 44 73 158 161 29375 ICV_74 $T=886080 491085 1 0 $X=885650 $Y=486530
X2777 44 73 165 161 29481 ICV_74 $T=890560 491085 0 0 $X=890130 $Y=490695
X2778 44 73 165 28826 29506 ICV_74 $T=891680 514605 1 0 $X=891250 $Y=510050
X2779 44 73 165 29293 29574 ICV_74 $T=894480 569485 0 0 $X=894050 $Y=569095
X2780 44 73 29709 29574 29688 ICV_74 $T=898960 569485 1 0 $X=898530 $Y=564930
X2781 44 73 29425 29421 190 ICV_74 $T=902880 506765 0 0 $X=902450 $Y=506375
X2782 44 73 29661 29772 203 ICV_74 $T=905680 514605 1 0 $X=905250 $Y=510050
X2783 44 73 216 166 29922 ICV_74 $T=909040 506765 0 0 $X=908610 $Y=506375
X2784 44 73 196 29924 30105 ICV_74 $T=918560 561645 1 0 $X=918130 $Y=557090
X2785 44 73 30541 206 30509 ICV_74 $T=937600 561645 0 0 $X=937170 $Y=561255
X2786 44 73 302 30594 30854 ICV_74 $T=951600 522445 1 0 $X=951170 $Y=517890
X2787 44 73 30919 30544 30891 ICV_74 $T=953280 616525 0 0 $X=952850 $Y=616135
X2788 44 73 30903 30742 30904 ICV_74 $T=953840 632205 1 0 $X=953410 $Y=627650
X2789 44 73 300 298 30872 ICV_74 $T=954400 498925 0 0 $X=953970 $Y=498535
X2790 44 73 312 30605 30997 ICV_74 $T=957200 514605 1 0 $X=956770 $Y=510050
X2791 44 73 31026 272 31010 ICV_74 $T=957760 545965 1 0 $X=957330 $Y=541410
X2792 44 73 31026 183 31043 ICV_74 $T=958880 545965 0 0 $X=958450 $Y=545575
X2793 44 73 31059 183 30999 ICV_74 $T=958880 569485 0 0 $X=958450 $Y=569095
X2794 44 73 31060 31029 31012 ICV_74 $T=958880 632205 0 0 $X=958450 $Y=631815
X2795 44 73 31027 29250 31119 ICV_74 $T=963360 624365 1 0 $X=962930 $Y=619810
X2796 44 73 31488 31339 31493 ICV_74 $T=974000 632205 0 0 $X=973570 $Y=631815
X2797 44 73 31450 30815 31892 ICV_74 $T=986320 640045 0 0 $X=985890 $Y=639655
X2798 44 73 32435 220 32413 ICV_74 $T=1003120 514605 0 0 $X=1002690 $Y=514215
X2799 44 73 32438 345 32415 ICV_74 $T=1003120 545965 0 0 $X=1002690 $Y=545575
X2800 44 73 32534 324 32517 ICV_74 $T=1006480 506765 1 0 $X=1006050 $Y=502210
X2801 44 73 356 30893 32561 ICV_74 $T=1009840 506765 1 0 $X=1009410 $Y=502210
X2802 44 73 32660 325 32647 ICV_74 $T=1010960 561645 0 0 $X=1010530 $Y=561255
X2803 44 73 32695 330 360 ICV_74 $T=1012080 491085 1 0 $X=1011650 $Y=486530
X2804 44 73 379 312 32912 ICV_74 $T=1027200 491085 0 0 $X=1026770 $Y=490695
X2805 44 73 33323 33157 393 ICV_74 $T=1035600 545965 0 0 $X=1035170 $Y=545575
X2806 44 73 158 32794 397 ICV_74 $T=1041200 514605 0 0 $X=1040770 $Y=514215
X2807 44 73 158 29346 33818 ICV_74 $T=1063600 491085 0 0 $X=1063170 $Y=490695
X2808 44 73 33188 33578 33834 ICV_74 $T=1063600 655725 0 0 $X=1063170 $Y=655335
X2809 44 73 33844 33374 33855 ICV_74 $T=1064720 663565 0 0 $X=1064290 $Y=663175
X2810 44 73 196 33589 33893 ICV_74 $T=1066960 530285 0 0 $X=1066530 $Y=529895
X2811 44 73 78 33914 29859 ICV_74 $T=1068640 624365 1 0 $X=1068210 $Y=619810
X2812 44 73 78 29790 33919 ICV_74 $T=1068640 632205 0 0 $X=1068210 $Y=631815
X2813 44 73 33996 33681 34052 ICV_74 $T=1074800 522445 1 0 $X=1074370 $Y=517890
X2814 44 73 226 419 34039 ICV_74 $T=1074800 530285 1 0 $X=1074370 $Y=525730
X2815 44 73 34082 206 34376 ICV_74 $T=1086560 491085 0 0 $X=1086130 $Y=490695
X2816 44 73 33864 206 34446 ICV_74 $T=1089360 530285 1 0 $X=1088930 $Y=525730
X2817 44 73 80 33914 34546 ICV_74 $T=1092720 608685 0 0 $X=1092290 $Y=608295
X2818 44 73 78 33955 35158 ICV_74 $T=1112320 655725 1 0 $X=1111890 $Y=651170
X2819 44 73 78 35434 35389 ICV_74 $T=1122960 640045 0 0 $X=1122530 $Y=639655
X2820 44 73 82 445 35598 ICV_74 $T=1137520 726285 1 0 $X=1137090 $Y=721730
X2821 44 73 80 35434 36130 ICV_74 $T=1152640 600845 0 0 $X=1152210 $Y=600455
X2822 44 73 36233 36130 36220 ICV_74 $T=1156000 585165 1 0 $X=1155570 $Y=580610
X2823 44 73 89 36204 36247 ICV_74 $T=1158240 608685 0 0 $X=1157810 $Y=608295
X2824 44 73 82 31802 36212 ICV_74 $T=1162160 655725 1 0 $X=1161730 $Y=651170
X2825 44 73 80 35590 36510 ICV_74 $T=1170560 600845 1 0 $X=1170130 $Y=596290
X2826 44 73 37566 37467 488 ICV_74 $T=1209760 726285 1 0 $X=1209330 $Y=721730
X2827 44 73 83 37242 37615 ICV_74 $T=1212560 702765 0 0 $X=1212130 $Y=702375
X2828 44 73 82 33912 37672 ICV_74 $T=1215920 632205 1 0 $X=1215490 $Y=627650
X2829 44 73 96 33912 37687 ICV_74 $T=1216480 640045 0 0 $X=1216050 $Y=639655
X2830 44 73 38719 38497 38694 ICV_74 $T=1256240 545965 0 0 $X=1255810 $Y=545575
X2831 44 73 38756 38913 38991 ICV_74 $T=1265760 632205 0 0 $X=1265330 $Y=631815
X2832 44 73 39130 39063 38992 ICV_74 $T=1269120 655725 1 0 $X=1268690 $Y=651170
X2833 44 73 39628 36564 39068 ICV_74 $T=1282560 663565 1 0 $X=1282130 $Y=659010
X2834 44 25034 24330 25016 73 ICV_78 $T=720320 663565 1 0 $X=719890 $Y=659010
X2835 44 25016 24482 25155 73 ICV_78 $T=724800 655725 0 0 $X=724370 $Y=655335
X2836 44 25303 24530 25252 73 ICV_78 $T=728720 624365 1 0 $X=728290 $Y=619810
X2837 44 25383 24077 25364 73 ICV_78 $T=730960 616525 1 0 $X=730530 $Y=611970
X2838 44 26739 26716 26725 73 ICV_78 $T=783600 545965 0 0 $X=783170 $Y=545575
X2839 44 80 26649 26682 73 ICV_78 $T=785280 585165 1 0 $X=784850 $Y=580610
X2840 44 27099 27071 27082 73 ICV_78 $T=799840 522445 1 0 $X=799410 $Y=517890
X2841 44 78 26946 27260 73 ICV_78 $T=806000 538125 0 0 $X=805570 $Y=537735
X2842 44 80 26946 27423 73 ICV_78 $T=811600 561645 0 0 $X=811170 $Y=561255
X2843 44 28137 28036 28138 73 ICV_78 $T=842400 687085 0 0 $X=841970 $Y=686695
X2844 44 27801 122 28219 73 ICV_78 $T=854720 702765 0 0 $X=854290 $Y=702375
X2845 44 29547 169 29519 73 ICV_78 $T=891680 538125 1 0 $X=891250 $Y=533570
X2846 44 29425 29481 29655 73 ICV_78 $T=896720 514605 0 0 $X=896290 $Y=514215
X2847 44 29646 29574 187 73 ICV_78 $T=898400 506765 0 0 $X=897970 $Y=506375
X2848 44 196 29789 29747 73 ICV_78 $T=902320 538125 1 0 $X=901890 $Y=533570
X2849 44 29322 29643 29789 73 ICV_78 $T=905680 498925 0 0 $X=905250 $Y=498535
X2850 44 30034 29454 221 73 ICV_78 $T=911840 498925 1 0 $X=911410 $Y=494370
X2851 44 30036 215 29923 73 ICV_78 $T=912400 569485 1 0 $X=911970 $Y=564930
X2852 44 29983 183 30046 73 ICV_78 $T=912960 545965 1 0 $X=912530 $Y=541410
X2853 44 30096 30072 30082 73 ICV_78 $T=914640 663565 0 0 $X=914210 $Y=663175
X2854 44 30411 29787 255 73 ICV_78 $T=929760 498925 1 0 $X=929330 $Y=494370
X2855 44 267 30231 266 73 ICV_78 $T=934240 498925 1 0 $X=933810 $Y=494370
X2856 44 286 261 30697 73 ICV_78 $T=943200 514605 1 0 $X=942770 $Y=510050
X2857 44 311 313 316 73 ICV_78 $T=956640 726285 1 0 $X=956210 $Y=721730
X2858 44 243 30594 31051 73 ICV_78 $T=958320 561645 1 0 $X=957890 $Y=557090
X2859 44 31148 29824 31133 73 ICV_78 $T=961120 585165 0 0 $X=960690 $Y=584775
X2860 44 295 322 31134 73 ICV_78 $T=961120 726285 1 0 $X=960690 $Y=721730
X2861 44 31190 259 31157 73 ICV_78 $T=962800 514605 1 0 $X=962370 $Y=510050
X2862 44 31193 30232 31178 73 ICV_78 $T=963360 553805 1 0 $X=962930 $Y=549250
X2863 44 336 285 31506 73 ICV_78 $T=973440 718445 1 0 $X=973010 $Y=713890
X2864 44 31494 297 31658 73 ICV_78 $T=977920 718445 1 0 $X=977490 $Y=713890
X2865 44 31074 31289 31781 73 ICV_78 $T=981840 632205 0 0 $X=981410 $Y=631815
X2866 44 31286 31220 32046 73 ICV_78 $T=990240 647885 0 0 $X=989810 $Y=647495
X2867 44 32114 31414 32101 73 ICV_78 $T=991920 663565 1 0 $X=991490 $Y=659010
X2868 44 32435 183 32414 73 ICV_78 $T=1002560 522445 0 0 $X=1002130 $Y=522055
X2869 44 32724 272 32646 73 ICV_78 $T=1012080 514605 1 0 $X=1011650 $Y=510050
X2870 44 362 239 32725 73 ICV_78 $T=1012640 530285 0 0 $X=1012210 $Y=529895
X2871 44 196 351 32934 73 ICV_78 $T=1019360 514605 1 0 $X=1018930 $Y=510050
X2872 44 33201 33091 33115 73 ICV_78 $T=1029440 647885 1 0 $X=1029010 $Y=643330
X2873 44 158 28124 33213 73 ICV_78 $T=1030000 561645 0 0 $X=1029570 $Y=561255
X2874 44 33271 33266 33015 73 ICV_78 $T=1033360 530285 0 0 $X=1032930 $Y=529895
X2875 44 33254 33157 33314 73 ICV_78 $T=1034480 561645 1 0 $X=1034050 $Y=557090
X2876 44 158 33075 33343 73 ICV_78 $T=1037840 569485 0 0 $X=1037410 $Y=569095
X2877 44 33403 33345 33299 73 ICV_78 $T=1038960 624365 0 0 $X=1038530 $Y=623975
X2878 44 33424 215 33416 73 ICV_78 $T=1040080 585165 1 0 $X=1039650 $Y=580610
X2879 44 78 33105 33454 73 ICV_78 $T=1042320 687085 0 0 $X=1041890 $Y=686695
X2880 44 33429 33368 404 73 ICV_78 $T=1045120 522445 0 0 $X=1044690 $Y=522055
X2881 44 33048 33451 33537 73 ICV_78 $T=1046800 647885 0 0 $X=1046370 $Y=647495
X2882 44 33708 215 33689 73 ICV_78 $T=1055200 577325 0 0 $X=1054770 $Y=576935
X2883 44 33720 33705 33719 73 ICV_78 $T=1056320 538125 1 0 $X=1055890 $Y=533570
X2884 44 33819 272 33806 73 ICV_78 $T=1061360 561645 0 0 $X=1060930 $Y=561255
X2885 44 33874 220 33867 73 ICV_78 $T=1064160 577325 0 0 $X=1063730 $Y=576935
X2886 44 33891 33578 33883 73 ICV_78 $T=1065280 671405 1 0 $X=1064850 $Y=666850
X2887 44 432 33728 433 73 ICV_78 $T=1066400 498925 0 0 $X=1065970 $Y=498535
X2888 44 33855 33328 33931 73 ICV_78 $T=1068080 663565 0 0 $X=1067650 $Y=663175
X2889 44 217 33015 441 73 ICV_78 $T=1071440 538125 1 0 $X=1071010 $Y=533570
X2890 44 226 32832 34098 73 ICV_78 $T=1075360 514605 0 0 $X=1074930 $Y=514215
X2891 44 243 32534 34148 73 ICV_78 $T=1078160 522445 1 0 $X=1077730 $Y=517890
X2892 44 277 374 34281 73 ICV_78 $T=1082080 491085 0 0 $X=1081650 $Y=490695
X2893 44 78 34460 34614 73 ICV_78 $T=1094400 616525 1 0 $X=1093970 $Y=611970
X2894 44 35341 35311 35329 73 ICV_78 $T=1117360 608685 1 0 $X=1116930 $Y=604130
X2895 44 82 341 35769 73 ICV_78 $T=1136400 702765 0 0 $X=1135970 $Y=702375
X2896 44 96 31802 36242 73 ICV_78 $T=1160480 671405 0 0 $X=1160050 $Y=671015
X2897 44 36600 36510 36601 73 ICV_78 $T=1173920 600845 1 0 $X=1173490 $Y=596290
X2898 44 82 34368 36759 73 ICV_78 $T=1180640 647885 0 0 $X=1180210 $Y=647495
X2899 44 80 481 37277 73 ICV_78 $T=1197440 491085 1 0 $X=1197010 $Y=486530
X2900 44 37111 37283 37391 73 ICV_78 $T=1202480 545965 1 0 $X=1202050 $Y=541410
X2901 44 37765 96 37565 73 ICV_78 $T=1219840 632205 0 0 $X=1219410 $Y=631815
X2902 44 38644 34118 38555 73 ICV_78 $T=1252880 663565 0 0 $X=1252450 $Y=663175
X2903 44 38609 38326 38701 73 ICV_78 $T=1255120 538125 1 0 $X=1254690 $Y=533570
X2904 44 38462 36564 38764 73 ICV_78 $T=1260160 624365 0 0 $X=1259730 $Y=623975
X2905 44 38644 36564 38901 73 ICV_78 $T=1261840 663565 0 0 $X=1261410 $Y=663175
X2955 44 73 24567 24610 24589 ICV_72 $T=710240 655725 1 0 $X=709810 $Y=651170
X2956 44 73 24531 24796 24644 ICV_72 $T=715280 608685 1 0 $X=714850 $Y=604130
X2957 44 73 25899 26009 81 ICV_72 $T=751120 491085 1 0 $X=750690 $Y=486530
X2958 44 73 80 87 26009 ICV_72 $T=756160 491085 1 0 $X=755730 $Y=486530
X2959 44 73 80 91 26258 ICV_72 $T=761200 491085 1 0 $X=760770 $Y=486530
X2960 44 73 82 26467 26370 ICV_72 $T=772400 647885 0 0 $X=771970 $Y=647495
X2961 44 73 26890 26917 26902 ICV_72 $T=793680 491085 1 0 $X=793250 $Y=486530
X2962 44 73 26991 27042 27068 ICV_72 $T=800960 538125 0 0 $X=800530 $Y=537735
X2963 44 73 89 27443 27378 ICV_72 $T=813280 632205 1 0 $X=812850 $Y=627650
X2964 44 73 96 112 27439 ICV_72 $T=813840 663565 1 0 $X=813410 $Y=659010
X2965 44 73 27438 27491 27479 ICV_72 $T=815520 545965 0 0 $X=815090 $Y=545575
X2966 44 73 27933 96 27890 ICV_72 $T=837360 655725 1 0 $X=836930 $Y=651170
X2967 44 73 28379 136 28371 ICV_72 $T=855840 694925 0 0 $X=855410 $Y=694535
X2968 44 73 28165 29173 29149 ICV_72 $T=878240 616525 1 0 $X=877810 $Y=611970
X2969 44 73 158 28317 162 ICV_72 $T=887200 498925 1 0 $X=886770 $Y=494370
X2970 44 73 30036 220 30028 ICV_72 $T=914640 577325 0 0 $X=914210 $Y=576935
X2971 44 73 243 30232 29716 ICV_72 $T=923040 545965 1 0 $X=922610 $Y=541410
X2972 44 73 216 30313 245 ICV_72 $T=926960 530285 1 0 $X=926530 $Y=525730
X2973 44 73 78 30314 30096 ICV_72 $T=926960 663565 0 0 $X=926530 $Y=663175
X2974 44 73 267 29454 30594 ICV_72 $T=940400 498925 0 0 $X=939970 $Y=498535
X2975 44 73 279 264 30605 ICV_72 $T=940960 506765 1 0 $X=940530 $Y=502210
X2976 44 73 30507 259 30678 ICV_72 $T=943760 530285 0 0 $X=943330 $Y=529895
X2977 44 73 30904 30938 30920 ICV_72 $T=954400 647885 0 0 $X=953970 $Y=647495
X2978 44 73 289 235 31101 ICV_72 $T=961680 514605 0 0 $X=961250 $Y=514215
X2979 44 73 31028 30929 31118 ICV_72 $T=962240 608685 0 0 $X=961810 $Y=608295
X2980 44 73 30093 324 31162 ICV_72 $T=963360 506765 1 0 $X=962930 $Y=502210
X2981 44 73 31149 31492 31487 ICV_72 $T=974000 616525 1 0 $X=973570 $Y=611970
X2982 44 73 30919 31625 31634 ICV_72 $T=979040 616525 1 0 $X=978610 $Y=611970
X2983 44 73 215 32454 32438 ICV_72 $T=1004240 538125 0 0 $X=1003810 $Y=537735
X2984 44 73 31147 30581 32629 ICV_72 $T=1010960 593005 1 0 $X=1010530 $Y=588450
X2985 44 73 302 32832 32587 ICV_72 $T=1017120 522445 0 0 $X=1016690 $Y=522055
X2986 44 73 32793 272 32847 ICV_72 $T=1018240 593005 0 0 $X=1017810 $Y=592615
X2987 44 73 31147 33242 33186 ICV_72 $T=1032240 585165 1 0 $X=1031810 $Y=580610
X2988 44 73 158 33272 33383 ICV_72 $T=1042320 553805 1 0 $X=1041890 $Y=549250
X2989 44 73 33323 33446 33435 ICV_72 $T=1042880 545965 0 0 $X=1042450 $Y=545575
X2990 44 73 184 32454 33518 ICV_72 $T=1047920 569485 0 0 $X=1047490 $Y=569095
X2991 44 73 184 33369 33563 ICV_72 $T=1050160 569485 1 0 $X=1049730 $Y=564930
X2992 44 73 174 33314 410 ICV_72 $T=1052400 498925 0 0 $X=1051970 $Y=498535
X2993 44 73 289 33435 33699 ICV_72 $T=1056880 553805 1 0 $X=1056450 $Y=549250
X2994 44 73 33818 431 373 ICV_72 $T=1064160 491085 1 0 $X=1063730 $Y=486530
X2995 44 73 33819 183 33882 ICV_72 $T=1066960 553805 1 0 $X=1066530 $Y=549250
X2996 44 73 33874 215 33865 ICV_72 $T=1068080 577325 1 0 $X=1067650 $Y=572770
X2997 44 73 243 32618 34301 ICV_72 $T=1084320 506765 0 0 $X=1083890 $Y=506375
X2998 44 73 33919 34397 34382 ICV_72 $T=1087120 655725 0 0 $X=1086690 $Y=655335
X2999 44 73 34082 183 34449 ICV_72 $T=1089920 498925 0 0 $X=1089490 $Y=498535
X3000 44 73 216 409 34456 ICV_72 $T=1092720 514605 1 0 $X=1092290 $Y=510050
X3001 44 73 89 35388 35569 ICV_72 $T=1132480 702765 1 0 $X=1132050 $Y=698210
X3002 44 73 36663 37260 37244 ICV_72 $T=1198000 522445 0 0 $X=1197570 $Y=522055
X3003 44 73 37241 37278 37258 ICV_72 $T=1198560 577325 1 0 $X=1198130 $Y=572770
X3004 44 73 83 37884 495 ICV_72 $T=1226560 702765 1 0 $X=1226130 $Y=698210
X3005 44 73 77 498 37799 ICV_72 $T=1229920 702765 0 0 $X=1229490 $Y=702375
X3006 44 73 39423 38763 39627 ICV_72 $T=1283680 624365 0 0 $X=1283250 $Y=623975
X3007 24143 24531 44 73 24546 AND2X1 $T=708000 600845 0 0 $X=707570 $Y=600455
X3008 24776 24700 44 73 24587 AND2X1 $T=717520 600845 1 180 $X=713730 $Y=600455
X3009 24840 24793 44 73 24752 AND2X1 $T=719200 647885 0 180 $X=715410 $Y=643330
X3010 24813 24039 44 73 24153 AND2X1 $T=721440 616525 1 180 $X=717650 $Y=616135
X3011 24673 24998 44 73 25137 AND2X1 $T=724240 647885 0 0 $X=723810 $Y=647495
X3012 24143 24530 44 73 24673 AND2X1 $T=728160 640045 1 180 $X=724370 $Y=639655
X3013 25080 24143 44 73 25191 AND2X1 $T=725920 647885 1 0 $X=725490 $Y=643330
X3014 25154 24978 44 73 25338 AND2X1 $T=730400 600845 0 0 $X=729970 $Y=600455
X3015 27993 28073 44 73 28067 AND2X1 $T=840720 718445 0 0 $X=840290 $Y=718055
X3016 29563 29588 44 73 29616 AND2X1 $T=895040 553805 0 0 $X=894610 $Y=553415
X3017 210 212 44 73 29938 AND2X1 $T=908480 491085 0 0 $X=908050 $Y=490695
X3018 30106 30080 44 73 30156 AND2X1 $T=918000 522445 0 0 $X=917570 $Y=522055
X3019 30149 30164 44 73 30186 AND2X1 $T=919680 593005 1 0 $X=919250 $Y=588450
X3020 30211 30140 44 73 30225 AND2X1 $T=923040 538125 0 0 $X=922610 $Y=537735
X3021 30233 30255 44 73 30272 AND2X1 $T=924160 593005 1 0 $X=923730 $Y=588450
X3022 30336 236 44 73 30378 AND2X1 $T=929200 585165 1 0 $X=928770 $Y=580610
X3023 30570 30542 44 73 30412 AND2X1 $T=941520 585165 0 180 $X=937730 $Y=580610
X3024 30551 30529 44 73 30573 AND2X1 $T=943760 538125 0 180 $X=939970 $Y=533570
X3025 30677 30648 44 73 30508 AND2X1 $T=946000 506765 1 180 $X=942210 $Y=506375
X3026 30735 30732 44 73 30631 AND2X1 $T=949920 593005 1 180 $X=946130 $Y=592615
X3027 299 30697 44 73 30759 AND2X1 $T=952160 514605 1 180 $X=948370 $Y=514215
X3028 308 318 44 73 328 AND2X1 $T=970640 726285 0 180 $X=966850 $Y=721730
X3029 31028 31399 44 73 31286 AND2X1 $T=980720 655725 1 180 $X=976930 $Y=655335
X3030 31616 31577 44 73 31489 AND2X1 $T=980720 663565 1 180 $X=976930 $Y=663175
X3031 31270 31658 44 73 31834 AND2X1 $T=983520 718445 0 0 $X=983090 $Y=718055
X3032 31538 31399 44 73 31809 AND2X1 $T=988560 640045 0 180 $X=984770 $Y=635490
X3033 31538 30544 44 73 31863 AND2X1 $T=988000 624365 0 0 $X=987570 $Y=623975
X3034 324 337 44 73 30893 AND2X1 $T=993600 498925 0 0 $X=993170 $Y=498535
X3035 32520 32384 44 73 32457 AND2X1 $T=1009280 585165 1 180 $X=1005490 $Y=584775
X3036 32845 215 44 73 32726 AND2X1 $T=1021600 538125 0 180 $X=1017810 $Y=533570
X3037 32827 32965 44 73 32946 AND2X1 $T=1021600 545965 1 0 $X=1021170 $Y=541410
X3038 32985 32847 44 73 33041 AND2X1 $T=1023280 593005 0 0 $X=1022850 $Y=592615
X3039 32979 33045 44 73 33074 AND2X1 $T=1024400 530285 1 0 $X=1023970 $Y=525730
X3040 33076 33043 44 73 32879 AND2X1 $T=1028320 506765 1 180 $X=1024530 $Y=506375
X3041 33078 32968 44 73 33126 AND2X1 $T=1026640 593005 1 0 $X=1026210 $Y=588450
X3042 33102 33140 44 73 33047 AND2X1 $T=1032240 640045 0 180 $X=1028450 $Y=635490
X3043 33156 33167 44 73 33044 AND2X1 $T=1033360 514605 0 180 $X=1029570 $Y=510050
X3044 33214 33239 44 73 33255 AND2X1 $T=1032240 593005 0 0 $X=1031810 $Y=592615
X3045 33323 33337 44 73 398 AND2X1 $T=1037840 553805 1 0 $X=1037410 $Y=549250
X3046 33197 236 44 73 33473 AND2X1 $T=1043440 569485 1 0 $X=1043010 $Y=564930
X3047 33240 33476 44 73 33274 AND2X1 $T=1048480 624365 1 180 $X=1044690 $Y=623975
X3048 33464 33140 44 73 33443 AND2X1 $T=1050160 632205 1 180 $X=1046370 $Y=631815
X3049 33393 33385 44 73 365 AND2X1 $T=1051280 538125 1 180 $X=1047490 $Y=537735
X3050 33581 33361 44 73 33626 AND2X1 $T=1051280 632205 1 0 $X=1050850 $Y=627650
X3051 33464 33476 44 73 33538 AND2X1 $T=1052400 663565 0 0 $X=1051970 $Y=663175
X3052 411 33638 44 73 33657 AND2X1 $T=1052960 538125 0 0 $X=1052530 $Y=537735
X3053 33650 33476 44 73 33188 AND2X1 $T=1055760 663565 0 0 $X=1055330 $Y=663175
X3054 33219 33173 44 73 33629 AND2X1 $T=1059680 655725 1 180 $X=1055890 $Y=655335
X3055 33867 33868 44 73 33004 AND2X1 $T=1072000 585165 1 180 $X=1068210 $Y=584775
X3056 34159 390 44 73 34114 AND2X1 $T=1082080 491085 1 180 $X=1078290 $Y=490695
X3057 34178 34141 44 73 34083 AND2X1 $T=1082080 506765 1 180 $X=1078290 $Y=506375
X3058 34602 34289 44 73 34742 AND2X1 $T=1098320 569485 1 0 $X=1097890 $Y=564930
X3059 38189 38152 44 73 496 AND2X1 $T=1239440 585165 0 0 $X=1239010 $Y=584775
X3060 38311 38448 44 73 80 AND2X1 $T=1247280 569485 1 0 $X=1246850 $Y=564930
X3061 38417 38452 44 73 38479 AND2X1 $T=1247280 655725 1 0 $X=1246850 $Y=651170
X3062 38546 38518 44 73 38486 AND2X1 $T=1253440 640045 0 180 $X=1249650 $Y=635490
X3063 38756 38608 44 73 38565 AND2X1 $T=1260720 647885 0 180 $X=1256930 $Y=643330
X3064 39148 39190 44 73 39165 AND2X1 $T=1271360 624365 1 0 $X=1270930 $Y=619810
X3065 38790 39233 44 73 39095 AND2X1 $T=1276400 632205 1 180 $X=1272610 $Y=631815
X3066 39395 39068 44 73 39623 AND2X1 $T=1282000 671405 1 0 $X=1281570 $Y=666850
X3067 39215 34347 44 73 39706 AND2X1 $T=1284240 640045 0 0 $X=1283810 $Y=639655
X3068 24038 44 73 24347 INVX2 $T=704080 655725 0 0 $X=703650 $Y=655335
X3069 24329 44 73 24125 INVX2 $T=704640 624365 1 0 $X=704210 $Y=619810
X3070 24077 44 73 24472 INVX2 $T=707440 663565 1 0 $X=707010 $Y=659010
X3071 24260 44 73 24481 INVX2 $T=710800 640045 1 180 $X=708690 $Y=639655
X3072 24588 44 73 24531 INVX2 $T=712480 600845 0 0 $X=712050 $Y=600455
X3073 24644 44 73 24564 INVX2 $T=714160 608685 1 180 $X=712050 $Y=608295
X3074 24700 44 73 24417 INVX2 $T=715280 624365 1 180 $X=713170 $Y=623975
X3075 24330 44 73 24621 INVX2 $T=715840 640045 1 180 $X=713730 $Y=639655
X3076 24547 44 73 25031 INVX2 $T=722560 600845 1 0 $X=722130 $Y=596290
X3077 24351 44 73 25061 INVX2 $T=723680 593005 0 0 $X=723250 $Y=592615
X3078 24751 44 73 24284 INVX2 $T=724240 616525 1 0 $X=723810 $Y=611970
X3079 24861 44 73 24039 INVX2 $T=725920 616525 0 0 $X=725490 $Y=616135
X3080 24264 44 73 24796 INVX2 $T=728160 608685 0 180 $X=726050 $Y=604130
X3081 24882 44 73 24998 INVX2 $T=726480 632205 0 0 $X=726050 $Y=631815
X3082 24530 44 73 24195 INVX2 $T=737120 632205 0 180 $X=735010 $Y=627650
X3083 25251 44 73 25651 INVX2 $T=741600 616525 1 0 $X=741170 $Y=611970
X3084 119 44 73 27579 INVX2 $T=822240 718445 1 180 $X=820130 $Y=718055
X3085 27801 44 73 27764 INVX2 $T=830640 694925 1 180 $X=828530 $Y=694535
X3086 127 44 73 27654 INVX2 $T=830640 702765 0 180 $X=828530 $Y=698210
X3087 27859 44 73 27604 INVX2 $T=832880 718445 0 180 $X=830770 $Y=713890
X3088 126 44 73 27765 INVX2 $T=835120 718445 0 180 $X=833010 $Y=713890
X3089 27891 44 73 117 INVX2 $T=837920 694925 1 180 $X=835810 $Y=694535
X3090 27917 44 73 133 INVX2 $T=839040 726285 0 180 $X=836930 $Y=721730
X3091 28078 44 73 28097 INVX2 $T=842400 702765 1 0 $X=841970 $Y=698210
X3092 28133 44 73 27711 INVX2 $T=845760 702765 0 180 $X=843650 $Y=698210
X3093 28181 44 73 28197 INVX2 $T=846880 687085 1 0 $X=846450 $Y=682530
X3094 139 44 73 27839 INVX2 $T=848560 726285 0 180 $X=846450 $Y=721730
X3095 28174 44 73 27918 INVX2 $T=849120 726285 1 180 $X=847010 $Y=725895
X3096 142 44 73 27945 INVX2 $T=850240 718445 0 180 $X=848130 $Y=713890
X3097 143 44 73 28154 INVX2 $T=851360 726285 0 180 $X=849250 $Y=721730
X3098 28231 44 73 27624 INVX2 $T=852480 694925 1 180 $X=850370 $Y=694535
X3099 27751 44 73 136 INVX2 $T=858080 687085 1 180 $X=855970 $Y=686695
X3100 27820 44 73 122 INVX2 $T=862560 710605 0 0 $X=862130 $Y=710215
X3101 29597 44 73 29534 INVX2 $T=897840 538125 0 180 $X=895730 $Y=533570
X3102 280 44 73 30683 INVX2 $T=944320 710605 0 0 $X=943890 $Y=710215
X3103 30998 44 73 31000 INVX2 $T=960000 585165 1 0 $X=959570 $Y=580610
X3104 318 44 73 320 INVX2 $T=961120 726285 0 0 $X=960690 $Y=725895
X3105 31009 44 73 31099 INVX2 $T=961680 506765 1 0 $X=961250 $Y=502210
X3106 30892 44 73 31029 INVX2 $T=962240 632205 0 0 $X=961810 $Y=631815
X3107 31058 44 73 31089 INVX2 $T=962800 561645 0 0 $X=962370 $Y=561255
X3108 31065 44 73 31113 INVX2 $T=962800 655725 1 0 $X=962370 $Y=651170
X3109 31117 44 73 31074 INVX2 $T=963360 647885 1 0 $X=962930 $Y=643330
X3110 31220 44 73 31202 INVX2 $T=967840 663565 0 180 $X=965730 $Y=659010
X3111 30929 44 73 31226 INVX2 $T=968960 608685 1 180 $X=966850 $Y=608295
X3112 30544 44 73 31206 INVX2 $T=969520 616525 1 180 $X=967410 $Y=616135
X3113 30742 44 73 31450 INVX2 $T=973440 632205 1 0 $X=973010 $Y=627650
X3114 31414 44 73 31239 INVX2 $T=973440 655725 0 0 $X=973010 $Y=655335
X3115 30820 44 73 311 INVX2 $T=977920 726285 0 180 $X=975810 $Y=721730
X3116 29250 44 73 31289 INVX2 $T=979040 632205 1 180 $X=976930 $Y=631815
X3117 31327 44 73 31166 INVX2 $T=983520 640045 1 0 $X=983090 $Y=635490
X3118 30815 44 73 31399 INVX2 $T=986320 647885 0 180 $X=984210 $Y=643330
X3119 345 44 73 31193 INVX2 $T=986880 506765 1 0 $X=986450 $Y=502210
X3120 199 44 73 31091 INVX2 $T=991360 498925 1 180 $X=989250 $Y=498535
X3121 32332 44 73 32282 INVX2 $T=1002560 553805 1 180 $X=1000450 $Y=553415
X3122 183 44 73 32384 INVX2 $T=1003680 577325 0 0 $X=1003250 $Y=576935
X3123 361 44 73 32696 INVX2 $T=1013760 553805 1 0 $X=1013330 $Y=549250
X3124 362 44 73 32902 INVX2 $T=1024400 530285 1 180 $X=1022290 $Y=529895
X3125 32864 44 73 300 INVX2 $T=1027200 491085 1 180 $X=1025090 $Y=490695
X3126 217 44 73 33112 INVX2 $T=1027760 530285 0 0 $X=1027330 $Y=529895
X3127 33048 44 73 33113 INVX2 $T=1027760 663565 0 0 $X=1027330 $Y=663175
X3128 33219 44 73 33114 INVX2 $T=1033920 632205 1 180 $X=1031810 $Y=631815
X3129 33102 44 73 33298 INVX2 $T=1035600 647885 1 0 $X=1035170 $Y=643330
X3130 394 44 73 33305 INVX2 $T=1038400 491085 0 180 $X=1036290 $Y=486530
X3131 33360 44 73 33378 INVX2 $T=1042320 647885 1 180 $X=1040210 $Y=647495
X3132 33440 44 73 33407 INVX2 $T=1045120 679245 1 180 $X=1043010 $Y=678855
X3133 33240 44 73 33578 INVX2 $T=1051280 624365 1 0 $X=1050850 $Y=619810
X3134 33386 44 73 33173 INVX2 $T=1057440 655725 1 0 $X=1057010 $Y=651170
X3135 33201 44 73 33328 INVX2 $T=1060800 647885 1 0 $X=1060370 $Y=643330
X3136 33140 44 73 33734 INVX2 $T=1063040 632205 0 180 $X=1060930 $Y=627650
X3137 33091 44 73 33650 INVX2 $T=1064720 663565 1 180 $X=1062610 $Y=663175
X3138 33227 44 73 33312 INVX2 $T=1069200 655725 0 180 $X=1067090 $Y=651170
X3139 82 44 73 463 INVX2 $T=1138640 624365 0 0 $X=1138210 $Y=623975
X3140 96 44 73 26247 INVX2 $T=1139760 655725 0 0 $X=1139330 $Y=655335
X3141 37944 44 73 38003 INVX2 $T=1232720 553805 1 0 $X=1232290 $Y=549250
X3142 38068 44 73 38063 INVX2 $T=1240000 545965 0 0 $X=1239570 $Y=545575
X3143 25418 44 73 38189 INVX2 $T=1243920 577325 1 180 $X=1241810 $Y=576935
X3144 38297 44 73 38325 INVX2 $T=1243360 577325 1 0 $X=1242930 $Y=572770
X3145 496 44 73 38448 INVX2 $T=1248400 561645 1 0 $X=1247970 $Y=557090
X3146 38462 44 73 38420 INVX2 $T=1250080 616525 0 180 $X=1247970 $Y=611970
X3147 38309 44 73 38478 INVX2 $T=1248960 530285 0 0 $X=1248530 $Y=529895
X3148 80 44 73 38497 INVX2 $T=1250080 545965 0 0 $X=1249650 $Y=545575
X3149 38505 44 73 38525 INVX2 $T=1250640 655725 0 0 $X=1250210 $Y=655335
X3150 38517 44 73 38411 INVX2 $T=1252880 569485 1 180 $X=1250770 $Y=569095
X3151 38555 44 73 38518 INVX2 $T=1253440 647885 0 180 $X=1251330 $Y=643330
X3152 36949 44 73 38600 INVX2 $T=1253440 608685 0 0 $X=1253010 $Y=608295
X3153 38608 44 73 38520 INVX2 $T=1255680 640045 1 180 $X=1253570 $Y=639655
X3154 38563 44 73 38557 INVX2 $T=1255120 553805 1 0 $X=1254690 $Y=549250
X3155 38644 44 73 38529 INVX2 $T=1256800 671405 0 180 $X=1254690 $Y=666850
X3156 38572 44 73 38679 INVX2 $T=1256240 616525 1 0 $X=1255810 $Y=611970
X3157 38715 44 73 38688 INVX2 $T=1259040 655725 0 180 $X=1256930 $Y=651170
X3158 34480 44 73 38666 INVX2 $T=1258480 616525 0 0 $X=1258050 $Y=616135
X3159 36564 44 73 38763 INVX2 $T=1263520 624365 0 180 $X=1261410 $Y=619810
X3160 38701 44 73 38811 INVX2 $T=1262400 545965 1 0 $X=1261970 $Y=541410
X3161 38546 44 73 38847 INVX2 $T=1264080 647885 1 180 $X=1261970 $Y=647495
X3162 38891 44 73 38733 INVX2 $T=1265200 608685 0 180 $X=1263090 $Y=604130
X3163 38721 44 73 38913 INVX2 $T=1264080 632205 1 0 $X=1263650 $Y=627650
X3164 38945 44 73 38261 INVX2 $T=1266880 624365 1 180 $X=1264770 $Y=623975
X3165 39215 44 73 39221 INVX2 $T=1275280 647885 1 180 $X=1273170 $Y=647495
X3166 39302 44 73 39275 INVX2 $T=1280320 608685 0 180 $X=1278210 $Y=604130
X3167 39395 44 73 39380 INVX2 $T=1280320 647885 1 180 $X=1278210 $Y=647495
X3168 39493 44 73 39234 INVX2 $T=1282000 655725 0 180 $X=1279890 $Y=651170
X3169 39192 44 73 39423 INVX2 $T=1280880 624365 0 0 $X=1280450 $Y=623975
X3170 34118 44 73 39628 INVX2 $T=1285920 663565 1 0 $X=1285490 $Y=659010
X3171 32913 44 73 39650 INVX2 $T=1291520 647885 0 0 $X=1291090 $Y=647495
X3272 26514 44 73 26479 BUFX1 $T=775760 569485 1 180 $X=772530 $Y=569095
X3273 26514 44 73 102 BUFX1 $T=784160 522445 0 180 $X=780930 $Y=517890
X3274 27247 44 73 27181 BUFX1 $T=808800 687085 0 180 $X=805570 $Y=682530
X3275 27247 44 73 27324 BUFX1 $T=813280 671405 0 180 $X=810050 $Y=666850
X3276 26514 44 73 27616 BUFX1 $T=820560 561645 0 0 $X=820130 $Y=561255
X3277 26514 44 73 27646 BUFX1 $T=821680 538125 0 0 $X=821250 $Y=537735
X3278 26514 44 73 129 BUFX1 $T=831200 522445 0 0 $X=830770 $Y=522055
X3279 28420 44 73 26514 BUFX1 $T=858640 569485 0 180 $X=855410 $Y=564930
X3280 26514 44 73 28697 BUFX1 $T=863680 569485 0 0 $X=863250 $Y=569095
X3281 27247 44 73 29114 BUFX1 $T=876000 679245 0 0 $X=875570 $Y=678855
X3282 154 44 73 29140 BUFX1 $T=881600 671405 0 180 $X=878370 $Y=666850
X3283 252 44 73 28420 BUFX1 $T=930320 569485 0 180 $X=927090 $Y=564930
X3284 27247 44 73 30451 BUFX1 $T=932560 687085 0 0 $X=932130 $Y=686695
X3285 252 44 73 278 BUFX1 $T=938720 679245 0 0 $X=938290 $Y=678855
X3286 278 44 73 27247 BUFX1 $T=942640 679245 0 0 $X=942210 $Y=678855
X3287 278 44 73 154 BUFX1 $T=945440 702765 0 0 $X=945010 $Y=702375
X3288 154 44 73 307 BUFX1 $T=952720 702765 1 0 $X=952290 $Y=698210
X3289 28420 44 73 354 BUFX1 $T=1006480 569485 1 0 $X=1006050 $Y=564930
X3290 27247 44 73 358 BUFX1 $T=1010960 679245 0 0 $X=1010530 $Y=678855
X3291 354 44 73 33621 BUFX1 $T=1056320 608685 0 180 $X=1053090 $Y=604130
X3292 278 44 73 447 BUFX1 $T=1081520 710605 0 0 $X=1081090 $Y=710215
X3293 447 44 73 448 BUFX1 $T=1085440 710605 0 0 $X=1085010 $Y=710215
X3294 447 44 73 35561 BUFX1 $T=1132480 702765 0 180 $X=1129250 $Y=698210
X3295 28420 44 73 35773 BUFX1 $T=1142000 577325 0 180 $X=1138770 $Y=572770
X3296 35773 44 73 35821 BUFX1 $T=1139200 600845 0 0 $X=1138770 $Y=600455
X3297 35773 44 73 466 BUFX1 $T=1147040 569485 0 0 $X=1146610 $Y=569095
X3298 447 44 73 468 BUFX1 $T=1153200 726285 0 180 $X=1149970 $Y=721730
X3299 28420 44 73 36421 BUFX1 $T=1165520 569485 1 0 $X=1165090 $Y=564930
X3300 36421 44 73 36394 BUFX1 $T=1168320 577325 1 180 $X=1165090 $Y=576935
X3301 36421 44 73 36706 BUFX1 $T=1179520 553805 0 0 $X=1179090 $Y=553415
X3302 36421 44 73 478 BUFX1 $T=1189040 491085 0 180 $X=1185810 $Y=486530
X3303 36421 44 73 485 BUFX1 $T=1199120 506765 0 0 $X=1198690 $Y=506375
X3304 36421 44 73 37291 BUFX1 $T=1203600 569485 0 180 $X=1200370 $Y=564930
X3305 35773 44 73 37413 BUFX1 $T=1204160 593005 0 0 $X=1203730 $Y=592615
X3306 36421 44 73 491 BUFX1 $T=1212560 538125 1 0 $X=1212130 $Y=533570
X3307 35773 44 73 37744 BUFX1 $T=1219840 577325 0 0 $X=1219410 $Y=576935
X3308 44 73 53801 pad_in $T=74960 621325 0 270 $X=74960 $Y=530425
X3399 44 73 23984 24038 24013 ICV_77 $T=692880 608685 0 0 $X=692450 $Y=608295
X3400 44 73 23985 24039 24009 ICV_77 $T=692880 616525 0 0 $X=692450 $Y=616135
X3401 44 73 80 26084 26186 ICV_77 $T=755600 538125 0 0 $X=755170 $Y=537735
X3402 44 73 27637 119 27501 ICV_77 $T=820000 710605 1 0 $X=819570 $Y=706050
X3403 44 73 82 164 29295 ICV_77 $T=885520 726285 1 0 $X=885090 $Y=721730
X3404 44 73 29894 215 29748 ICV_77 $T=906240 561645 0 0 $X=905810 $Y=561255
X3405 44 73 30630 259 30542 ICV_77 $T=939840 585165 0 0 $X=939410 $Y=584775
X3406 44 73 30632 285 30633 ICV_77 $T=939840 718445 0 0 $X=939410 $Y=718055
X3407 44 73 184 30141 30873 ICV_77 $T=951040 553805 1 0 $X=950610 $Y=549250
X3408 44 73 31027 31065 30923 ICV_77 $T=956640 624365 0 0 $X=956210 $Y=623975
X3409 44 73 31057 31091 30916 ICV_77 $T=957760 498925 0 0 $X=957330 $Y=498535
X3410 44 73 32436 32486 32471 ICV_77 $T=1002560 553805 0 0 $X=1002130 $Y=553415
X3411 44 73 33554 331 33668 ICV_77 $T=1051840 506765 1 0 $X=1051410 $Y=502210
X3412 44 73 33502 220 33854 ICV_77 $T=1067520 569485 1 0 $X=1067090 $Y=564930
X3413 44 73 80 36830 36840 ICV_77 $T=1187920 593005 0 0 $X=1187490 $Y=592615
X3414 44 73 83 37299 37467 ICV_77 $T=1204160 726285 1 0 $X=1203730 $Y=721730
X3415 44 73 38763 39650 38715 ICV_77 $T=1285360 647885 1 0 $X=1284930 $Y=643330
X3520 44 24010 24057 24033 73 24038 24125 24010 ICV_112 $T=696240 640045 1 0 $X=695810 $Y=635490
X3521 44 24305 24355 24123 73 24458 24351 24190 ICV_112 $T=703520 608685 1 0 $X=703090 $Y=604130
X3522 44 25866 25915 25900 73 80 25476 25915 ICV_112 $T=748320 561645 1 0 $X=747890 $Y=557090
X3523 44 25950 25994 25967 73 80 25991 25994 ICV_112 $T=750560 514605 1 0 $X=750130 $Y=510050
X3524 44 80 26975 26868 73 78 26649 26837 ICV_112 $T=796480 585165 0 0 $X=796050 $Y=584775
X3525 44 80 26990 27194 73 27260 27194 27282 ICV_112 $T=805440 514605 1 0 $X=805010 $Y=510050
X3526 44 96 120 27524 73 82 118 27554 ICV_112 $T=821120 671405 0 0 $X=820690 $Y=671015
X3527 44 27807 27918 27529 73 27807 27891 27956 ICV_112 $T=832880 710605 1 0 $X=832450 $Y=706050
X3528 44 174 180 29588 73 185 176 29656 ICV_112 $T=895600 545965 0 0 $X=895170 $Y=545575
X3529 44 29618 198 30220 73 29845 162 249 ICV_112 $T=923040 491085 0 0 $X=922610 $Y=490695
X3530 44 30312 206 30288 73 196 30232 30345 ICV_112 $T=929200 561645 1 0 $X=928770 $Y=557090
X3531 44 165 30414 264 73 277 227 30441 ICV_112 $T=935360 506765 1 0 $X=934930 $Y=502210
X3532 44 258 271 268 73 199 227 30580 ICV_112 $T=937040 491085 1 0 $X=936610 $Y=486530
X3533 44 30541 259 30843 73 30918 259 30543 ICV_112 $T=951040 585165 0 0 $X=950610 $Y=584775
X3534 44 31147 28750 32225 73 32283 206 32301 ICV_112 $T=996960 569485 1 0 $X=996530 $Y=564930
X3535 44 31147 32499 32584 73 32679 32584 32660 ICV_112 $T=1009280 569485 1 0 $X=1008850 $Y=564930
X3536 44 370 205 32807 73 32978 236 32967 ICV_112 $T=1019360 569485 1 0 $X=1018930 $Y=564930
X3537 44 31147 33118 33090 73 165 30581 33169 ICV_112 $T=1027200 577325 1 0 $X=1026770 $Y=572770
X3538 44 33130 33212 380 73 33271 33130 392 ICV_112 $T=1031120 522445 0 0 $X=1030690 $Y=522055
X3539 44 33029 33279 33151 73 165 33273 33327 ICV_112 $T=1037840 530285 0 0 $X=1037410 $Y=529895
X3540 44 33335 33361 33300 73 33405 33091 33335 ICV_112 $T=1037840 640045 0 0 $X=1037410 $Y=639655
X3541 44 165 32792 33453 73 185 404 33515 ICV_112 $T=1044560 561645 1 0 $X=1044130 $Y=557090
X3542 44 33585 33634 33607 73 185 409 33669 ICV_112 $T=1052400 553805 0 0 $X=1051970 $Y=553415
X3543 44 431 437 33615 73 196 32695 33974 ICV_112 $T=1069200 506765 1 0 $X=1068770 $Y=502210
X3544 44 34055 206 34365 73 34157 206 34419 ICV_112 $T=1086000 538125 0 0 $X=1085570 $Y=537735
X3545 44 82 37603 37478 73 96 29939 37645 ICV_112 $T=1212000 647885 1 0 $X=1211570 $Y=643330
X3546 24077 24038 73 44 23987 XOR2X1 $T=702400 655725 1 180 $X=695810 $Y=655335
X3547 24329 24700 73 44 25251 XOR2X1 $T=746640 616525 1 180 $X=740050 $Y=616135
X3548 25584 25477 73 44 25968 XOR2X1 $T=746080 663565 1 0 $X=745650 $Y=659010
X3549 25713 25547 73 44 26097 XOR2X1 $T=750560 647885 1 0 $X=750130 $Y=643330
X3550 25419 26206 73 44 26277 XOR2X1 $T=758960 640045 0 0 $X=758530 $Y=639655
X3551 24566 26608 73 44 26661 XOR2X1 $T=779120 647885 0 0 $X=778690 $Y=647495
X3552 26740 26362 73 44 26641 XOR2X1 $T=788080 694925 0 180 $X=781490 $Y=690370
X3553 26861 26839 73 44 24329 XOR2X1 $T=793680 616525 0 180 $X=787090 $Y=611970
X3554 26960 26791 73 44 26858 XOR2X1 $T=798720 671405 0 180 $X=792130 $Y=666850
X3555 121 118 73 44 27440 XOR2X1 $T=822800 687085 0 180 $X=816210 $Y=682530
X3556 123 120 73 44 24264 XOR2X1 $T=826160 600845 1 180 $X=819570 $Y=600455
X3557 126 122 73 44 127 XOR2X1 $T=837360 726285 0 180 $X=830770 $Y=721730
X3558 28035 125 73 44 27933 XOR2X1 $T=841840 647885 1 180 $X=835250 $Y=647495
X3559 27859 27624 73 44 28181 XOR2X1 $T=848560 687085 0 0 $X=848130 $Y=686695
X3560 28181 136 73 44 28455 XOR2X1 $T=853600 687085 1 0 $X=853170 $Y=682530
X3561 28523 112 73 44 27751 XOR2X1 $T=862000 679245 0 180 $X=855410 $Y=674690
X3562 151 150 73 44 24700 XOR2X1 $T=878240 640045 0 180 $X=871650 $Y=635490
X3563 153 26485 73 44 29250 XOR2X1 $T=877120 616525 0 0 $X=876690 $Y=616135
X3564 156 157 73 44 126 XOR2X1 $T=886080 679245 0 180 $X=879490 $Y=674690
X3565 167 170 73 44 28231 XOR2X1 $T=896720 694925 1 180 $X=890130 $Y=694535
X3566 29590 163 73 44 29467 XOR2X1 $T=897840 726285 0 180 $X=891250 $Y=721730
X3567 197 194 73 44 27859 XOR2X1 $T=906800 710605 1 180 $X=900210 $Y=710215
X3568 29846 164 73 44 29736 XOR2X1 $T=908480 718445 0 180 $X=901890 $Y=713890
X3569 29957 29939 73 44 24530 XOR2X1 $T=912960 624365 1 180 $X=906370 $Y=623975
X3570 30444 30500 73 44 27820 XOR2X1 $T=938720 632205 1 180 $X=932130 $Y=631815
X3571 265 26839 73 44 30544 XOR2X1 $T=933680 616525 0 0 $X=933250 $Y=616135
X3572 275 270 73 44 24751 XOR2X1 $T=940400 632205 0 180 $X=933810 $Y=627650
X3573 30531 194 73 44 280 XOR2X1 $T=935920 710605 1 0 $X=935490 $Y=706050
X3574 30554 112 73 44 285 XOR2X1 $T=939280 702765 0 0 $X=938850 $Y=702375
X3575 30635 157 73 44 30742 XOR2X1 $T=942640 624365 0 0 $X=942210 $Y=623975
X3576 30475 30500 73 44 30815 XOR2X1 $T=946000 632205 0 0 $X=945570 $Y=631815
X3577 30814 30842 73 44 24861 XOR2X1 $T=953840 608685 1 180 $X=947250 $Y=608295
X3578 30880 30921 73 44 28133 XOR2X1 $T=957200 679245 0 180 $X=950610 $Y=674690
X3579 30742 30815 73 44 30892 XOR2X1 $T=952160 640045 1 0 $X=951730 $Y=635490
X3580 303 306 73 44 313 XOR2X1 $T=953280 702765 0 0 $X=952850 $Y=702375
X3581 30977 26467 73 44 292 XOR2X1 $T=955520 702765 1 0 $X=955090 $Y=698210
X3582 314 120 73 44 31117 XOR2X1 $T=957760 608685 1 0 $X=957330 $Y=604130
X3583 31240 26467 73 44 332 XOR2X1 $T=963920 702765 1 0 $X=963490 $Y=698210
X3584 30815 31117 73 44 31492 XOR2X1 $T=971760 624365 0 0 $X=971330 $Y=623975
X3585 338 341 73 44 30820 XOR2X1 $T=976800 702765 0 0 $X=976370 $Y=702375
X3586 344 31802 73 44 31327 XOR2X1 $T=986880 608685 1 180 $X=980290 $Y=608295
X3587 32581 97 73 44 359 XOR2X1 $T=1007600 726285 1 0 $X=1007170 $Y=721730
X3588 32806 26554 73 44 32913 XOR2X1 $T=1016000 624365 1 0 $X=1015570 $Y=619810
X3589 32865 107 73 44 33240 XOR2X1 $T=1028320 624365 1 0 $X=1027890 $Y=619810
X3590 33578 33650 73 44 33440 XOR2X1 $T=1058000 671405 1 180 $X=1051410 $Y=671015
X3591 33709 418 73 44 33476 XOR2X1 $T=1059680 624365 0 180 $X=1053090 $Y=619810
X3592 434 33912 73 44 33091 XOR2X1 $T=1071440 632205 0 180 $X=1064850 $Y=627650
X3593 435 147 73 44 33227 XOR2X1 $T=1071440 640045 0 180 $X=1064850 $Y=635490
X3594 33659 33912 73 44 444 XOR2X1 $T=1073120 632205 1 0 $X=1072690 $Y=627650
X3595 440 270 73 44 34118 XOR2X1 $T=1073120 640045 1 0 $X=1072690 $Y=635490
X3596 34100 445 73 44 33386 XOR2X1 $T=1081520 647885 0 180 $X=1074930 $Y=643330
X3597 33958 147 73 44 34347 XOR2X1 $T=1081520 632205 1 0 $X=1081090 $Y=627650
X3598 34367 34368 73 44 33201 XOR2X1 $T=1089360 640045 1 180 $X=1082770 $Y=639655
X3599 34352 107 73 44 34480 XOR2X1 $T=1086560 608685 0 0 $X=1086130 $Y=608295
X3600 454 34368 73 44 455 XOR2X1 $T=1092160 671405 0 0 $X=1091730 $Y=671015
X3601 31541 457 73 44 34569 XOR2X1 $T=1101680 718445 1 180 $X=1095090 $Y=718055
X3602 33946 464 73 44 35983 XOR2X1 $T=1142560 655725 1 0 $X=1142130 $Y=651170
X3603 32343 35984 73 44 35828 XOR2X1 $T=1149840 671405 1 180 $X=1143250 $Y=671015
X3604 36158 469 73 44 35838 XOR2X1 $T=1156560 694925 1 180 $X=1149970 $Y=694535
X3605 33639 471 73 44 36350 XOR2X1 $T=1158240 694925 0 0 $X=1157810 $Y=694535
X3606 32260 36540 73 44 36382 XOR2X1 $T=1175600 624365 1 180 $X=1169010 $Y=623975
X3607 34742 36058 73 44 36564 XOR2X1 $T=1169440 655725 0 0 $X=1169010 $Y=655335
X3608 32244 36578 73 44 36674 XOR2X1 $T=1174480 647885 0 0 $X=1174050 $Y=647495
X3609 34250 30842 73 44 36949 XOR2X1 $T=1185120 608685 0 0 $X=1184690 $Y=608295
X3610 37981 37883 73 44 37798 XOR2X1 $T=1233840 624365 1 180 $X=1227250 $Y=623975
X3611 38023 37603 73 44 36659 XOR2X1 $T=1235520 640045 1 180 $X=1228930 $Y=639655
X3612 38024 37821 73 44 37765 XOR2X1 $T=1235520 647885 1 180 $X=1228930 $Y=647495
X3613 34480 38763 73 44 38891 XOR2X1 $T=1261840 616525 1 0 $X=1261410 $Y=611970
X3614 44 73 24191 24145 23985 ICV_96 $T=702400 624365 1 180 $X=699170 $Y=623975
X3615 44 73 82 25547 26048 ICV_96 $T=756160 655725 1 180 $X=752930 $Y=655335
X3616 44 73 27440 96 27425 ICV_96 $T=816080 671405 1 180 $X=812850 $Y=671015
X3617 44 73 27839 27765 27686 ICV_96 $T=832320 718445 1 180 $X=829090 $Y=718055
X3618 44 73 28174 139 27626 ICV_96 $T=848000 718445 1 180 $X=844770 $Y=718055
X3619 44 73 29618 29507 178 ICV_96 $T=898960 491085 0 180 $X=895730 $Y=486530
X3620 44 73 196 29878 30140 ICV_96 $T=921920 545965 0 180 $X=918690 $Y=541410
X3621 44 73 184 29688 30299 ICV_96 $T=929760 577325 0 180 $X=926530 $Y=572770
X3622 44 73 185 268 30716 ICV_96 $T=951040 545965 1 180 $X=947810 $Y=545575
X3623 44 73 369 353 367 ICV_96 $T=1021040 491085 0 180 $X=1017810 $Y=486530
X3624 44 73 33113 33102 33172 ICV_96 $T=1032800 663565 0 180 $X=1029570 $Y=659010
X3625 44 73 33271 33131 32627 ICV_96 $T=1037280 538125 1 180 $X=1034050 $Y=537735
X3626 44 73 165 28767 33337 ICV_96 $T=1041760 545965 1 180 $X=1038530 $Y=545575
X3627 44 73 158 28767 33393 ICV_96 $T=1043440 545965 0 180 $X=1040210 $Y=541410
X3628 44 73 33443 33274 33396 ICV_96 $T=1045680 632205 1 180 $X=1042450 $Y=631815
X3629 44 73 158 32499 33475 ICV_96 $T=1047920 538125 0 180 $X=1044690 $Y=533570
X3630 44 73 199 33369 33608 ICV_96 $T=1055200 577325 0 180 $X=1051970 $Y=572770
X3631 44 73 33681 33446 416 ICV_96 $T=1058000 514605 1 180 $X=1054770 $Y=514215
X3632 44 73 33680 31091 33679 ICV_96 $T=1058560 498925 0 180 $X=1055330 $Y=494370
X3633 44 73 33749 33578 33748 ICV_96 $T=1063040 640045 1 180 $X=1059810 $Y=639655
X3634 44 73 158 31556 428 ICV_96 $T=1065840 506765 1 180 $X=1062610 $Y=506375
X3635 44 73 33830 33485 32832 ICV_96 $T=1066400 514605 0 180 $X=1063170 $Y=510050
X3636 44 73 432 33822 33522 ICV_96 $T=1070320 514605 0 180 $X=1067090 $Y=510050
X3637 44 73 165 28266 33899 ICV_96 $T=1070880 491085 1 180 $X=1067650 $Y=490695
X3638 44 73 34040 220 33998 ICV_96 $T=1077040 561645 1 180 $X=1073810 $Y=561255
X3639 44 73 34055 183 34316 ICV_96 $T=1088240 553805 0 180 $X=1085010 $Y=549250
X3640 44 73 35828 96 35812 ICV_96 $T=1142560 671405 1 180 $X=1139330 $Y=671015
X3641 44 73 38636 34118 38590 ICV_96 $T=1256800 655725 1 180 $X=1253570 $Y=655335
X3642 44 73 39027 38913 38966 ICV_96 $T=1269680 624365 1 180 $X=1266450 $Y=623975
X3643 44 73 36949 34480 39422 ICV_96 $T=1280880 616525 1 180 $X=1277650 $Y=616135
X3644 44 73 24195 24417 24351 ICV_94 $T=706880 624365 0 0 $X=706450 $Y=623975
X3645 44 73 24960 24776 25321 ICV_94 $T=729280 608685 0 0 $X=728850 $Y=608295
X3646 44 73 86 26176 26156 ICV_94 $T=755600 726285 0 0 $X=755170 $Y=725895
X3647 44 73 82 97 26356 ICV_94 $T=773520 663565 1 0 $X=773090 $Y=659010
X3648 44 73 28138 27801 28087 ICV_94 $T=844080 694925 0 0 $X=843650 $Y=694535
X3649 44 73 158 28826 29425 ICV_94 $T=887200 514605 0 0 $X=886770 $Y=514215
X3650 44 73 29322 29999 218 ICV_94 $T=910160 498925 0 0 $X=909730 $Y=498535
X3651 44 73 217 195 29984 ICV_94 $T=910160 522445 1 0 $X=909730 $Y=517890
X3652 44 73 30411 283 30569 ICV_94 $T=939840 491085 0 0 $X=939410 $Y=490695
X3653 44 73 30957 30935 30777 ICV_94 $T=954960 514605 0 0 $X=954530 $Y=514215
X3654 44 73 310 285 31179 ICV_94 $T=962240 710605 1 0 $X=961810 $Y=706050
X3655 44 73 31327 31074 31746 ICV_94 $T=980720 647885 0 0 $X=980290 $Y=647495
X3656 44 73 33029 33157 33065 ICV_94 $T=1032240 569485 1 0 $X=1031810 $Y=564930
X3657 44 73 317 33347 33253 ICV_94 $T=1035600 498925 1 0 $X=1035170 $Y=494370
X3658 44 73 33464 33091 33581 ICV_94 $T=1049600 640045 1 0 $X=1049170 $Y=635490
X3659 44 73 33454 34353 34334 ICV_94 $T=1083760 687085 1 0 $X=1083330 $Y=682530
X3660 44 73 80 33977 34369 ICV_94 $T=1088800 687085 0 0 $X=1088370 $Y=686695
X3661 44 73 82 464 36088 ICV_94 $T=1149840 671405 0 0 $X=1149410 $Y=671015
X3662 44 73 34347 39628 39493 ICV_94 $T=1282000 655725 1 0 $X=1281570 $Y=651170
X3663 44 73 24751 24264 24385 ICV_101 $T=711920 632205 1 0 $X=711490 $Y=627650
X3664 44 73 24776 25061 24961 ICV_101 $T=725360 593005 0 0 $X=724930 $Y=592615
X3665 44 73 25384 25100 25385 ICV_101 $T=730960 632205 0 0 $X=730530 $Y=631815
X3666 44 73 89 26217 26231 ICV_101 $T=757840 647885 0 0 $X=757410 $Y=647495
X3667 44 73 89 27902 145 ICV_101 $T=849680 655725 1 0 $X=849250 $Y=651170
X3668 44 73 158 28353 29422 ICV_101 $T=886640 530285 0 0 $X=886210 $Y=529895
X3669 44 73 158 29293 29711 ICV_101 $T=897840 569485 0 0 $X=897410 $Y=569095
X3670 44 73 285 30683 296 ICV_101 $T=946000 710605 0 0 $X=945570 $Y=710215
X3671 44 73 216 287 30836 ICV_101 $T=948800 538125 0 0 $X=948370 $Y=537735
X3672 44 73 31358 292 31508 ICV_101 $T=972880 710605 1 0 $X=972450 $Y=706050
X3673 44 73 31887 31492 31992 ICV_101 $T=988000 616525 1 0 $X=987570 $Y=611970
X3674 44 73 32628 29346 32302 ICV_101 $T=1008160 569485 0 0 $X=1007730 $Y=569095
X3675 44 73 32828 32791 32806 ICV_101 $T=1014880 553805 0 0 $X=1014450 $Y=553415
X3676 44 73 33127 33054 32998 ICV_101 $T=1025520 498925 0 0 $X=1025090 $Y=498535
X3677 44 73 165 31858 33131 ICV_101 $T=1026080 545965 0 0 $X=1025650 $Y=545575
X3678 44 73 33227 33201 33062 ICV_101 $T=1029440 655725 1 0 $X=1029010 $Y=651170
X3679 44 73 33518 33516 33523 ICV_101 $T=1045680 577325 0 0 $X=1045250 $Y=576935
X3680 44 73 158 33671 33681 ICV_101 $T=1066400 522445 0 0 $X=1065970 $Y=522055
X3681 44 73 34614 34546 34685 ICV_101 $T=1096080 608685 0 0 $X=1095650 $Y=608295
X3682 44 73 78 33977 34682 ICV_101 $T=1096080 679245 1 0 $X=1095650 $Y=674690
X3683 44 73 38297 38448 38720 ICV_101 $T=1255120 585165 1 0 $X=1254690 $Y=580610
X3684 44 73 38694 38563 38990 ICV_101 $T=1264080 545965 0 0 $X=1263650 $Y=545575
X3685 44 73 38990 38788 39030 ICV_101 $T=1265200 553805 1 0 $X=1264770 $Y=549250
X3717 44 73 24673 24472 24631 ICV_79 $T=714720 663565 0 180 $X=711490 $Y=659010
X3718 44 73 77 74 25783 ICV_79 $T=748320 718445 0 180 $X=745090 $Y=713890
X3719 44 73 77 75 25901 ICV_79 $T=751120 718445 1 180 $X=747890 $Y=718055
X3720 44 73 83 25827 84 ICV_79 $T=756160 718445 1 180 $X=752930 $Y=718055
X3721 44 73 82 26362 26391 ICV_79 $T=770160 679245 0 180 $X=766930 $Y=674690
X3722 44 73 82 26608 26787 ICV_79 $T=790880 663565 1 180 $X=787650 $Y=663175
X3723 44 73 96 26839 26779 ICV_79 $T=797040 655725 0 180 $X=793810 $Y=651170
X3724 44 73 78 27658 28165 ICV_79 $T=848000 616525 0 180 $X=844770 $Y=611970
X3725 44 73 80 27713 28303 ICV_79 $T=854720 608685 0 180 $X=851490 $Y=604130
X3726 44 73 96 152 29104 ICV_79 $T=879360 726285 0 180 $X=876130 $Y=721730
X3727 44 73 29334 29456 166 ICV_79 $T=893360 506765 1 180 $X=890130 $Y=506375
X3728 44 73 165 28783 168 ICV_79 $T=895600 522445 1 180 $X=892370 $Y=522055
X3729 44 73 80 28572 29738 ICV_79 $T=904000 624365 0 180 $X=900770 $Y=619810
X3730 44 73 29878 199 29742 ICV_79 $T=910160 553805 0 180 $X=906930 $Y=549250
X3731 44 73 30069 215 30048 ICV_79 $T=918000 585165 1 180 $X=914770 $Y=584775
X3732 44 73 196 227 30119 ICV_79 $T=920800 538125 1 180 $X=917570 $Y=537735
X3733 44 73 89 29844 237 ICV_79 $T=921920 718445 1 180 $X=918690 $Y=718055
X3734 44 73 30163 220 29657 ICV_79 $T=922480 577325 1 180 $X=919250 $Y=576935
X3735 44 73 243 30093 30136 ICV_79 $T=924720 553805 0 180 $X=921490 $Y=549250
X3736 44 73 78 30098 30127 ICV_79 $T=924720 663565 1 180 $X=921490 $Y=663175
X3737 44 73 243 29655 30229 ICV_79 $T=926400 506765 1 180 $X=923170 $Y=506375
X3738 44 73 184 30097 30247 ICV_79 $T=926960 561645 0 180 $X=923730 $Y=557090
X3739 44 73 171 168 30187 ICV_79 $T=928080 514605 1 180 $X=924850 $Y=514215
X3740 44 73 165 29858 30231 ICV_79 $T=928640 514605 0 180 $X=925410 $Y=510050
X3741 44 73 216 30052 30458 ICV_79 $T=936480 530285 1 180 $X=933250 $Y=529895
X3742 44 73 30528 29877 30399 ICV_79 $T=939840 522445 1 180 $X=936610 $Y=522055
X3743 44 73 216 274 30551 ICV_79 $T=941520 530285 1 180 $X=938290 $Y=529895
X3744 44 73 30623 236 30599 ICV_79 $T=943760 577325 1 180 $X=940530 $Y=576935
X3745 44 73 31066 30892 31052 ICV_79 $T=962800 640045 1 180 $X=959570 $Y=639655
X3746 44 73 31164 31118 31149 ICV_79 $T=966160 616525 0 180 $X=962930 $Y=611970
X3747 44 73 31995 32117 32114 ICV_79 $T=997520 671405 0 180 $X=994290 $Y=666850
X3748 44 73 351 334 32434 ICV_79 $T=1007040 514605 0 180 $X=1003810 $Y=510050
X3749 44 73 80 31195 32285 ICV_79 $T=1007040 679245 1 180 $X=1003810 $Y=678855
X3750 44 73 32628 28124 32648 ICV_79 $T=1014320 577325 1 180 $X=1011090 $Y=576935
X3751 44 73 33104 33046 33093 ICV_79 $T=1031120 553805 0 180 $X=1027890 $Y=549250
X3752 44 73 33198 33173 33187 ICV_79 $T=1033360 679245 0 180 $X=1030130 $Y=674690
X3753 44 73 33225 33169 33347 ICV_79 $T=1041200 538125 1 180 $X=1037970 $Y=537735
X3754 44 73 424 33728 423 ICV_79 $T=1061920 491085 0 180 $X=1058690 $Y=486530
X3755 44 73 33385 33213 427 ICV_79 $T=1064720 553805 0 180 $X=1061490 $Y=549250
X3756 44 73 33831 272 33733 ICV_79 $T=1066400 585165 1 180 $X=1063170 $Y=584775
X3757 44 73 33864 259 33868 ICV_79 $T=1068640 585165 0 180 $X=1065410 $Y=580610
X3758 44 73 33953 220 33718 ICV_79 $T=1074240 577325 1 180 $X=1071010 $Y=576935
X3759 44 73 33818 33899 33995 ICV_79 $T=1075920 498925 0 180 $X=1072690 $Y=494370
X3760 44 73 34040 215 34041 ICV_79 $T=1077600 569485 0 180 $X=1074370 $Y=564930
X3761 44 73 217 446 34141 ICV_79 $T=1083200 491085 0 180 $X=1079970 $Y=486530
X3762 44 73 243 34174 34346 ICV_79 $T=1088800 545965 0 180 $X=1085570 $Y=541410
X3763 44 73 33519 183 34459 ICV_79 $T=1093280 561645 0 180 $X=1090050 $Y=557090
X3764 44 73 80 34640 35237 ICV_79 $T=1118480 687085 1 180 $X=1115250 $Y=686695
X3765 44 73 89 37256 37360 ICV_79 $T=1205840 616525 1 180 $X=1202610 $Y=616135
X3766 44 73 37579 37480 37554 ICV_79 $T=1213680 710605 0 180 $X=1210450 $Y=706050
X3767 44 73 80 36274 37685 ICV_79 $T=1219840 585165 1 180 $X=1216610 $Y=584775
X3768 44 73 37799 37615 37784 ICV_79 $T=1226000 710605 0 180 $X=1222770 $Y=706050
X3769 44 73 78 36758 37783 ICV_79 $T=1226560 545965 1 180 $X=1223330 $Y=545575
X3770 44 73 80 37796 38022 ICV_79 $T=1236080 514605 0 180 $X=1232850 $Y=510050
X3771 44 73 38291 38006 38350 ICV_79 $T=1247280 538125 0 180 $X=1244050 $Y=533570
X3772 44 73 38391 38006 38279 ICV_79 $T=1247840 530285 0 180 $X=1244610 $Y=525730
X3773 44 73 38360 38189 38297 ICV_79 $T=1248960 585165 0 180 $X=1245730 $Y=580610
X3774 44 73 38732 38516 38821 ICV_79 $T=1263520 561645 1 180 $X=1260290 $Y=561255
X3775 44 73 39275 39088 39261 ICV_79 $T=1276400 608685 0 180 $X=1273170 $Y=604130
X3776 44 73 24153 24776 24750 ICV_109 $T=715840 593005 0 0 $X=715410 $Y=592615
X3777 44 73 25966 26010 25993 ICV_109 $T=751120 498925 0 0 $X=750690 $Y=498535
X3778 44 73 26814 26842 26831 ICV_109 $T=790320 561645 1 0 $X=789890 $Y=557090
X3779 44 73 82 157 29441 ICV_109 $T=889440 710605 0 0 $X=889010 $Y=710215
X3780 44 73 29571 29507 29677 ICV_109 $T=898960 498925 0 0 $X=898530 $Y=498535
X3781 44 73 80 29790 29662 ICV_109 $T=902880 624365 0 0 $X=902450 $Y=623975
X3782 44 73 185 191 29802 ICV_109 $T=903440 553805 1 0 $X=903010 $Y=549250
X3783 44 73 29709 30038 223 ICV_109 $T=913520 491085 0 0 $X=913090 $Y=490695
X3784 44 73 217 30052 179 ICV_109 $T=914080 522445 0 0 $X=913650 $Y=522055
X3785 44 73 30275 236 30346 ICV_109 $T=930880 577325 0 0 $X=930450 $Y=576935
X3786 44 73 30447 30545 30608 ICV_109 $T=940960 679245 1 0 $X=940530 $Y=674690
X3787 44 73 196 30605 30649 ICV_109 $T=944880 553805 0 0 $X=944450 $Y=553415
X3788 44 73 184 30334 30752 ICV_109 $T=948800 553805 0 0 $X=948370 $Y=553415
X3789 44 73 218 30893 301 ICV_109 $T=952720 498925 1 0 $X=952290 $Y=494370
X3790 44 73 30919 31028 31011 ICV_109 $T=958320 616525 0 0 $X=957890 $Y=616135
X3791 44 73 31305 333 31189 ICV_109 $T=969520 491085 0 0 $X=969090 $Y=490695
X3792 44 73 31065 31399 31378 ICV_109 $T=971200 647885 0 0 $X=970770 $Y=647495
X3793 44 73 32377 28032 32520 ICV_109 $T=1007600 577325 0 0 $X=1007170 $Y=576935
X3794 44 73 243 32845 32827 ICV_109 $T=1017680 545965 1 0 $X=1017250 $Y=541410
X3795 44 73 33030 220 33078 ICV_109 $T=1028320 585165 1 0 $X=1027890 $Y=580610
X3796 44 73 216 383 33168 ICV_109 $T=1030000 514605 0 0 $X=1029570 $Y=514215
X3797 44 73 33225 33131 386 ICV_109 $T=1032800 538125 1 0 $X=1032370 $Y=533570
X3798 44 73 32377 33242 33344 ICV_109 $T=1037280 577325 1 0 $X=1036850 $Y=572770
X3799 44 73 33327 33343 368 ICV_109 $T=1037840 530285 1 0 $X=1037410 $Y=525730
X3800 44 73 33305 32864 33359 ICV_109 $T=1038400 491085 1 0 $X=1037970 $Y=486530
X3801 44 73 33343 33368 376 ICV_109 $T=1038400 522445 0 0 $X=1037970 $Y=522055
X3802 44 73 33227 33091 33360 ICV_109 $T=1038400 640045 1 0 $X=1037970 $Y=635490
X3803 44 73 158 33415 33225 ICV_109 $T=1041200 538125 1 0 $X=1040770 $Y=533570
X3804 44 73 158 33315 33212 ICV_109 $T=1041760 530285 1 0 $X=1041330 $Y=525730
X3805 44 73 317 402 33434 ICV_109 $T=1042320 491085 1 0 $X=1041890 $Y=486530
X3806 44 73 33464 33488 33316 ICV_109 $T=1045120 671405 0 0 $X=1044690 $Y=671015
X3807 44 73 33226 259 33520 ICV_109 $T=1047920 585165 0 0 $X=1047490 $Y=584775
X3808 44 73 165 33272 33541 ICV_109 $T=1050160 553805 1 0 $X=1049730 $Y=549250
X3809 44 73 33576 33601 33590 ICV_109 $T=1051280 522445 0 0 $X=1050850 $Y=522055
X3810 44 73 184 407 33670 ICV_109 $T=1054640 561645 0 0 $X=1054210 $Y=561255
X3811 44 73 33682 33385 33784 ICV_109 $T=1063040 545965 1 0 $X=1062610 $Y=541410
X3812 44 73 33769 33312 33856 ICV_109 $T=1065280 679245 0 0 $X=1064850 $Y=678855
X3813 44 73 34024 33996 443 ICV_109 $T=1074800 491085 0 0 $X=1074370 $Y=490695
X3814 44 73 185 33692 34056 ICV_109 $T=1075360 545965 1 0 $X=1074930 $Y=541410
X3815 44 73 33831 183 34115 ICV_109 $T=1077600 538125 1 0 $X=1077170 $Y=533570
X3816 44 73 34098 34230 34219 ICV_109 $T=1081520 522445 0 0 $X=1081090 $Y=522055
X3817 44 73 89 37709 37673 ICV_109 $T=1219840 616525 0 0 $X=1219410 $Y=616135
X3818 44 73 37783 37819 37797 ICV_109 $T=1223760 514605 1 0 $X=1223330 $Y=510050
X3819 44 73 24195 24700 24588 ICV_105 $T=716400 616525 1 0 $X=715970 $Y=611970
X3820 44 73 24861 24530 25642 ICV_105 $T=737680 624365 0 0 $X=737250 $Y=623975
X3821 44 73 89 26216 26145 ICV_105 $T=756720 608685 0 0 $X=756290 $Y=608295
X3822 44 73 80 26453 26716 ICV_105 $T=783040 538125 1 0 $X=782610 $Y=533570
X3823 44 73 80 26999 26842 ICV_105 $T=796480 561645 0 0 $X=796050 $Y=561255
X3824 44 73 89 27424 27444 ICV_105 $T=810480 640045 1 0 $X=810050 $Y=635490
X3825 44 73 158 160 29334 ICV_105 $T=881600 506765 1 0 $X=881170 $Y=502210
X3826 44 73 165 160 29421 ICV_105 $T=885520 514605 1 0 $X=885090 $Y=510050
X3827 44 73 29548 29519 26861 ICV_105 $T=890000 538125 0 0 $X=889570 $Y=537735
X3828 44 73 30158 220 30149 ICV_105 $T=916320 577325 1 0 $X=915890 $Y=572770
X3829 44 73 158 250 29618 ICV_105 $T=923600 498925 1 0 $X=923170 $Y=494370
X3830 44 73 308 320 31417 ICV_105 $T=968960 726285 0 0 $X=968530 $Y=725895
X3831 44 73 31506 31417 31494 ICV_105 $T=971200 718445 0 0 $X=970770 $Y=718055
X3832 44 73 33253 32864 33127 ICV_105 $T=1029440 498925 1 0 $X=1029010 $Y=494370
X3833 44 73 165 32794 400 ICV_105 $T=1038960 506765 0 0 $X=1038530 $Y=506375
X3834 44 73 185 402 33766 ICV_105 $T=1057440 491085 0 0 $X=1057010 $Y=490695
X3835 44 73 165 31556 431 ICV_105 $T=1061360 506765 1 0 $X=1060930 $Y=502210
X3836 44 73 78 35294 36217 ICV_105 $T=1153200 624365 1 0 $X=1152770 $Y=619810
X3837 44 73 37387 37277 487 ICV_105 $T=1200240 491085 0 0 $X=1199810 $Y=490695
X3838 44 73 38081 37991 38244 ICV_105 $T=1237200 710605 0 0 $X=1236770 $Y=710215
X3839 44 73 38451 36564 38417 ICV_105 $T=1243920 647885 1 0 $X=1243490 $Y=643330
X3840 44 73 80 37882 38484 ICV_105 $T=1245600 593005 0 0 $X=1245170 $Y=592615
X3841 44 73 38665 38484 38654 ICV_105 $T=1251760 593005 0 0 $X=1251330 $Y=592615
X3862 44 73 25828 25782 578 577 ICV_111 $T=723120 702765 1 0 $X=722690 $Y=698210
X3863 44 73 26483 26463 578 102 ICV_111 $T=762320 498925 0 0 $X=761890 $Y=498535
X3864 44 73 27695 27670 578 27324 ICV_111 $T=813840 632205 0 0 $X=813410 $Y=631815
X3865 44 73 27762 27669 578 27646 ICV_111 $T=815520 522445 1 0 $X=815090 $Y=517890
X3866 44 73 28123 28033 578 27616 ICV_111 $T=830640 561645 0 0 $X=830210 $Y=561255
X3867 44 73 28867 28724 578 28697 ICV_111 $T=864800 561645 0 0 $X=864370 $Y=561255
X3868 44 73 29346 29248 578 28697 ICV_111 $T=873200 600845 1 0 $X=872770 $Y=596290
X3869 44 73 29928 29842 578 28697 ICV_111 $T=897280 593005 0 0 $X=896850 $Y=592615
X3870 44 73 30245 30221 578 580 ICV_111 $T=912960 718445 1 0 $X=912530 $Y=713890
X3871 44 73 33977 34348 578 448 ICV_111 $T=1087120 694925 1 0 $X=1086690 $Y=690370
X3872 44 73 35308 35192 578 35821 ICV_111 $T=1111760 640045 1 0 $X=1111330 $Y=635490
X3873 44 73 30921 35763 578 35561 ICV_111 $T=1128000 694925 1 0 $X=1127570 $Y=690370
X3874 44 73 475 36636 578 468 ICV_111 $T=1166640 726285 1 0 $X=1166210 $Y=721730
X3875 44 73 30500 36713 578 35561 ICV_111 $T=1167200 647885 1 0 $X=1166770 $Y=643330
X3876 44 73 476 36664 578 468 ICV_111 $T=1167200 718445 0 0 $X=1166770 $Y=718055
X3877 44 73 37675 37554 578 37413 ICV_111 $T=1201360 718445 0 0 $X=1200930 $Y=718055
X3878 44 73 37709 37695 578 36706 ICV_111 $T=1209200 530285 0 0 $X=1208770 $Y=529895
X3879 44 73 37944 38007 578 37291 ICV_111 $T=1220400 561645 0 0 $X=1219970 $Y=561255
X3880 44 73 76 26156 578 577 ICV_113 $T=748320 726285 0 180 $X=722690 $Y=721730
X3881 44 73 26443 26738 578 27646 ICV_113 $T=799840 522445 1 180 $X=774210 $Y=522055
X3882 44 73 26946 27673 578 27616 ICV_113 $T=822240 561645 0 180 $X=796610 $Y=557090
X3883 44 73 28244 28680 578 29114 ICV_113 $T=875440 663565 1 180 $X=849810 $Y=663175
X3884 44 73 30298 31322 578 307 ICV_113 $T=970640 694925 1 180 $X=945010 $Y=694535
X3885 44 73 31195 32303 578 358 ICV_113 $T=1012640 679245 0 180 $X=987010 $Y=674690
X3886 44 73 33671 33986 578 33621 ICV_113 $T=1081520 593005 1 180 $X=1055890 $Y=592615
X3887 44 73 34640 35370 578 35561 ICV_113 $T=1131360 694925 1 180 $X=1105730 $Y=694535
X3888 44 73 31194 35450 578 36394 ICV_113 $T=1134160 593005 1 180 $X=1108530 $Y=592615
X3889 44 73 456 35660 578 466 ICV_113 $T=1143680 561645 1 180 $X=1118050 $Y=561255
X3890 44 73 31326 35800 578 466 ICV_113 $T=1149840 553805 0 180 $X=1124210 $Y=549250
X3891 44 73 35810 36406 578 36706 ICV_113 $T=1181200 530285 0 180 $X=1155570 $Y=525730
X3892 44 73 35590 36601 578 37291 ICV_113 $T=1187920 608685 0 180 $X=1162290 $Y=604130
X3893 44 73 35430 37025 578 37291 ICV_113 $T=1192400 585165 1 180 $X=1166770 $Y=584775
X3894 44 73 34368 37061 578 37413 ICV_113 $T=1202480 663565 1 180 $X=1176850 $Y=663175
X3895 44 73 36758 37258 578 37291 ICV_113 $T=1208640 561645 1 180 $X=1183010 $Y=561255
X3896 44 73 36446 37391 578 491 ICV_113 $T=1219840 553805 0 180 $X=1194210 $Y=549250
X3897 44 73 37435 37710 578 37413 ICV_113 $T=1232160 608685 1 180 $X=1206530 $Y=608295
X4039 44 73 25252 25083 25322 25338 ICV_97 $T=729280 624365 0 0 $X=728850 $Y=623975
X4040 44 73 25459 25651 25660 25642 ICV_97 $T=739920 624365 1 0 $X=739490 $Y=619810
X4041 44 73 26391 26587 26604 26603 ICV_97 $T=776880 671405 0 0 $X=776450 $Y=671015
X4042 44 73 127 27891 27943 27751 ICV_97 $T=834560 702765 1 0 $X=834130 $Y=698210
X4043 44 73 28376 26247 146 28610 ICV_97 $T=859200 671405 1 0 $X=858770 $Y=666850
X4044 44 73 29833 219 30027 30035 ICV_97 $T=911280 545965 0 0 $X=910850 $Y=545575
X4045 44 73 31165 31205 31060 31238 ICV_97 $T=963920 632205 0 0 $X=963490 $Y=631815
X4046 44 73 31469 31306 31541 31468 ICV_97 $T=974000 671405 0 0 $X=973570 $Y=671015
X4047 44 73 31577 31206 31943 31399 ICV_97 $T=986320 647885 1 0 $X=985890 $Y=643330
X4048 44 73 31908 31951 31972 31797 ICV_97 $T=987440 655725 0 0 $X=987010 $Y=655335
X4049 44 73 32413 32586 32612 32626 ICV_97 $T=1008160 522445 1 0 $X=1007730 $Y=517890
X4050 44 73 33512 33474 33555 33565 ICV_97 $T=1047360 506765 1 0 $X=1046930 $Y=502210
X4051 44 73 33386 33328 33361 33227 ICV_97 $T=1047360 640045 0 0 $X=1046930 $Y=639655
X4052 44 73 289 33553 33638 33648 ICV_97 $T=1051280 530285 0 0 $X=1050850 $Y=529895
X4053 44 73 33910 33711 33946 33920 ICV_97 $T=1068640 647885 0 0 $X=1068210 $Y=647495
X4054 44 73 33882 33944 33975 33886 ICV_97 $T=1069760 545965 1 0 $X=1069330 $Y=541410
X4055 44 73 39356 39407 39233 39422 ICV_97 $T=1276400 632205 0 0 $X=1275970 $Y=631815
X4056 44 73 25155 24038 25365 ICV_99 $T=729280 655725 0 0 $X=728850 $Y=655335
X4057 44 73 89 26483 26474 ICV_99 $T=768480 616525 1 0 $X=768050 $Y=611970
X4058 44 73 26664 26682 26672 ICV_99 $T=779120 585165 1 0 $X=778690 $Y=580610
X4059 44 73 82 107 26865 ICV_99 $T=788640 624365 0 0 $X=788210 $Y=623975
X4060 44 73 78 26999 26664 ICV_99 $T=794240 585165 1 0 $X=793810 $Y=580610
X4061 44 73 78 111 27438 ICV_99 $T=810480 538125 0 0 $X=810050 $Y=537735
X4062 44 73 82 120 27415 ICV_99 $T=816640 640045 1 0 $X=816210 $Y=635490
X4063 44 73 158 28122 29322 ICV_99 $T=881040 498925 1 0 $X=880610 $Y=494370
X4064 44 73 89 30060 224 ICV_99 $T=911280 726285 1 0 $X=910850 $Y=721730
X4065 44 73 89 30190 242 ICV_99 $T=917440 726285 1 0 $X=917010 $Y=721730
X4066 44 73 286 266 30853 ICV_99 $T=948240 498925 0 0 $X=947810 $Y=498535
X4067 44 73 305 311 30790 ICV_99 $T=950480 726285 1 0 $X=950050 $Y=721730
X4068 44 73 31065 31206 31205 ICV_99 $T=962240 624365 0 0 $X=961810 $Y=623975
X4069 44 73 30051 334 31321 ICV_99 $T=967280 506765 0 0 $X=966850 $Y=506375
X4070 44 73 33746 33312 33672 ICV_99 $T=1057440 687085 1 0 $X=1057010 $Y=682530
X4071 44 73 77 504 38190 ICV_99 $T=1241120 718445 0 0 $X=1240690 $Y=718055
X4072 44 73 78 505 38665 ICV_99 $T=1257920 593005 0 0 $X=1257490 $Y=592615
X4073 44 73 39089 38520 39104 ICV_99 $T=1266320 663565 0 0 $X=1265890 $Y=663175
X4074 44 73 25493 25540 25566 25437 ICV_100 $T=734880 647885 1 0 $X=734450 $Y=643330
X4075 44 73 26048 26109 26122 26145 ICV_100 $T=752240 663565 1 0 $X=751810 $Y=659010
X4076 44 73 27545 27578 27422 27603 ICV_100 $T=816640 702765 0 0 $X=816210 $Y=702375
X4077 44 73 29616 29742 29760 29656 ICV_100 $T=898400 553805 0 0 $X=897970 $Y=553415
X4078 44 73 30026 30225 30244 245 ICV_100 $T=920240 538125 1 0 $X=919810 $Y=533570
X4079 44 73 30288 251 30337 30345 ICV_100 $T=924720 553805 0 0 $X=924290 $Y=553415
X4080 44 73 30346 30186 30397 30412 ICV_100 $T=927520 593005 1 0 $X=927090 $Y=588450
X4081 44 73 31239 31327 31438 31399 ICV_100 $T=970080 655725 1 0 $X=969650 $Y=651170
X4082 44 73 31638 31450 31832 29250 ICV_100 $T=981840 624365 0 0 $X=981410 $Y=623975
X4083 44 73 31286 31950 31951 31781 ICV_100 $T=985760 655725 1 0 $X=985330 $Y=651170
X4084 44 73 32046 31943 32080 32075 ICV_100 $T=990800 647885 1 0 $X=990370 $Y=643330
X4085 44 73 32318 32457 32486 32519 ICV_100 $T=1002560 585165 1 0 $X=1002130 $Y=580610
X4086 44 73 33275 33309 33324 33172 ICV_100 $T=1032800 663565 0 0 $X=1032370 $Y=663175
X4087 44 73 33140 33114 33345 33227 ICV_100 $T=1033920 632205 0 0 $X=1033490 $Y=631815
X4088 44 73 33610 33616 33659 33503 ICV_100 $T=1050720 593005 1 0 $X=1050290 $Y=588450
X4089 44 73 33689 33520 33609 33733 ICV_100 $T=1054640 585165 0 0 $X=1054210 $Y=584775
X4090 44 73 38891 38600 39088 32913 ICV_100 $T=1265200 608685 1 0 $X=1264770 $Y=604130
X4091 44 73 24700 24264 24329 25383 ICV_107 $T=736000 608685 0 0 $X=735570 $Y=608295
X4092 44 73 93 26065 26618 26616 ICV_107 $T=779120 561645 1 0 $X=778690 $Y=557090
X4093 44 73 93 27763 27043 27671 ICV_107 $T=822800 640045 1 0 $X=822370 $Y=635490
X4094 44 73 93 28200 28136 28106 ICV_107 $T=842400 655725 1 0 $X=841970 $Y=651170
X4095 44 73 93 28725 28244 28680 ICV_107 $T=863680 655725 1 0 $X=863250 $Y=651170
X4096 44 73 134 29347 29280 29249 ICV_107 $T=881040 608685 0 0 $X=880610 $Y=608295
X4097 44 73 85 29280 28572 29306 ICV_107 $T=883280 616525 0 0 $X=882850 $Y=616135
X4098 44 73 93 29466 29002 29373 ICV_107 $T=886080 679245 1 0 $X=885650 $Y=674690
X4099 44 73 134 29824 29678 30142 ICV_107 $T=918560 616525 0 0 $X=918130 $Y=616135
X4100 44 73 211 231 30200 30069 ICV_107 $T=920240 569485 1 0 $X=919810 $Y=564930
X4101 44 73 211 29710 30093 30507 ICV_107 $T=939840 545965 1 0 $X=939410 $Y=541410
X4102 44 73 85 32284 31030 32154 ICV_107 $T=994720 687085 1 0 $X=994290 $Y=682530
X4103 44 73 211 395 376 32437 ICV_107 $T=1034480 498925 0 0 $X=1034050 $Y=498535
X4104 44 73 211 34174 34052 33874 ICV_107 $T=1075360 553805 1 0 $X=1074930 $Y=549250
X4105 44 73 93 35772 36204 36174 ICV_107 $T=1154320 561645 1 0 $X=1153890 $Y=557090
X4106 44 73 79 36058 473 36307 ICV_107 $T=1159920 718445 0 0 $X=1159490 $Y=718055
X4107 44 73 79 34368 476 36664 ICV_107 $T=1177840 710605 0 0 $X=1177410 $Y=710215
X4108 44 73 79 31802 477 36675 ICV_107 $T=1178400 694925 0 0 $X=1177970 $Y=694535
X4109 44 73 79 36540 37242 37209 ICV_107 $T=1196320 663565 1 0 $X=1195890 $Y=659010
X4110 44 73 37944 78 80 38007 ICV_107 $T=1232160 553805 0 0 $X=1231730 $Y=553415
X4189 44 73 25914 25993 578 102 ICV_80 $T=753360 491085 0 0 $X=752930 $Y=490695
X4190 44 73 25991 25967 578 102 ICV_80 $T=753360 506765 0 0 $X=752930 $Y=506375
X4191 44 73 26065 25951 578 102 ICV_80 $T=753360 514605 0 0 $X=752930 $Y=514215
X4192 44 73 26084 26281 578 26479 ICV_80 $T=753360 530285 0 0 $X=752930 $Y=529895
X4193 44 73 26284 26255 578 26479 ICV_80 $T=753360 577325 1 0 $X=752930 $Y=572770
X4194 44 73 26216 26361 578 26479 ICV_80 $T=753360 577325 0 0 $X=752930 $Y=576935
X4195 44 73 26066 25952 578 26479 ICV_80 $T=753360 585165 1 0 $X=752930 $Y=580610
X4196 44 73 26173 26146 578 27181 ICV_80 $T=753360 687085 1 0 $X=752930 $Y=682530
X4197 44 73 26326 26515 578 27181 ICV_80 $T=758960 694925 0 0 $X=758530 $Y=694535
X4198 44 73 26698 26624 578 27616 ICV_80 $T=771280 608685 1 0 $X=770850 $Y=604130
X4199 44 73 28266 28189 578 129 ICV_80 $T=833440 506765 0 0 $X=833010 $Y=506375
X4200 44 73 28783 28645 578 28697 ICV_80 $T=860880 553805 0 0 $X=860450 $Y=553415
X4201 44 73 29280 29306 578 28697 ICV_80 $T=872640 632205 1 0 $X=872210 $Y=627650
X4202 44 73 31858 31728 578 33621 ICV_80 $T=975680 600845 0 0 $X=975250 $Y=600455
X4203 44 73 31839 31910 578 307 ICV_80 $T=986320 694925 0 0 $X=985890 $Y=694535
X4204 44 73 347 32416 578 307 ICV_80 $T=989120 718445 1 0 $X=988690 $Y=713890
X4205 44 73 33105 32809 578 358 ICV_80 $T=1019920 687085 1 0 $X=1019490 $Y=682530
X4206 44 73 35206 35124 578 448 ICV_80 $T=1103920 702765 0 0 $X=1103490 $Y=702375
X4207 44 73 35275 35309 578 448 ICV_80 $T=1103920 718445 1 0 $X=1103490 $Y=713890
X4208 44 73 35294 35293 578 35821 ICV_80 $T=1106720 647885 1 0 $X=1106290 $Y=643330
X4209 44 73 35912 35935 578 35561 ICV_80 $T=1141440 647885 1 0 $X=1141010 $Y=643330
X4210 44 73 37257 37224 578 37291 ICV_80 $T=1198000 561645 1 0 $X=1197570 $Y=557090
X4211 44 73 37299 37276 578 37413 ICV_80 $T=1198000 679245 0 0 $X=1197570 $Y=678855
X4212 44 73 35762 37602 578 37291 ICV_80 $T=1199120 585165 1 0 $X=1198690 $Y=580610
X4213 44 73 37603 37417 578 37413 ICV_80 $T=1199120 655725 1 0 $X=1198690 $Y=651170
X4214 44 73 37821 37688 578 37413 ICV_80 $T=1211440 663565 0 0 $X=1211010 $Y=663175
X4215 44 73 37884 37881 578 589 ICV_80 $T=1218720 671405 0 0 $X=1218290 $Y=671015
X4216 44 73 80 25914 26010 ICV_103 $T=755040 498925 0 0 $X=754610 $Y=498535
X4217 44 73 89 26284 26314 ICV_103 $T=764000 616525 0 0 $X=763570 $Y=616135
X4218 44 73 89 26973 26974 ICV_103 $T=797600 616525 1 0 $X=797170 $Y=611970
X4219 44 73 27636 27674 27637 ICV_103 $T=822800 702765 0 0 $X=822370 $Y=702375
X4220 44 73 80 29309 29173 ICV_103 $T=883280 616525 1 0 $X=882850 $Y=611970
X4221 44 73 29736 96 29806 ICV_103 $T=904000 726285 1 0 $X=903570 $Y=721730
X4222 44 73 216 232 30080 ICV_103 $T=916320 498925 1 0 $X=915890 $Y=494370
X4223 44 73 226 30097 30078 ICV_103 $T=916320 514605 0 0 $X=915890 $Y=514215
X4224 44 73 31244 31820 31910 ICV_103 $T=987440 687085 1 0 $X=987010 $Y=682530
X4225 44 73 33102 33173 33082 ICV_103 $T=1030560 655725 0 0 $X=1030130 $Y=655335
X4226 44 73 33337 33383 32618 ICV_103 $T=1039520 514605 1 0 $X=1039090 $Y=510050
X4227 44 73 33360 33386 33404 ICV_103 $T=1042320 640045 1 0 $X=1041890 $Y=635490
X4228 44 73 33405 33274 33336 ICV_103 $T=1042880 655725 1 0 $X=1042450 $Y=651170
X4229 44 73 33219 33328 33721 ICV_103 $T=1058000 671405 1 0 $X=1057570 $Y=666850
X4230 44 73 165 33671 33822 ICV_103 $T=1067520 530285 1 0 $X=1067090 $Y=525730
X4231 44 73 239 34174 34218 ICV_103 $T=1081520 538125 1 0 $X=1081090 $Y=533570
X4232 44 73 239 33995 34230 ICV_103 $T=1082080 530285 1 0 $X=1081650 $Y=525730
X4233 44 73 82 36540 36934 ICV_103 $T=1189040 640045 1 0 $X=1188610 $Y=635490
X4234 44 73 36902 36962 36951 ICV_103 $T=1189600 538125 0 0 $X=1189170 $Y=537735
X4235 44 73 78 36830 37241 ICV_103 $T=1198560 593005 1 0 $X=1198130 $Y=588450
X4236 44 73 77 37675 37579 ICV_103 $T=1215920 710605 1 0 $X=1215490 $Y=706050
X4237 44 73 83 37465 494 ICV_103 $T=1219280 702765 1 0 $X=1218850 $Y=698210
X4238 44 73 38505 36564 38564 ICV_103 $T=1252880 624365 1 0 $X=1252450 $Y=619810
X4239 44 73 38608 38462 38546 ICV_103 $T=1255680 640045 0 0 $X=1255250 $Y=639655
X4240 44 73 82 26206 26445 ICV_71 $T=769040 647885 1 0 $X=768610 $Y=643330
X4241 44 73 28455 126 28568 ICV_71 $T=859760 687085 1 0 $X=859330 $Y=682530
X4242 44 73 158 28783 29390 ICV_71 $T=886080 522445 0 0 $X=885650 $Y=522055
X4243 44 73 165 28317 29454 ICV_71 $T=888880 498925 0 0 $X=888450 $Y=498535
X4244 44 73 184 29632 29563 ICV_71 $T=896720 561645 1 0 $X=896290 $Y=557090
X4245 44 73 199 29777 29834 ICV_71 $T=904560 553805 0 0 $X=904130 $Y=553415
X4246 44 73 165 30126 198 ICV_71 $T=923040 506765 1 0 $X=922610 $Y=502210
X4247 44 73 80 30234 30709 ICV_71 $T=944320 663565 0 0 $X=943890 $Y=663175
X4248 44 73 217 282 30768 ICV_71 $T=947120 545965 1 0 $X=946690 $Y=541410
X4249 44 73 30838 30709 30819 ICV_71 $T=949360 671405 1 0 $X=948930 $Y=666850
X4250 44 73 31147 29293 31132 ICV_71 $T=961680 585165 1 0 $X=961250 $Y=580610
X4251 44 73 32437 183 32408 ICV_71 $T=1002560 538125 1 0 $X=1002130 $Y=533570
X4252 44 73 33030 215 32985 ICV_71 $T=1022720 585165 0 0 $X=1022290 $Y=584775
X4253 44 73 158 31858 33104 ICV_71 $T=1026080 553805 0 0 $X=1025650 $Y=553415
X4254 44 73 216 380 33156 ICV_71 $T=1028320 506765 0 0 $X=1027890 $Y=506375
X4255 44 73 33679 33636 417 ICV_71 $T=1055200 491085 1 0 $X=1054770 $Y=486530
X4256 44 73 33567 33173 33768 ICV_71 $T=1059680 655725 0 0 $X=1059250 $Y=655335
X4257 44 73 33763 33674 33769 ICV_71 $T=1059680 679245 0 0 $X=1059250 $Y=678855
X4258 44 73 96 30500 37348 ICV_71 $T=1201360 647885 1 0 $X=1200930 $Y=643330
X4259 44 73 83 36959 37480 ICV_71 $T=1206400 702765 1 0 $X=1205970 $Y=698210
X4260 44 73 83 37259 37689 ICV_71 $T=1215920 702765 0 0 $X=1215490 $Y=702375
X4261 44 73 39117 39215 38782 ICV_71 $T=1274160 663565 1 0 $X=1273730 $Y=659010
X4262 44 73 26838 26815 578 27181 ICV_73 $T=779120 687085 1 0 $X=778690 $Y=682530
X4263 44 73 120 27388 578 27324 ICV_73 $T=802080 655725 1 0 $X=801650 $Y=651170
X4264 44 73 27443 27421 578 27616 ICV_73 $T=802640 600845 1 0 $X=802210 $Y=596290
X4265 44 73 27488 27466 578 27324 ICV_73 $T=804880 616525 1 0 $X=804450 $Y=611970
X4266 44 73 112 27837 578 29140 ICV_73 $T=818880 663565 1 0 $X=818450 $Y=659010
X4267 44 73 28750 28609 578 28697 ICV_73 $T=863120 538125 0 0 $X=862690 $Y=537735
X4268 44 73 29309 29149 578 28697 ICV_73 $T=870400 624365 0 0 $X=869970 $Y=623975
X4269 44 73 30146 30145 578 29114 ICV_73 $T=904000 671405 1 0 $X=903570 $Y=666850
X4270 44 73 33954 34489 578 35821 ICV_73 $T=1085440 624365 1 0 $X=1085010 $Y=619810
X4271 44 73 34410 34507 578 35821 ICV_73 $T=1085440 632205 0 0 $X=1085010 $Y=631815
X4272 44 73 34305 34491 578 35821 ICV_73 $T=1085440 655725 1 0 $X=1085010 $Y=651170
X4273 44 73 34408 34334 578 448 ICV_73 $T=1085440 679245 0 0 $X=1085010 $Y=678855
X4274 44 73 32792 34844 578 35821 ICV_73 $T=1087120 600845 0 0 $X=1086690 $Y=600455
X4275 44 73 35330 35360 578 448 ICV_73 $T=1105040 687085 1 0 $X=1104610 $Y=682530
X4276 44 73 35523 35503 578 35561 ICV_73 $T=1111200 663565 0 0 $X=1110770 $Y=663175
X4277 44 73 471 36235 578 468 ICV_73 $T=1145360 718445 1 0 $X=1144930 $Y=713890
X4278 44 73 37347 37244 578 485 ICV_73 $T=1196880 522445 1 0 $X=1196450 $Y=517890
X4279 44 73 37256 37223 578 36706 ICV_73 $T=1196880 538125 0 0 $X=1196450 $Y=537735
X4280 44 73 37085 37284 578 37291 ICV_73 $T=1196880 608685 1 0 $X=1196450 $Y=604130
X4281 44 78 26807 26768 73 78 26867 26378 ICV_108 $T=788640 498925 1 0 $X=788210 $Y=494370
X4282 44 158 175 29571 73 165 175 29643 ICV_108 $T=895040 498925 1 0 $X=894610 $Y=494370
X4283 44 29456 29646 29632 73 158 29347 29646 ICV_108 $T=897840 530285 1 0 $X=897410 $Y=525730
X4284 44 29334 29619 29710 73 165 29788 29619 ICV_108 $T=900080 514605 1 0 $X=899650 $Y=510050
X4285 44 29601 206 29833 73 174 209 29891 ICV_108 $T=905680 545965 0 0 $X=905250 $Y=545575
X4286 44 165 29928 29845 73 217 203 29997 ICV_108 $T=909040 514605 1 0 $X=908610 $Y=510050
X4287 44 29845 225 30051 73 158 29928 30034 ICV_108 $T=914640 514605 1 0 $X=914210 $Y=510050
X4288 44 29375 30167 230 73 238 29999 29878 ICV_108 $T=919680 498925 0 0 $X=919250 $Y=498535
X4289 44 158 29858 225 73 30034 30231 30097 ICV_108 $T=920240 514605 1 0 $X=919810 $Y=510050
X4290 44 193 30038 30334 73 158 30414 257 ICV_108 $T=928640 491085 0 0 $X=928210 $Y=490695
X4291 44 158 30181 253 73 158 30415 29856 ICV_108 $T=928640 506765 0 0 $X=928210 $Y=506375
X4292 44 196 30220 30344 73 29857 259 30296 ICV_108 $T=929200 538125 1 0 $X=928770 $Y=533570
X4293 44 29999 30411 30052 73 165 262 30038 ICV_108 $T=931440 498925 0 0 $X=931010 $Y=498535
X4294 44 29618 30038 261 73 158 262 30411 ICV_108 $T=934240 491085 0 0 $X=933810 $Y=490695
X4295 44 185 261 30442 73 243 30569 30566 ICV_108 $T=935920 553805 1 0 $X=935490 $Y=549250
X4296 44 243 30051 30468 73 158 30607 30528 ICV_108 $T=937600 530285 1 0 $X=937170 $Y=525730
X4297 44 277 30605 30648 73 263 30594 30677 ICV_108 $T=946000 506765 1 0 $X=945570 $Y=502210
X4298 44 30741 30767 30673 73 239 30837 30767 ICV_108 $T=947680 530285 1 0 $X=947250 $Y=525730
X4299 44 309 30743 30837 73 302 30051 30983 ICV_108 $T=954960 530285 1 0 $X=954530 $Y=525730
X4300 44 165 31194 271 73 158 31326 30476 ICV_108 $T=966720 530285 0 0 $X=966290 $Y=529895
X4301 44 216 33015 32769 73 196 33092 33045 ICV_108 $T=1023280 538125 1 0 $X=1022850 $Y=533570
X4302 44 243 33077 33005 73 165 27986 33130 ICV_108 $T=1025520 522445 0 0 $X=1025090 $Y=522055
X4303 44 158 32792 33254 73 158 33061 33323 ICV_108 $T=1034480 561645 0 0 $X=1034050 $Y=561255
X4304 44 31148 33315 33214 73 33226 272 33358 ICV_108 $T=1035600 585165 0 0 $X=1035170 $Y=584775
X4305 44 158 33242 33400 73 33682 33822 429 ICV_108 $T=1060240 530285 1 0 $X=1059810 $Y=525730
X4306 44 33475 33728 32454 73 33475 33822 421 ICV_108 $T=1061360 530285 0 0 $X=1060930 $Y=529895
X4307 44 33818 436 394 73 33830 33899 377 ICV_108 $T=1069200 491085 1 0 $X=1068770 $Y=486530
X4308 44 82 30842 36271 73 89 36341 36331 ICV_108 $T=1158800 624365 0 0 $X=1158370 $Y=623975
X4309 44 78 37854 37900 73 80 37854 37819 ICV_108 $T=1227680 514605 1 0 $X=1227250 $Y=510050
X4310 44 73 27422 27455 27441 ICV_93 $T=812160 702765 0 0 $X=811730 $Y=702375
X4311 44 73 27604 122 27530 ICV_93 $T=820000 726285 0 0 $X=819570 $Y=725895
X4312 44 73 27931 28005 26960 ICV_93 $T=836240 679245 0 0 $X=835810 $Y=678855
X4313 44 73 28133 27820 113 ICV_93 $T=853600 679245 0 0 $X=853170 $Y=678855
X4314 44 73 29722 29803 29805 ICV_93 $T=902880 577325 0 0 $X=902450 $Y=576935
X4315 44 73 29760 29955 29941 ICV_93 $T=908480 585165 0 0 $X=908050 $Y=584775
X4316 44 73 30734 30856 30800 ICV_93 $T=949360 561645 1 0 $X=948930 $Y=557090
X4317 44 73 169 32384 259 ICV_93 $T=1000320 585165 0 0 $X=999890 $Y=584775
X4318 44 73 32582 32583 32562 ICV_93 $T=1008160 530285 0 0 $X=1007730 $Y=529895
X4319 44 73 31193 32726 32594 ICV_93 $T=1012080 538125 0 0 $X=1011650 $Y=537735
X4320 44 73 32612 371 32846 ICV_93 $T=1017120 522445 1 0 $X=1016690 $Y=517890
X4321 44 73 33013 33049 32982 ICV_93 $T=1022720 671405 1 0 $X=1022290 $Y=666850
X4322 44 73 34175 33839 34289 ICV_93 $T=1082080 561645 0 0 $X=1081650 $Y=561255
X4323 44 73 34173 34302 34251 ICV_93 $T=1082640 530285 0 0 $X=1082210 $Y=529895
X4324 44 73 36564 38467 38449 ICV_93 $T=1246160 632205 1 0 $X=1245730 $Y=627650
X4325 44 73 38450 38486 38467 ICV_93 $T=1246720 632205 0 0 $X=1246290 $Y=631815
X4326 44 73 34118 38529 38505 ICV_93 $T=1248400 663565 0 0 $X=1247970 $Y=663175
X4327 44 73 32913 34347 38644 ICV_93 $T=1257360 663565 1 0 $X=1256930 $Y=659010
X4328 44 73 39276 39317 39214 ICV_93 $T=1273040 608685 0 0 $X=1272610 $Y=608295
X4329 44 73 38572 39482 39317 ICV_93 $T=1277520 608685 0 0 $X=1277090 $Y=608295
X4330 44 73 39650 38763 39215 ICV_93 $T=1287600 640045 1 0 $X=1287170 $Y=635490
X4331 44 27569 27511 27545 73 27509 113 27398 ICV_102 $T=818880 718445 0 180 $X=815650 $Y=713890
X4332 44 29772 29643 189 73 29619 29571 188 ICV_102 $T=903440 498925 0 180 $X=900210 $Y=494370
X4333 44 30167 162 240 73 29481 30034 234 ICV_102 $T=920240 491085 1 180 $X=917010 $Y=490695
X4334 44 217 30313 30529 73 217 209 30435 ICV_102 $T=937600 538125 0 180 $X=934370 $Y=533570
X4335 44 185 266 30776 73 286 268 30715 ICV_102 $T=948800 506765 1 180 $X=945570 $Y=506375
X4336 44 31809 31220 31908 73 31414 31746 31775 ICV_102 $T=989120 663565 0 180 $X=985890 $Y=659010
X4337 44 33213 33169 33092 73 158 28032 33171 ICV_102 $T=1032800 553805 1 180 $X=1029570 $Y=553415
X4338 44 33300 33219 33032 73 33241 33102 33179 ICV_102 $T=1035040 640045 1 180 $X=1031810 $Y=639655
X4339 44 33301 33228 33292 73 80 32630 33228 ICV_102 $T=1035040 694925 0 180 $X=1031810 $Y=690370
X4340 44 165 33315 33368 73 165 32499 33485 ICV_102 $T=1048480 530285 0 180 $X=1045250 $Y=525730
X4341 44 412 31091 33576 73 33423 33491 33512 ICV_102 $T=1052960 498925 0 180 $X=1049730 $Y=494370
X4342 44 33699 331 33720 73 33682 33541 413 ICV_102 $T=1058000 545965 1 180 $X=1054770 $Y=545575
X4343 44 165 29346 430 73 426 33400 395 ICV_102 $T=1063600 498925 1 180 $X=1060370 $Y=498535
X4344 44 33978 33911 33956 73 80 33465 33911 ICV_102 $T=1071440 694925 1 180 $X=1068210 $Y=694535
X4345 44 216 33692 34447 73 243 33995 34379 ICV_102 $T=1089920 530285 1 180 $X=1086690 $Y=529895
X4346 44 89 35670 35888 73 35838 96 35801 ICV_102 $T=1143120 694925 1 180 $X=1139890 $Y=694535
X4347 44 78 35751 36663 73 78 36446 36600 ICV_102 $T=1178400 585165 0 180 $X=1175170 $Y=580610
X4348 44 80 36415 36962 73 78 36415 37111 ICV_102 $T=1196880 545965 0 180 $X=1193650 $Y=541410
X4349 44 38694 38326 38823 73 38701 38448 38719 ICV_102 $T=1260720 538125 1 180 $X=1257490 $Y=537735
X4350 44 38823 38820 38835 73 38391 38309 38684 ICV_102 $T=1261280 530285 0 180 $X=1258050 $Y=525730
X4351 44 73 127 27604 124 27711 ICV_98 $T=824480 726285 0 0 $X=824050 $Y=725895
X4352 44 73 28245 28219 141 117 ICV_98 $T=845760 702765 0 0 $X=845330 $Y=702375
X4353 44 73 30162 30136 30047 30105 ICV_98 $T=916880 561645 0 0 $X=916450 $Y=561255
X4354 44 73 31220 31028 31233 31166 ICV_98 $T=964480 655725 1 0 $X=964050 $Y=651170
X4355 44 73 33187 33147 33049 33116 ICV_98 $T=1027200 671405 1 0 $X=1026770 $Y=666850
X4356 44 73 33426 33396 33013 33375 ICV_98 $T=1038960 663565 0 0 $X=1038530 $Y=663175
X4357 44 73 33386 33201 33427 33476 ICV_98 $T=1045120 655725 0 0 $X=1044690 $Y=655335
X4358 44 73 33918 33898 33900 33806 ICV_98 $T=1065840 561645 0 0 $X=1065410 $Y=561255
X4359 44 73 34335 34316 34303 34158 ICV_98 $T=1082640 561645 1 0 $X=1082210 $Y=557090
X4360 44 73 34450 449 34407 34308 ICV_98 $T=1087120 506765 1 0 $X=1086690 $Y=502210
X4361 44 73 34365 34447 34380 34379 ICV_98 $T=1088800 538125 1 0 $X=1088370 $Y=533570
X4362 44 73 38325 38411 38311 503 ICV_98 $T=1244480 569485 0 0 $X=1244050 $Y=569095
X4363 44 73 78 38811 38854 38702 ICV_98 $T=1259600 553805 1 0 $X=1259170 $Y=549250
X4364 44 73 39009 38966 38485 38912 ICV_98 $T=1263520 624365 1 0 $X=1263090 $Y=619810
X4365 44 73 39010 34118 38899 32913 ICV_98 $T=1263520 655725 0 0 $X=1263090 $Y=655335
X4366 44 73 39423 39063 39190 34480 ICV_98 $T=1274720 624365 1 0 $X=1274290 $Y=619810
X4367 44 73 80 26903 28107 ICV_82 $T=849120 577325 0 180 $X=845890 $Y=572770
X4368 44 73 28434 28303 28421 ICV_82 $T=859760 608685 0 180 $X=856530 $Y=604130
X4369 44 73 28568 28543 28540 ICV_82 $T=863680 687085 1 180 $X=860450 $Y=686695
X4370 44 73 29953 206 29982 ICV_82 $T=914640 530285 0 180 $X=911410 $Y=525730
X4371 44 73 30163 215 30164 ICV_82 $T=923040 585165 1 180 $X=919810 $Y=584775
X4372 44 73 80 30314 30446 ICV_82 $T=940400 671405 0 180 $X=937170 $Y=666850
X4373 44 73 30528 29454 293 ICV_82 $T=949360 491085 1 180 $X=946130 $Y=490695
X4374 44 73 31162 31254 31285 ICV_82 $T=971200 506765 0 180 $X=967970 $Y=502210
X4375 44 73 31027 31239 31339 ICV_82 $T=972880 640045 0 180 $X=969650 $Y=635490
X4376 44 73 32518 325 32452 ICV_82 $T=1009280 561645 0 180 $X=1006050 $Y=557090
X4377 44 73 33393 33453 379 ICV_82 $T=1047360 545965 0 180 $X=1044130 $Y=541410
X4378 44 73 33807 33763 33832 ICV_82 $T=1066960 640045 1 180 $X=1063730 $Y=639655
X4379 44 73 80 34460 35311 ICV_82 $T=1121840 616525 1 180 $X=1118610 $Y=616135
X4380 44 73 89 35523 35747 ICV_82 $T=1140320 671405 0 180 $X=1137090 $Y=666850
X4381 44 73 89 36598 36866 ICV_82 $T=1190720 616525 1 180 $X=1187490 $Y=616135
X4382 44 73 80 36333 37708 ICV_82 $T=1221520 514605 1 180 $X=1218290 $Y=514215
X4383 44 73 78 37882 37773 ICV_82 $T=1230480 585165 1 180 $X=1227250 $Y=584775
X4384 44 73 93 27762 27902 28339 ICV_110 $T=848000 632205 0 0 $X=847570 $Y=631815
X4385 44 73 85 29821 30146 30165 ICV_110 $T=914640 679245 0 0 $X=914210 $Y=678855
X4386 44 73 93 32284 347 32416 ICV_110 $T=998080 710605 1 0 $X=997650 $Y=706050
X4387 44 73 205 33779 33591 33953 ICV_110 $T=1066960 545965 0 0 $X=1066530 $Y=545575
X4388 44 73 211 32695 32534 34082 ICV_110 $T=1070880 498925 0 0 $X=1070450 $Y=498535
X4389 44 73 85 33577 34408 34427 ICV_110 $T=1083760 671405 0 0 $X=1083330 $Y=671015
X4390 44 73 85 33954 34460 34489 ICV_110 $T=1086000 624365 0 0 $X=1085570 $Y=623975
X4391 44 73 134 34684 35786 35811 ICV_110 $T=1134160 545965 0 0 $X=1133730 $Y=545575
X4392 44 73 134 30607 35810 35837 ICV_110 $T=1135280 522445 0 0 $X=1134850 $Y=522055
X4393 44 73 93 35613 35912 35935 ICV_110 $T=1139760 640045 0 0 $X=1139330 $Y=639655
X4394 44 73 85 35810 36333 36406 ICV_110 $T=1159920 530285 0 0 $X=1159490 $Y=529895
X4395 44 73 85 35601 35751 36425 ICV_110 $T=1161040 600845 0 0 $X=1160610 $Y=600455
X4396 44 73 93 35826 36173 36486 ICV_110 $T=1164400 538125 1 0 $X=1163970 $Y=533570
X4397 44 73 85 35430 36758 37025 ICV_110 $T=1186240 577325 0 0 $X=1185810 $Y=576935
X4398 44 73 85 35836 37796 37831 ICV_110 $T=1219280 506765 1 0 $X=1218850 $Y=502210
X4399 44 73 93 489 37820 37855 ICV_110 $T=1220400 593005 0 0 $X=1219970 $Y=592615
X4400 44 167 ANTENNA $T=893920 694925 1 0 $X=893490 $Y=690370
X4401 44 167 ANTENNA $T=896720 694925 0 0 $X=896290 $Y=694535
X4402 44 167 ANTENNA $T=897840 694925 0 0 $X=897410 $Y=694535
X4403 44 197 ANTENNA $T=906800 710605 0 0 $X=906370 $Y=710215
X4404 44 197 ANTENNA $T=907920 710605 0 0 $X=907490 $Y=710215
X4405 44 252 ANTENNA $T=933120 569485 1 0 $X=932690 $Y=564930
X4406 44 252 ANTENNA $T=934240 569485 1 0 $X=933810 $Y=564930
X4407 44 338 ANTENNA $T=975680 702765 0 0 $X=975250 $Y=702375
X4408 44 331 ANTENNA $T=988560 491085 0 0 $X=988130 $Y=490695
X4409 44 331 ANTENNA $T=992480 491085 0 0 $X=992050 $Y=490695
X4410 44 454 ANTENNA $T=1094960 679245 1 0 $X=1094530 $Y=674690
X4411 44 454 ANTENNA $T=1098320 671405 0 0 $X=1097890 $Y=671015
X4412 165 44 73 158 INVX4 $T=1100560 514605 1 180 $X=1097890 $Y=514215
X4413 467 44 73 89 INVX4 $T=1150400 600845 0 0 $X=1149970 $Y=600455
.ENDS
***************************************
.SUBCKT ICV_84 1 2 3 4 5 6
** N=8 EP=6 IP=13 FDC=40
X1 4 6 2 5 1 2 3 DFFQSRX1 $T=25760 0 1 180 $X=130 $Y=-390
.ENDS
***************************************
.SUBCKT ICV_83 1 2 3 4 5
** N=7 EP=5 IP=11 FDC=4
X1 3 4 1 2 5 NAND2X1 $T=0 0 0 0 $X=-430 $Y=-390
.ENDS
***************************************
.SUBCKT ICV_59
** N=4 EP=0 IP=8 FDC=0
.ENDS
***************************************
.SUBCKT ICV_85 18 44 45 46 47 48 49 50 51 52 53 54 55 56 57 58 59 60 61 62
+ 63 64 65 66 67 68 69 70 71 72 73 74 75 76 77 78 79 80 81 82
+ 83 84 85 86 87 88 89 90 91 92 93 94 95 96 97 98 99 100 101 102
+ 103 104 105 106 107 108 109 110 111 112 113 114 115 116 117 118 119 120 121 122
+ 123 124 125 126 127 128 129 130 131 132 133 134 135 136 137 138 139 140 141 142
+ 143 144 145 146 147 148 149 150 151 152 153 154 155 156 157 158 159 160 161 162
+ 163 164 165 166 167 168 169 170 171 172 173 174 175 176 177 178 179 180 181 182
+ 183 184 185 186 187 188 189 190 191 192 193 194 195 196 197 198 199 200 201 202
+ 203 204 205 206 207 274 277 283 284 287 295 297 302 303 305 306 309 312
** N=202401 EP=178 IP=13867 FDC=12383
X613 24866 53 44 180 18 44 24867 DFFQSRX1 $T=723120 741965 0 0 $X=722690 $Y=741575
X614 24986 53 44 180 18 44 24255 DFFQSRX1 $T=748320 757645 0 180 $X=722690 $Y=753090
X615 24963 26172 44 180 18 44 24256 DFFQSRX1 $T=748320 789005 1 180 $X=722690 $Y=788615
X616 25560 26172 44 180 18 44 24257 DFFQSRX1 $T=748320 804685 0 180 $X=722690 $Y=800130
X617 25067 26172 44 180 18 44 24436 DFFQSRX1 $T=752800 773325 1 180 $X=727170 $Y=772935
X618 25331 26172 44 180 18 44 24783 DFFQSRX1 $T=761760 781165 0 180 $X=736130 $Y=776610
X619 25432 53 44 180 18 44 25642 DFFQSRX1 $T=750000 765485 1 0 $X=749570 $Y=760930
X620 274 53 44 180 18 44 25226 DFFQSRX1 $T=753920 734125 0 0 $X=753490 $Y=733735
X621 25840 53 44 180 18 44 25370 DFFQSRX1 $T=753920 757645 1 0 $X=753490 $Y=753090
X622 25896 53 44 180 18 44 25936 DFFQSRX1 $T=757280 741965 1 0 $X=756850 $Y=737410
X623 26217 26172 44 180 18 44 26254 DFFQSRX1 $T=762880 773325 1 0 $X=762450 $Y=768770
X624 26111 28142 44 180 18 44 26022 DFFQSRX1 $T=764000 828205 1 0 $X=763570 $Y=823650
X625 26199 26172 44 180 18 44 26333 DFFQSRX1 $T=765680 812525 1 0 $X=765250 $Y=807970
X626 26469 26172 44 180 18 44 25915 DFFQSRX1 $T=793120 804685 1 180 $X=767490 $Y=804295
X627 26251 28142 44 180 18 44 26309 DFFQSRX1 $T=767920 843885 0 0 $X=767490 $Y=843495
X628 277 101 44 180 18 44 64 DFFQSRX1 $T=781920 734125 1 0 $X=781490 $Y=729570
X629 26519 28142 44 180 18 44 26776 DFFQSRX1 $T=782480 851725 0 0 $X=782050 $Y=851335
X630 26917 28177 44 180 18 44 26468 DFFQSRX1 $T=810480 773325 1 180 $X=784850 $Y=772935
X631 26811 26172 44 180 18 44 26965 DFFQSRX1 $T=786960 789005 0 0 $X=786530 $Y=788615
X632 26978 28177 44 180 18 44 26569 DFFQSRX1 $T=813840 781165 0 180 $X=788210 $Y=776610
X633 27071 28177 44 180 18 44 25969 DFFQSRX1 $T=813840 812525 1 180 $X=788210 $Y=812135
X634 26787 28142 44 180 18 44 27003 DFFQSRX1 $T=789200 828205 1 0 $X=788770 $Y=823650
X635 27127 28177 44 180 18 44 26808 DFFQSRX1 $T=821120 796845 1 180 $X=795490 $Y=796455
X636 27620 101 44 180 18 44 27112 DFFQSRX1 $T=831760 749805 0 180 $X=806130 $Y=745250
X637 27721 28177 44 180 18 44 27250 DFFQSRX1 $T=835120 765485 0 180 $X=809490 $Y=760930
X638 27720 28177 44 180 18 44 27271 DFFQSRX1 $T=835680 757645 1 180 $X=810050 $Y=757255
X639 27650 28142 44 180 18 44 27704 DFFQSRX1 $T=811040 828205 0 0 $X=810610 $Y=827815
X640 27827 28142 44 180 18 44 27326 DFFQSRX1 $T=837360 867405 1 180 $X=811730 $Y=867015
X641 27684 28177 44 180 18 44 27361 DFFQSRX1 $T=838480 812525 0 180 $X=812850 $Y=807970
X642 27785 28142 44 180 18 44 27362 DFFQSRX1 $T=838480 875245 1 180 $X=812850 $Y=874855
X643 28335 29573 44 180 18 44 27701 DFFQSRX1 $T=853040 812525 1 180 $X=827410 $Y=812135
X644 28316 28177 44 180 18 44 27601 DFFQSRX1 $T=854720 781165 1 180 $X=829090 $Y=780775
X645 28191 29573 44 180 18 44 27902 DFFQSRX1 $T=855280 828205 0 180 $X=829650 $Y=823650
X646 28270 28142 44 180 18 44 28303 DFFQSRX1 $T=830640 836045 0 0 $X=830210 $Y=835655
X647 28419 101 44 180 18 44 28004 DFFQSRX1 $T=858640 757645 0 180 $X=833010 $Y=753090
X648 28579 101 44 180 18 44 28441 DFFQSRX1 $T=834000 749805 0 0 $X=833570 $Y=749415
X649 28185 28177 44 180 18 44 28219 DFFQSRX1 $T=834000 789005 1 0 $X=833570 $Y=784450
X650 28442 28177 44 180 18 44 28477 DFFQSRX1 $T=834000 804685 1 0 $X=833570 $Y=800130
X651 28847 29573 44 180 18 44 28020 DFFQSRX1 $T=859200 836045 0 180 $X=833570 $Y=831490
X652 28848 30498 44 180 18 44 27235 DFFQSRX1 $T=864800 875245 1 180 $X=839170 $Y=874855
X653 28933 29573 44 180 18 44 28300 DFFQSRX1 $T=874880 773325 1 180 $X=849250 $Y=772935
X654 29208 29573 44 180 18 44 29171 DFFQSRX1 $T=864800 796845 1 0 $X=864370 $Y=792290
X655 29259 29573 44 180 18 44 29294 DFFQSRX1 $T=864800 804685 0 0 $X=864370 $Y=804295
X656 29224 29573 44 180 18 44 28664 DFFQSRX1 $T=864800 812525 0 0 $X=864370 $Y=812135
X657 28956 29573 44 180 18 44 29135 DFFQSRX1 $T=864800 836045 0 0 $X=864370 $Y=835655
X658 28974 30498 44 180 18 44 29445 DFFQSRX1 $T=864800 875245 0 0 $X=864370 $Y=874855
X659 29313 101 44 180 18 44 91 DFFQSRX1 $T=873200 749805 0 0 $X=872770 $Y=749415
X660 29673 30498 44 180 18 44 29332 DFFQSRX1 $T=899520 851725 0 180 $X=873890 $Y=847170
X661 283 101 44 180 18 44 103 DFFQSRX1 $T=875440 741965 1 0 $X=875010 $Y=737410
X662 284 101 44 180 18 44 104 DFFQSRX1 $T=876000 734125 1 0 $X=875570 $Y=729570
X663 29943 112 44 180 18 44 98 DFFQSRX1 $T=901760 741965 1 180 $X=876130 $Y=741575
X664 30113 112 44 180 18 44 100 DFFQSRX1 $T=902880 757645 1 180 $X=877250 $Y=757255
X665 29653 29573 44 180 18 44 30153 DFFQSRX1 $T=877680 773325 0 0 $X=877250 $Y=772935
X666 29927 29573 44 180 18 44 29491 DFFQSRX1 $T=905120 812525 0 180 $X=879490 $Y=807970
X667 29928 30498 44 180 18 44 29334 DFFQSRX1 $T=905120 828205 0 180 $X=879490 $Y=823650
X668 30029 29573 44 180 18 44 30031 DFFQSRX1 $T=884960 781165 0 0 $X=884530 $Y=780775
X669 30154 30498 44 180 18 44 30241 DFFQSRX1 $T=890000 843885 1 0 $X=889570 $Y=839330
X670 30636 30498 44 180 18 44 30689 DFFQSRX1 $T=906240 851725 1 0 $X=905810 $Y=847170
X671 287 112 44 180 18 44 99 DFFQSRX1 $T=909040 734125 1 0 $X=908610 $Y=729570
X672 30604 112 44 180 18 44 30769 DFFQSRX1 $T=909040 734125 0 0 $X=908610 $Y=733735
X673 30890 112 44 180 18 44 30288 DFFQSRX1 $T=934800 757645 1 180 $X=909170 $Y=757255
X674 30664 112 44 180 18 44 30753 DFFQSRX1 $T=910160 781165 1 0 $X=909730 $Y=776610
X675 30680 30498 44 180 18 44 30707 DFFQSRX1 $T=910720 820365 1 0 $X=910290 $Y=815810
X676 30945 31362 44 180 18 44 29744 DFFQSRX1 $T=935920 883085 0 180 $X=910290 $Y=878530
X677 30651 31362 44 180 18 44 30832 DFFQSRX1 $T=911840 890925 1 0 $X=911410 $Y=886370
X678 30781 30498 44 180 18 44 30929 DFFQSRX1 $T=912960 859565 1 0 $X=912530 $Y=855010
X679 30863 30498 44 180 18 44 30891 DFFQSRX1 $T=915200 828205 0 0 $X=914770 $Y=827815
X680 30843 30498 44 180 18 44 30997 DFFQSRX1 $T=915200 843885 1 0 $X=914770 $Y=839330
X681 31015 112 44 180 18 44 30979 DFFQSRX1 $T=916880 796845 1 0 $X=916450 $Y=792290
X682 31748 31362 44 180 18 44 29929 DFFQSRX1 $T=963360 883085 1 180 $X=937730 $Y=882695
X683 31416 31362 44 180 18 44 31734 DFFQSRX1 $T=942080 843885 0 0 $X=941650 $Y=843495
X684 31686 31362 44 180 18 44 31513 DFFQSRX1 $T=970640 851725 0 180 $X=945010 $Y=847170
X685 31585 31362 44 180 18 44 31514 DFFQSRX1 $T=970640 859565 1 180 $X=945010 $Y=859175
X686 32742 31362 44 180 18 44 31440 DFFQSRX1 $T=970640 875245 0 180 $X=945010 $Y=870690
X687 32994 31362 44 180 18 44 32741 DFFQSRX1 $T=979600 843885 0 0 $X=979170 $Y=843495
X688 33504 33783 44 180 18 44 32969 DFFQSRX1 $T=1017680 851725 1 180 $X=992050 $Y=851335
X689 33361 31362 44 180 18 44 33396 DFFQSRX1 $T=993600 836045 1 0 $X=993170 $Y=831490
X690 33598 34541 44 180 18 44 33147 DFFQSRX1 $T=1022720 773325 1 180 $X=997090 $Y=772935
X691 33599 33783 44 180 18 44 33246 DFFQSRX1 $T=1025520 843885 0 180 $X=999890 $Y=839330
X692 33717 295 44 180 18 44 33752 DFFQSRX1 $T=1005360 741965 0 0 $X=1004930 $Y=741575
X693 34200 33783 44 180 18 44 33152 DFFQSRX1 $T=1037280 883085 0 180 $X=1011650 $Y=878530
X694 34733 297 44 180 18 44 148 DFFQSRX1 $T=1037840 757645 0 180 $X=1012210 $Y=753090
X695 33948 33783 44 180 18 44 33982 DFFQSRX1 $T=1012640 804685 1 0 $X=1012210 $Y=800130
X696 33949 34541 44 180 18 44 33653 DFFQSRX1 $T=1037840 812525 0 180 $X=1012210 $Y=807970
X697 34150 34541 44 180 18 44 34070 DFFQSRX1 $T=1013760 765485 1 0 $X=1013330 $Y=760930
X698 34117 34541 44 180 18 44 33700 DFFQSRX1 $T=1039520 796845 0 180 $X=1013890 $Y=792290
X699 34396 34541 44 180 18 44 33718 DFFQSRX1 $T=1040080 789005 0 180 $X=1014450 $Y=784450
X700 34168 33783 44 180 18 44 34204 DFFQSRX1 $T=1018240 836045 0 0 $X=1017810 $Y=835655
X701 34323 33783 44 180 18 44 34257 DFFQSRX1 $T=1018800 851725 0 0 $X=1018370 $Y=851335
X702 34369 297 44 180 18 44 34372 DFFQSRX1 $T=1027200 734125 0 0 $X=1026770 $Y=733735
X703 34608 297 44 180 18 44 34576 DFFQSRX1 $T=1030000 749805 1 0 $X=1029570 $Y=745250
X704 34734 33783 44 180 18 44 32915 DFFQSRX1 $T=1059120 875245 0 180 $X=1033490 $Y=870690
X705 34354 34541 44 180 18 44 34322 DFFQSRX1 $T=1038960 804685 0 0 $X=1038530 $Y=804295
X706 34678 34541 44 180 18 44 34894 DFFQSRX1 $T=1041200 781165 0 0 $X=1040770 $Y=780775
X707 35008 34541 44 180 18 44 34513 DFFQSRX1 $T=1066400 789005 1 180 $X=1040770 $Y=788615
X708 35125 34541 44 180 18 44 34528 DFFQSRX1 $T=1066960 757645 1 180 $X=1041330 $Y=757255
X709 34829 34541 44 180 18 44 34861 DFFQSRX1 $T=1041760 804685 1 0 $X=1041330 $Y=800130
X710 34910 34541 44 180 18 44 34934 DFFQSRX1 $T=1041760 820365 1 0 $X=1041330 $Y=815810
X711 35195 36041 44 180 18 44 34373 DFFQSRX1 $T=1070880 883085 0 180 $X=1045250 $Y=878530
X712 35106 33783 44 180 18 44 35039 DFFQSRX1 $T=1050720 851725 0 0 $X=1050290 $Y=851335
X713 35680 36041 44 180 18 44 34954 DFFQSRX1 $T=1081520 828205 0 180 $X=1055890 $Y=823650
X714 36068 36041 44 180 18 44 35396 DFFQSRX1 $T=1097760 875245 1 180 $X=1072130 $Y=874855
X715 36069 36041 44 180 18 44 36264 DFFQSRX1 $T=1083200 867405 0 0 $X=1082770 $Y=867015
X716 36051 36041 44 180 18 44 36010 DFFQSRX1 $T=1087120 812525 0 0 $X=1086690 $Y=812135
X717 35963 36041 44 180 18 44 35981 DFFQSRX1 $T=1087120 828205 0 0 $X=1086690 $Y=827815
X718 35818 36041 44 180 18 44 35979 DFFQSRX1 $T=1087120 843885 0 0 $X=1086690 $Y=843495
X719 36585 36041 44 180 18 44 36617 DFFQSRX1 $T=1097200 812525 1 0 $X=1096770 $Y=807970
X720 36650 36041 44 180 18 44 36310 DFFQSRX1 $T=1122960 820365 1 180 $X=1097330 $Y=819975
X721 36831 37384 44 180 18 44 35777 DFFQSRX1 $T=1126880 859565 1 180 $X=1101250 $Y=859175
X722 37433 37802 44 180 18 44 36934 DFFQSRX1 $T=1143680 804685 0 180 $X=1118050 $Y=800130
X723 37374 36041 44 180 18 44 37400 DFFQSRX1 $T=1118480 812525 0 0 $X=1118050 $Y=812135
X724 37486 37384 44 180 18 44 35519 DFFQSRX1 $T=1144800 867405 1 180 $X=1119170 $Y=867015
X725 37399 37384 44 180 18 44 37638 DFFQSRX1 $T=1121280 859565 1 0 $X=1120850 $Y=855010
X726 305 306 44 180 18 44 186 DFFQSRX1 $T=1124640 734125 1 0 $X=1124210 $Y=729570
X727 37895 37802 44 180 18 44 37376 DFFQSRX1 $T=1158240 749805 0 180 $X=1132610 $Y=745250
X728 37777 37802 44 180 18 44 37812 DFFQSRX1 $T=1133600 757645 1 0 $X=1133170 $Y=753090
X729 38126 37802 44 180 18 44 38267 DFFQSRX1 $T=1140880 796845 0 0 $X=1140450 $Y=796455
X730 38105 37802 44 180 18 44 38128 DFFQSRX1 $T=1141440 820365 1 0 $X=1141010 $Y=815810
X731 38326 37802 44 180 18 44 38370 DFFQSRX1 $T=1151520 741965 1 0 $X=1151090 $Y=737410
X732 38407 37384 44 180 18 44 38049 DFFQSRX1 $T=1180080 851725 0 180 $X=1154450 $Y=847170
X733 38127 37384 44 180 18 44 38808 DFFQSRX1 $T=1162160 843885 1 0 $X=1161730 $Y=839330
X734 38859 39868 44 180 18 44 38461 DFFQSRX1 $T=1189600 765485 1 180 $X=1163970 $Y=765095
X735 38788 37802 44 180 18 44 38840 DFFQSRX1 $T=1164960 781165 0 0 $X=1164530 $Y=780775
X736 309 306 44 180 18 44 195 DFFQSRX1 $T=1167200 734125 0 0 $X=1166770 $Y=733735
X737 39487 37802 44 180 18 44 39363 DFFQSRX1 $T=1167200 757645 1 0 $X=1166770 $Y=753090
X738 38984 37802 44 180 18 44 39002 DFFQSRX1 $T=1167200 757645 0 0 $X=1166770 $Y=757255
X739 38805 37802 44 180 18 44 38912 DFFQSRX1 $T=1167200 796845 1 0 $X=1166770 $Y=792290
X740 38946 37384 44 180 18 44 39176 DFFQSRX1 $T=1167200 812525 0 0 $X=1166770 $Y=812135
X741 38825 37384 44 180 18 44 39040 DFFQSRX1 $T=1167200 828205 1 0 $X=1166770 $Y=823650
X742 39406 39868 44 180 18 44 38909 DFFQSRX1 $T=1203600 773325 1 180 $X=1177970 $Y=772935
X743 39510 39868 44 180 18 44 39056 DFFQSRX1 $T=1208080 781165 0 180 $X=1182450 $Y=776610
X744 39383 39868 44 180 18 44 39856 DFFQSRX1 $T=1199680 812525 1 0 $X=1199250 $Y=807970
X745 39533 39868 44 180 18 44 39760 DFFQSRX1 $T=1199680 812525 0 0 $X=1199250 $Y=812135
X746 40120 39868 44 180 18 44 39211 DFFQSRX1 $T=1200240 796845 1 0 $X=1199810 $Y=792290
X747 40003 200 44 180 18 44 40138 DFFQSRX1 $T=1201360 734125 0 0 $X=1200930 $Y=733735
X748 40509 200 44 180 18 44 39933 DFFQSRX1 $T=1232720 757645 0 180 $X=1207090 $Y=753090
X749 40195 39868 44 180 18 44 40412 DFFQSRX1 $T=1208640 765485 0 0 $X=1208210 $Y=765095
X750 41081 39868 44 180 18 44 40567 DFFQSRX1 $T=1251760 804685 0 180 $X=1226130 $Y=800130
X751 40776 200 44 180 18 44 41023 DFFQSRX1 $T=1228800 734125 0 0 $X=1228370 $Y=733735
X752 41299 200 44 180 18 44 41344 DFFQSRX1 $T=1234960 749805 0 0 $X=1234530 $Y=749415
X753 41123 200 44 180 18 44 41124 DFFQSRX1 $T=1234960 757645 1 0 $X=1234530 $Y=753090
X754 41300 39868 44 180 18 44 41246 DFFQSRX1 $T=1234960 773325 0 0 $X=1234530 $Y=772935
X885 59 60 25936 18 44 25896 MUX2X1 $T=772960 734125 0 180 $X=766930 $Y=729570
X886 65 60 26897 18 44 26859 MUX2X1 $T=803200 734125 1 180 $X=797170 $Y=733735
X887 67 60 27112 18 44 27620 MUX2X1 $T=816080 741965 1 0 $X=815650 $Y=737410
X888 69 60 27271 18 44 27720 MUX2X1 $T=819440 749805 0 0 $X=819010 $Y=749415
X889 70 60 27250 18 44 27721 MUX2X1 $T=819440 773325 1 0 $X=819010 $Y=768770
X890 28300 60 27851 18 44 28184 MUX2X1 $T=845200 765485 0 180 $X=839170 $Y=760930
X891 28004 60 28219 18 44 28185 MUX2X1 $T=845200 773325 1 180 $X=839170 $Y=772935
X892 28441 60 27601 18 44 28316 MUX2X1 $T=849680 781165 0 180 $X=843650 $Y=776610
X893 91 60 28477 18 44 28442 MUX2X1 $T=853600 796845 0 180 $X=847570 $Y=792290
X894 96 60 29058 18 44 29331 MUX2X1 $T=869280 765485 1 0 $X=868850 $Y=760930
X895 98 60 29171 18 44 29208 MUX2X1 $T=876000 789005 1 180 $X=869970 $Y=788615
X896 99 60 28664 18 44 29224 MUX2X1 $T=876560 812525 0 180 $X=870530 $Y=807970
X897 100 60 29294 18 44 29259 MUX2X1 $T=877680 804685 0 180 $X=871650 $Y=800130
X898 103 60 29491 18 44 29927 MUX2X1 $T=890000 804685 0 0 $X=889570 $Y=804295
X899 104 60 29334 18 44 29928 MUX2X1 $T=890000 820365 1 0 $X=889570 $Y=815810
X900 30031 60 30030 18 44 29991 MUX2X1 $T=902880 789005 0 180 $X=896850 $Y=784450
X901 110 60 30489 18 44 30459 MUX2X1 $T=917440 804685 0 180 $X=911410 $Y=800130
X902 30288 60 30707 18 44 30680 MUX2X1 $T=925280 812525 1 180 $X=919250 $Y=812135
X903 30153 60 30127 18 44 30830 MUX2X1 $T=920240 804685 1 0 $X=919810 $Y=800130
X904 116 60 30979 18 44 31015 MUX2X1 $T=926400 789005 1 0 $X=925970 $Y=784450
X905 30753 60 30891 18 44 30863 MUX2X1 $T=932000 812525 1 180 $X=925970 $Y=812135
X906 32183 32007 32144 18 44 32203 MUX2X1 $T=967840 789005 0 0 $X=967410 $Y=788615
X907 30769 60 33396 18 44 33361 MUX2X1 $T=1009280 828205 0 180 $X=1003250 $Y=823650
X908 33147 60 33074 18 44 33395 MUX2X1 $T=1010400 804685 1 180 $X=1004370 $Y=804295
X909 158 159 33752 18 44 33717 MUX2X1 $T=1020480 734125 1 180 $X=1014450 $Y=733735
X910 155 60 33982 18 44 33948 MUX2X1 $T=1028320 796845 1 180 $X=1022290 $Y=796455
X911 34070 60 33653 18 44 33949 MUX2X1 $T=1028320 804685 1 180 $X=1022290 $Y=804295
X912 148 60 34166 18 44 34132 MUX2X1 $T=1034480 820365 1 180 $X=1028450 $Y=819975
X913 33700 60 34322 18 44 34354 MUX2X1 $T=1031120 804685 0 0 $X=1030690 $Y=804295
X914 161 159 34372 18 44 34369 MUX2X1 $T=1042320 734125 0 180 $X=1036290 $Y=729570
X915 162 159 34576 18 44 34608 MUX2X1 $T=1039520 741965 1 0 $X=1039090 $Y=737410
X916 34528 60 34861 18 44 34829 MUX2X1 $T=1057440 796845 0 180 $X=1051410 $Y=792290
X917 34513 60 34934 18 44 34910 MUX2X1 $T=1060240 812525 1 180 $X=1054210 $Y=812135
X918 33718 60 34954 18 44 35680 MUX2X1 $T=1073120 820365 1 0 $X=1072690 $Y=815810
X919 34894 60 35756 18 44 35799 MUX2X1 $T=1076480 804685 1 0 $X=1076050 $Y=800130
X920 35873 35679 35695 18 44 35661 MUX2X1 $T=1085440 781165 0 180 $X=1079410 $Y=776610
X921 169 60 36010 18 44 36051 MUX2X1 $T=1084320 804685 1 0 $X=1083890 $Y=800130
X922 34912 60 36617 18 44 36585 MUX2X1 $T=1112880 796845 1 180 $X=1106850 $Y=796455
X923 183 60 36934 18 44 37433 MUX2X1 $T=1127440 796845 0 0 $X=1127010 $Y=796455
X924 186 60 37779 18 44 37746 MUX2X1 $T=1147600 781165 1 180 $X=1141570 $Y=780775
X925 187 60 37812 18 44 37777 MUX2X1 $T=1148720 749805 1 180 $X=1142690 $Y=749415
X926 188 60 37813 18 44 37778 MUX2X1 $T=1148720 773325 1 180 $X=1142690 $Y=772935
X927 37376 60 37948 18 44 37914 MUX2X1 $T=1153200 781165 1 180 $X=1147170 $Y=780775
X928 190 60 38350 18 44 38308 MUX2X1 $T=1165520 749805 0 180 $X=1159490 $Y=745250
X929 191 60 38370 18 44 38326 MUX2X1 $T=1166080 734125 1 180 $X=1160050 $Y=733735
X930 50 48 18 44 25005 NAND2X1 $T=750560 734125 1 180 $X=747330 $Y=733735
X931 45 24257 18 44 25293 NAND2X1 $T=752240 796845 0 180 $X=749010 $Y=792290
X932 45 25371 18 44 25313 NAND2X1 $T=751120 820365 1 0 $X=750690 $Y=815810
X933 52 25226 18 44 55 NAND2X1 $T=754480 734125 0 180 $X=751250 $Y=729570
X934 25451 56 18 44 25432 NAND2X1 $T=756160 757645 1 180 $X=752930 $Y=757255
X935 25642 48 18 44 25579 NAND2X1 $T=761200 773325 1 180 $X=757970 $Y=772935
X936 52 25642 18 44 25451 NAND2X1 $T=763440 757645 1 180 $X=760210 $Y=757255
X937 25821 25859 18 44 25840 NAND2X1 $T=764560 749805 1 0 $X=764130 $Y=745250
X938 58 25936 18 44 25859 NAND2X1 $T=767360 749805 1 0 $X=766930 $Y=745250
X939 52 25724 18 44 26114 NAND2X1 $T=775760 781165 1 180 $X=772530 $Y=780775
X940 45 25915 18 44 26270 NAND2X1 $T=778000 796845 0 0 $X=777570 $Y=796455
X941 58 61 18 44 26237 NAND2X1 $T=781920 749805 1 180 $X=778690 $Y=749415
X942 46 26333 18 44 26308 NAND2X1 $T=779120 812525 0 0 $X=778690 $Y=812135
X943 26435 48 18 44 26180 NAND2X1 $T=787520 796845 0 180 $X=784290 $Y=792290
X944 46 25915 18 44 26570 NAND2X1 $T=790320 820365 0 180 $X=787090 $Y=815810
X945 45 26776 18 44 26591 NAND2X1 $T=793120 843885 0 0 $X=792690 $Y=843495
X946 26825 26754 18 44 26811 NAND2X1 $T=797600 789005 0 180 $X=794370 $Y=784450
X947 52 26435 18 44 26807 NAND2X1 $T=798160 765485 0 180 $X=794930 $Y=760930
X948 52 26468 18 44 26881 NAND2X1 $T=799840 765485 1 180 $X=796610 $Y=765095
X949 45 25969 18 44 26882 NAND2X1 $T=799840 804685 1 180 $X=796610 $Y=804295
X950 46 26607 18 44 26956 NAND2X1 $T=804320 843885 1 180 $X=801090 $Y=843495
X951 52 26569 18 44 26945 NAND2X1 $T=802080 789005 1 0 $X=801650 $Y=784450
X952 58 27112 18 44 26844 NAND2X1 $T=803760 749805 0 0 $X=803330 $Y=749415
X953 27109 27141 18 44 27127 NAND2X1 $T=804880 789005 1 0 $X=804450 $Y=784450
X954 26808 48 18 44 27000 NAND2X1 $T=805440 804685 0 0 $X=805010 $Y=804295
X955 46 27003 18 44 27142 NAND2X1 $T=808240 836045 0 180 $X=805010 $Y=831490
X956 45 26607 18 44 27218 NAND2X1 $T=810480 851725 1 180 $X=807250 $Y=851335
X957 27361 48 18 44 27444 NAND2X1 $T=818320 812525 0 0 $X=817890 $Y=812135
X958 46 27408 18 44 27567 NAND2X1 $T=818320 851725 1 0 $X=817890 $Y=847170
X959 45 27326 18 44 27635 NAND2X1 $T=823360 859565 1 180 $X=820130 $Y=859175
X960 27701 48 18 44 27424 NAND2X1 $T=825040 820365 0 180 $X=821810 $Y=815810
X961 45 27362 18 44 27722 NAND2X1 $T=824480 851725 0 0 $X=824050 $Y=851335
X962 46 27362 18 44 27797 NAND2X1 $T=832880 859565 0 180 $X=829650 $Y=855010
X963 46 26776 18 44 27957 NAND2X1 $T=833440 851725 1 180 $X=830210 $Y=851335
X964 52 27701 18 44 28190 NAND2X1 $T=841280 812525 0 180 $X=838050 $Y=807970
X965 27902 48 18 44 27804 NAND2X1 $T=838480 843885 1 0 $X=838050 $Y=839330
X966 52 27902 18 44 28169 NAND2X1 $T=841280 820365 0 0 $X=840850 $Y=819975
X967 58 28219 18 44 28254 NAND2X1 $T=841840 796845 1 0 $X=841410 $Y=792290
X968 28299 82 18 44 28593 NAND2X1 $T=851920 741965 0 0 $X=851490 $Y=741575
X969 46 27704 18 44 28628 NAND2X1 $T=855840 851725 0 180 $X=852610 $Y=847170
X970 28303 48 18 44 28648 NAND2X1 $T=853600 843885 1 0 $X=853170 $Y=839330
X971 86 28441 18 44 28646 NAND2X1 $T=859200 749805 0 0 $X=858770 $Y=749415
X972 86 28300 18 44 28891 NAND2X1 $T=860320 749805 1 0 $X=859890 $Y=745250
X973 52 28020 18 44 28823 NAND2X1 $T=864800 828205 0 180 $X=861570 $Y=823650
X974 52 29135 18 44 28935 NAND2X1 $T=866480 843885 0 0 $X=866050 $Y=843495
X975 58 29334 18 44 28289 NAND2X1 $T=872640 828205 1 0 $X=872210 $Y=823650
X976 52 29332 18 44 29595 NAND2X1 $T=884960 851725 1 180 $X=881730 $Y=851335
X977 86 98 18 44 29775 NAND2X1 $T=888880 749805 1 0 $X=888450 $Y=745250
X978 46 29929 18 44 29643 NAND2X1 $T=893360 867405 0 0 $X=892930 $Y=867015
X979 30241 48 18 44 30205 NAND2X1 $T=906240 851725 1 180 $X=903010 $Y=851335
X980 52 30241 18 44 30166 NAND2X1 $T=904000 836045 1 0 $X=903570 $Y=831490
X981 46 30395 18 44 30253 NAND2X1 $T=907920 867405 0 0 $X=907490 $Y=867015
X982 86 99 18 44 111 NAND2X1 $T=908480 741965 1 0 $X=908050 $Y=737410
X983 30431 82 18 44 30430 NAND2X1 $T=912400 741965 1 180 $X=909170 $Y=741575
X984 45 30395 18 44 30303 NAND2X1 $T=913520 867405 1 180 $X=910290 $Y=867015
X985 46 30461 18 44 30539 NAND2X1 $T=913520 867405 0 0 $X=913090 $Y=867015
X986 30650 30555 18 44 30636 NAND2X1 $T=919680 836045 0 180 $X=916450 $Y=831490
X987 30689 48 18 44 30635 NAND2X1 $T=921360 859565 1 180 $X=918130 $Y=859175
X988 58 30127 18 44 30711 NAND2X1 $T=919680 836045 1 0 $X=919250 $Y=831490
X989 30798 30771 18 44 30781 NAND2X1 $T=925280 843885 1 180 $X=922050 $Y=843495
X990 30864 30711 18 44 30843 NAND2X1 $T=927520 836045 1 180 $X=924290 $Y=835655
X991 82 30769 18 44 30871 NAND2X1 $T=926400 741965 0 0 $X=925970 $Y=741575
X992 30929 48 18 44 30911 NAND2X1 $T=929760 859565 1 180 $X=926530 $Y=859175
X993 86 30288 18 44 30828 NAND2X1 $T=931440 749805 0 180 $X=928210 $Y=745250
X994 52 30929 18 44 30798 NAND2X1 $T=934240 851725 0 180 $X=931010 $Y=847170
X995 46 30832 18 44 31246 NAND2X1 $T=939840 867405 1 180 $X=936610 $Y=867015
X996 31375 31439 18 44 31415 NAND2X1 $T=941520 757645 0 0 $X=941090 $Y=757255
X997 31435 31183 18 44 31416 NAND2X1 $T=944320 836045 0 180 $X=941090 $Y=831490
X998 46 29445 18 44 31414 NAND2X1 $T=944320 867405 0 180 $X=941090 $Y=862850
X999 118 109 18 44 31317 NAND2X1 $T=944880 734125 0 0 $X=944450 $Y=733735
X1000 31683 127 18 44 31355 NAND2X1 $T=950480 749805 1 0 $X=950050 $Y=745250
X1001 31462 129 18 44 31700 NAND2X1 $T=950480 757645 1 0 $X=950050 $Y=753090
X1002 58 30891 18 44 31703 NAND2X1 $T=954960 836045 0 180 $X=951730 $Y=831490
X1003 52 31734 18 44 31435 NAND2X1 $T=954960 836045 1 180 $X=951730 $Y=835655
X1004 129 132 18 44 31779 NAND2X1 $T=953280 749805 0 0 $X=952850 $Y=749415
X1005 31747 134 18 44 31813 NAND2X1 $T=954960 796845 1 0 $X=954530 $Y=792290
X1006 52 31513 18 44 31668 NAND2X1 $T=954960 851725 0 0 $X=954530 $Y=851335
X1007 136 135 18 44 31269 NAND2X1 $T=959440 734125 0 180 $X=956210 $Y=729570
X1008 31740 31928 18 44 31783 NAND2X1 $T=957760 820365 1 0 $X=957330 $Y=815810
X1009 31954 31643 18 44 31937 NAND2X1 $T=961680 781165 0 180 $X=958450 $Y=776610
X1010 31911 31683 18 44 31953 NAND2X1 $T=962240 749805 1 180 $X=959010 $Y=749415
X1011 31917 31913 18 44 31987 NAND2X1 $T=963360 820365 0 180 $X=960130 $Y=815810
X1012 32010 31778 18 44 32006 NAND2X1 $T=963920 757645 0 180 $X=960690 $Y=753090
X1013 45 32054 18 44 31974 NAND2X1 $T=962240 867405 0 0 $X=961810 $Y=867015
X1014 31953 32006 18 44 32085 NAND2X1 $T=966720 757645 0 180 $X=963490 $Y=753090
X1015 32106 32105 18 44 31928 NAND2X1 $T=965040 812525 0 0 $X=964610 $Y=812135
X1016 32107 31881 18 44 32123 NAND2X1 $T=965040 820365 1 0 $X=964610 $Y=815810
X1017 32183 32228 18 44 32106 NAND2X1 $T=967840 820365 1 0 $X=967410 $Y=815810
X1018 32244 129 18 44 32316 NAND2X1 $T=971200 749805 0 0 $X=970770 $Y=749415
X1019 32351 32152 18 44 32296 NAND2X1 $T=974560 804685 1 180 $X=971330 $Y=804295
X1020 32177 122 18 44 32349 NAND2X1 $T=972320 765485 0 0 $X=971890 $Y=765095
X1021 32385 31861 18 44 32132 NAND2X1 $T=975680 773325 0 180 $X=972450 $Y=768770
X1022 32316 32104 18 44 32348 NAND2X1 $T=976800 749805 1 180 $X=973570 $Y=749415
X1023 31415 125 18 44 32423 NAND2X1 $T=977360 757645 0 180 $X=974130 $Y=753090
X1024 32514 32263 18 44 32403 NAND2X1 $T=979600 781165 1 180 $X=976370 $Y=780775
X1025 31825 31862 18 44 32496 NAND2X1 $T=976800 796845 0 0 $X=976370 $Y=796455
X1026 32370 134 18 44 32515 NAND2X1 $T=977360 789005 0 0 $X=976930 $Y=788615
X1027 32584 144 18 44 32563 NAND2X1 $T=981840 734125 1 180 $X=978610 $Y=733735
X1028 145 146 18 44 32584 NAND2X1 $T=980720 734125 1 0 $X=980290 $Y=729570
X1029 31825 32516 18 44 32708 NAND2X1 $T=986320 820365 0 180 $X=983090 $Y=815810
X1030 32107 134 18 44 32674 NAND2X1 $T=986880 820365 1 180 $X=983650 $Y=819975
X1031 32514 32088 18 44 32779 NAND2X1 $T=985760 781165 0 0 $X=985330 $Y=780775
X1032 32144 32755 18 44 32707 NAND2X1 $T=989680 796845 0 180 $X=986450 $Y=792290
X1033 32107 32088 18 44 32872 NAND2X1 $T=988560 781165 0 0 $X=988130 $Y=780775
X1034 45 32317 18 44 32995 NAND2X1 $T=994720 867405 0 180 $X=991490 $Y=862850
X1035 32913 32197 18 44 33073 NAND2X1 $T=996960 820365 0 180 $X=993730 $Y=815810
X1036 46 33152 18 44 32716 NAND2X1 $T=995840 875245 1 0 $X=995410 $Y=870690
X1037 151 152 18 44 33303 NAND2X1 $T=1002000 734125 0 0 $X=1001570 $Y=733735
X1038 33360 82 18 44 33338 NAND2X1 $T=1004800 765485 0 180 $X=1001570 $Y=760930
X1039 33263 33412 18 44 33504 NAND2X1 $T=1007040 836045 0 0 $X=1006610 $Y=835655
X1040 82 155 18 44 33544 NAND2X1 $T=1008160 765485 1 0 $X=1007730 $Y=760930
X1041 86 33147 18 44 33523 NAND2X1 $T=1011520 765485 1 180 $X=1008290 $Y=765095
X1042 33580 33619 18 44 33599 NAND2X1 $T=1009840 836045 0 0 $X=1009410 $Y=835655
X1043 151 156 18 44 33614 NAND2X1 $T=1010400 734125 0 0 $X=1009970 $Y=733735
X1044 52 33246 18 44 33580 NAND2X1 $T=1015440 836045 1 180 $X=1012210 $Y=835655
X1045 46 33772 18 44 33899 NAND2X1 $T=1019920 867405 1 0 $X=1019490 $Y=862850
X1046 33932 82 18 44 33917 NAND2X1 $T=1023280 773325 0 180 $X=1020050 $Y=768770
X1047 46 31514 18 44 34051 NAND2X1 $T=1027760 859565 1 180 $X=1024530 $Y=859175
X1048 86 34070 18 44 34126 NAND2X1 $T=1027760 773325 0 0 $X=1027330 $Y=772935
X1049 52 34204 18 44 34184 NAND2X1 $T=1029440 843885 0 0 $X=1029010 $Y=843495
X1050 52 34257 18 44 34239 NAND2X1 $T=1031120 851725 1 0 $X=1030690 $Y=847170
X1051 58 34166 18 44 34256 NAND2X1 $T=1031680 836045 1 0 $X=1031250 $Y=831490
X1052 34239 34256 18 44 34323 NAND2X1 $T=1036720 851725 0 180 $X=1033490 $Y=847170
X1053 34257 48 18 44 34479 NAND2X1 $T=1039520 867405 1 0 $X=1039090 $Y=862850
X1054 151 34576 18 44 34560 NAND2X1 $T=1041760 741965 0 0 $X=1041330 $Y=741575
X1055 86 148 18 44 34562 NAND2X1 $T=1044560 757645 0 180 $X=1041330 $Y=753090
X1056 34577 82 18 44 34321 NAND2X1 $T=1044560 773325 0 180 $X=1041330 $Y=768770
X1057 151 165 18 44 34712 NAND2X1 $T=1052400 734125 0 0 $X=1051970 $Y=733735
X1058 86 34513 18 44 34876 NAND2X1 $T=1055200 773325 0 180 $X=1051970 $Y=768770
X1059 58 34861 18 44 34913 NAND2X1 $T=1053520 828205 1 0 $X=1053090 $Y=823650
X1060 34891 34913 18 44 34911 NAND2X1 $T=1053520 828205 0 0 $X=1053090 $Y=827815
X1061 34935 48 18 44 34862 NAND2X1 $T=1056880 859565 0 180 $X=1053650 $Y=855010
X1062 86 34528 18 44 34957 NAND2X1 $T=1058000 749805 1 180 $X=1054770 $Y=749415
X1063 52 34529 18 44 34891 NAND2X1 $T=1059120 828205 1 180 $X=1055890 $Y=827815
X1064 58 34934 18 44 35058 NAND2X1 $T=1059120 828205 0 0 $X=1058690 $Y=827815
X1065 46 35396 18 44 35169 NAND2X1 $T=1068640 875245 0 0 $X=1068210 $Y=874855
X1066 46 34735 18 44 35558 NAND2X1 $T=1076480 875245 0 180 $X=1073250 $Y=870690
X1067 35568 35621 18 44 35541 NAND2X1 $T=1074800 765485 1 0 $X=1074370 $Y=760930
X1068 35661 35699 18 44 35569 NAND2X1 $T=1077040 781165 1 0 $X=1076610 $Y=776610
X1069 35594 35761 18 44 35660 NAND2X1 $T=1078720 773325 0 0 $X=1078290 $Y=772935
X1070 35755 35673 18 44 35737 NAND2X1 $T=1081520 789005 0 180 $X=1078290 $Y=784450
X1071 35754 35749 18 44 35761 NAND2X1 $T=1079840 773325 1 0 $X=1079410 $Y=768770
X1072 35842 35618 18 44 35818 NAND2X1 $T=1083760 843885 0 180 $X=1080530 $Y=839330
X1073 35854 35695 18 44 35734 NAND2X1 $T=1084320 789005 0 180 $X=1081090 $Y=784450
X1074 35874 35911 18 44 35542 NAND2X1 $T=1083200 789005 0 0 $X=1082770 $Y=788615
X1075 58 35756 18 44 35910 NAND2X1 $T=1083760 820365 0 0 $X=1083330 $Y=819975
X1076 35926 35962 18 44 35557 NAND2X1 $T=1084880 757645 1 0 $X=1084450 $Y=753090
X1077 35964 35910 18 44 35963 NAND2X1 $T=1088240 828205 0 180 $X=1085010 $Y=823650
X1078 36228 35957 18 44 36085 NAND2X1 $T=1096080 757645 1 180 $X=1092850 $Y=757255
X1079 35754 36066 18 44 36129 NAND2X1 $T=1097200 749805 1 180 $X=1093970 $Y=749415
X1080 36137 33543 18 44 35874 NAND2X1 $T=1096080 789005 0 0 $X=1095650 $Y=788615
X1081 58 36010 18 44 36483 NAND2X1 $T=1105040 820365 0 180 $X=1101810 $Y=815810
X1082 36311 48 18 44 36052 NAND2X1 $T=1102240 843885 1 0 $X=1101810 $Y=839330
X1083 36067 36566 18 44 36622 NAND2X1 $T=1107280 749805 1 0 $X=1106850 $Y=745250
X1084 36665 36483 18 44 36650 NAND2X1 $T=1111200 820365 0 180 $X=1107970 $Y=815810
X1085 36310 48 18 44 36653 NAND2X1 $T=1108400 843885 1 0 $X=1107970 $Y=839330
X1086 36349 35754 18 44 36695 NAND2X1 $T=1112880 749805 0 180 $X=1109650 $Y=745250
X1087 36727 36102 18 44 36592 NAND2X1 $T=1113440 773325 1 180 $X=1110210 $Y=772935
X1088 35749 36460 18 44 36696 NAND2X1 $T=1114000 781165 1 180 $X=1110770 $Y=780775
X1089 33543 35962 18 44 36743 NAND2X1 $T=1114560 789005 1 180 $X=1111330 $Y=788615
X1090 58 36617 18 44 36757 NAND2X1 $T=1112320 812525 0 0 $X=1111890 $Y=812135
X1091 52 36310 18 44 36665 NAND2X1 $T=1115120 828205 1 180 $X=1111890 $Y=827815
X1092 35749 36743 18 44 36613 NAND2X1 $T=1115680 796845 0 180 $X=1112450 $Y=792290
X1093 36176 36835 18 44 36814 NAND2X1 $T=1114000 781165 1 0 $X=1113570 $Y=776610
X1094 36651 36757 18 44 36860 NAND2X1 $T=1115120 828205 0 0 $X=1114690 $Y=827815
X1095 36858 36697 18 44 36859 NAND2X1 $T=1120720 757645 1 180 $X=1117490 $Y=757255
X1096 58 36934 18 44 37284 NAND2X1 $T=1129680 812525 0 180 $X=1126450 $Y=807970
X1097 52 37400 18 44 37357 NAND2X1 $T=1129680 820365 0 0 $X=1129250 $Y=819975
X1098 37400 48 18 44 37372 NAND2X1 $T=1133600 836045 1 180 $X=1130370 $Y=835655
X1099 82 186 18 44 37829 NAND2X1 $T=1143680 734125 0 0 $X=1143250 $Y=733735
X1100 46 37638 18 44 37849 NAND2X1 $T=1147040 851725 0 180 $X=1143810 $Y=847170
X1101 46 37931 18 44 36040 NAND2X1 $T=1146480 859565 1 0 $X=1146050 $Y=855010
X1102 58 37813 18 44 38036 NAND2X1 $T=1150400 789005 0 0 $X=1149970 $Y=788615
X1103 38106 37915 18 44 38105 NAND2X1 $T=1155440 812525 1 180 $X=1152210 $Y=812135
X1104 46 36497 18 44 38107 NAND2X1 $T=1155440 836045 0 180 $X=1152210 $Y=831490
X1105 38144 38036 18 44 38126 NAND2X1 $T=1156000 789005 1 180 $X=1152770 $Y=788615
X1106 38128 48 18 44 38108 NAND2X1 $T=1156000 828205 1 180 $X=1152770 $Y=827815
X1107 38158 38197 18 44 38181 NAND2X1 $T=1154880 804685 1 0 $X=1154450 $Y=800130
X1108 58 37948 18 44 38285 NAND2X1 $T=1161040 789005 0 180 $X=1157810 $Y=784450
X1109 38267 48 18 44 38311 NAND2X1 $T=1158800 828205 1 0 $X=1158370 $Y=823650
X1110 46 38329 18 44 36807 NAND2X1 $T=1158800 836045 1 0 $X=1158370 $Y=831490
X1111 45 38049 18 44 38327 NAND2X1 $T=1162160 843885 0 180 $X=1158930 $Y=839330
X1112 58 192 18 44 38197 NAND2X1 $T=1163280 765485 1 0 $X=1162850 $Y=760930
X1113 46 37970 18 44 38484 NAND2X1 $T=1166640 828205 1 180 $X=1163410 $Y=827815
X1114 58 38370 18 44 38787 NAND2X1 $T=1173360 749805 1 0 $X=1172930 $Y=745250
X1115 38840 48 18 44 38806 NAND2X1 $T=1177280 804685 0 180 $X=1174050 $Y=800130
X1116 46 38894 18 44 38437 NAND2X1 $T=1176160 836045 1 0 $X=1175730 $Y=831490
X1117 52 38912 18 44 38824 NAND2X1 $T=1176720 789005 0 0 $X=1176290 $Y=788615
X1118 52 38840 18 44 38804 NAND2X1 $T=1179520 789005 0 0 $X=1179090 $Y=788615
X1119 39002 48 18 44 38928 NAND2X1 $T=1182880 804685 0 180 $X=1179650 $Y=800130
X1120 58 194 18 44 39001 NAND2X1 $T=1180640 741965 0 0 $X=1180210 $Y=741575
X1121 58 196 18 44 39431 NAND2X1 $T=1192400 741965 1 0 $X=1191970 $Y=737410
X1122 39056 48 18 44 39511 NAND2X1 $T=1197440 796845 0 180 $X=1194210 $Y=792290
X1123 45 38894 18 44 39596 NAND2X1 $T=1199680 828205 0 180 $X=1196450 $Y=823650
X1124 46 39176 18 44 39737 NAND2X1 $T=1203600 804685 0 180 $X=1200370 $Y=800130
X1125 46 39760 18 44 39564 NAND2X1 $T=1200800 820365 1 0 $X=1200370 $Y=815810
X1126 45 39856 18 44 39468 NAND2X1 $T=1203600 804685 1 0 $X=1203170 $Y=800130
X1127 45 39760 18 44 39449 NAND2X1 $T=1206400 820365 0 180 $X=1203170 $Y=815810
X1128 45 39211 18 44 39914 NAND2X1 $T=1208640 789005 1 180 $X=1205410 $Y=788615
X1129 40138 48 18 44 40123 NAND2X1 $T=1214800 765485 0 180 $X=1211570 $Y=760930
X1130 52 40138 18 44 40025 NAND2X1 $T=1216480 741965 0 180 $X=1213250 $Y=737410
X1131 198 48 18 44 40160 NAND2X1 $T=1216480 749805 1 180 $X=1213250 $Y=749415
X1132 40175 40160 18 44 40176 NAND2X1 $T=1216480 781165 0 180 $X=1213250 $Y=776610
X1133 45 40177 18 44 40175 NAND2X1 $T=1217040 789005 1 180 $X=1213810 $Y=788615
X1134 39933 48 18 44 40227 NAND2X1 $T=1218160 773325 1 180 $X=1214930 $Y=772935
X1135 52 40551 18 44 40281 NAND2X1 $T=1224320 741965 1 0 $X=1223890 $Y=737410
X1136 46 40567 18 44 40088 NAND2X1 $T=1225440 796845 1 0 $X=1225010 $Y=792290
X1137 40551 48 18 44 40610 NAND2X1 $T=1227680 781165 1 0 $X=1227250 $Y=776610
X1138 45 40567 18 44 40863 NAND2X1 $T=1236080 781165 0 180 $X=1232850 $Y=776610
X1139 58 204 18 44 41042 NAND2X1 $T=1238320 734125 1 0 $X=1237890 $Y=729570
X1140 52 41124 18 44 41103 NAND2X1 $T=1240000 765485 1 0 $X=1239570 $Y=760930
X1141 41103 41042 18 44 41123 NAND2X1 $T=1243360 749805 0 180 $X=1240130 $Y=745250
X1142 41124 48 18 44 41165 NAND2X1 $T=1244480 781165 0 180 $X=1241250 $Y=776610
X1143 205 48 18 44 41206 NAND2X1 $T=1245600 765485 0 180 $X=1242370 $Y=760930
X1144 45 41246 18 44 41226 NAND2X1 $T=1243360 765485 0 0 $X=1242930 $Y=765095
X1145 206 48 18 44 41264 NAND2X1 $T=1247280 734125 0 180 $X=1244050 $Y=729570
X1146 45 41344 18 44 41343 NAND2X1 $T=1246720 741965 0 0 $X=1246290 $Y=741575
X1383 18 44 26468 48 26750 ICV_68 $T=792000 796845 0 0 $X=791570 $Y=796455
X1384 18 44 45 27003 26860 ICV_68 $T=799280 820365 0 0 $X=798850 $Y=819975
X1385 18 44 27668 72 27687 ICV_68 $T=821120 734125 0 0 $X=820690 $Y=733735
X1386 18 44 82 28300 28284 ICV_68 $T=840720 749805 1 0 $X=840290 $Y=745250
X1387 18 44 52 28220 28252 ICV_68 $T=844640 843885 0 0 $X=844210 $Y=843495
X1388 18 44 58 28477 28354 ICV_68 $T=846320 812525 1 0 $X=845890 $Y=807970
X1389 18 44 29135 48 29172 ICV_68 $T=867040 851725 1 0 $X=866610 $Y=847170
X1390 18 44 58 30979 31183 ICV_68 $T=934240 836045 1 0 $X=933810 $Y=831490
X1391 18 44 31816 32388 32351 ICV_68 $T=971760 812525 1 0 $X=971330 $Y=807970
X1392 18 44 31913 31881 32517 ICV_68 $T=976240 820365 0 0 $X=975810 $Y=819975
X1393 18 44 58 33074 33012 ICV_68 $T=994720 836045 0 0 $X=994290 $Y=835655
X1394 18 44 82 148 34499 ICV_68 $T=1038400 773325 0 0 $X=1037970 $Y=772935
X1395 18 44 36054 36050 36023 ICV_68 $T=1090480 781165 1 0 $X=1090050 $Y=776610
X1396 18 44 45 36264 36138 ICV_68 $T=1093280 859565 0 0 $X=1092850 $Y=859175
X1397 18 44 86 183 36988 ICV_68 $T=1122400 734125 0 0 $X=1121970 $Y=733735
X1398 18 44 52 38267 38144 ICV_68 $T=1156000 789005 0 0 $X=1155570 $Y=788615
X1399 18 44 45 207 41301 ICV_68 $T=1247840 781165 0 0 $X=1247410 $Y=780775
X1400 18 45 24867 24782 44 ICV_69 $T=735440 749805 1 0 $X=735010 $Y=745250
X1401 18 25601 57 25641 44 ICV_69 $T=757280 741965 0 0 $X=756850 $Y=741575
X1402 18 26114 26163 26146 44 ICV_69 $T=772400 773325 0 0 $X=771970 $Y=772935
X1403 18 25703 48 26233 44 ICV_69 $T=776880 796845 1 0 $X=776450 $Y=792290
X1404 18 58 62 26163 44 ICV_69 $T=781360 749805 1 0 $X=780930 $Y=745250
X1405 18 45 26309 26331 44 ICV_69 $T=781360 836045 1 0 $X=780930 $Y=831490
X1406 18 26569 48 26486 44 ICV_69 $T=787520 796845 0 0 $X=787090 $Y=796455
X1407 18 26807 26844 26827 44 ICV_69 $T=793680 749805 0 0 $X=793250 $Y=749415
X1408 18 52 26965 26825 44 ICV_69 $T=797600 789005 1 0 $X=797170 $Y=784450
X1409 18 26945 26982 26978 44 ICV_69 $T=798160 781165 0 0 $X=797730 $Y=780775
X1410 18 52 27383 27747 44 ICV_69 $T=822800 789005 1 0 $X=822370 $Y=784450
X1411 18 58 27851 27809 44 ICV_69 $T=825040 781165 1 0 $X=824610 $Y=776610
X1412 18 28169 28207 28191 44 ICV_69 $T=836800 820365 0 0 $X=836370 $Y=819975
X1413 18 58 28664 28207 44 ICV_69 $T=851920 820365 1 0 $X=851490 $Y=815810
X1414 18 28823 28870 28847 44 ICV_69 $T=857520 828205 1 0 $X=857090 $Y=823650
X1415 18 28935 28977 28956 44 ICV_69 $T=860320 836045 0 0 $X=859890 $Y=835655
X1416 18 58 29294 29426 44 ICV_69 $T=874880 820365 0 0 $X=874450 $Y=819975
X1417 18 58 30030 30095 44 ICV_69 $T=897840 820365 1 0 $X=897410 $Y=815810
X1418 18 52 30689 30650 44 ICV_69 $T=916880 836045 0 0 $X=916450 $Y=835655
X1419 18 45 30832 30708 44 ICV_69 $T=921920 867405 0 0 $X=921490 $Y=867015
X1420 18 52 30997 30864 44 ICV_69 $T=927520 836045 0 0 $X=927090 $Y=835655
X1421 18 31245 31295 31270 44 ICV_69 $T=935920 749805 1 0 $X=935490 $Y=745250
X1422 18 31269 31317 31294 44 ICV_69 $T=936480 734125 1 0 $X=936050 $Y=729570
X1423 18 46 31440 30254 44 ICV_69 $T=939840 875245 1 0 $X=939410 $Y=870690
X1424 18 30997 48 31570 44 ICV_69 $T=944320 851725 0 0 $X=943890 $Y=851335
X1425 18 31648 31685 31667 44 ICV_69 $T=947680 828205 1 0 $X=947250 $Y=823650
X1426 18 31740 31816 31782 44 ICV_69 $T=952160 812525 0 0 $X=951730 $Y=812135
X1427 18 134 31861 31781 44 ICV_69 $T=967280 781165 0 0 $X=966850 $Y=780775
X1428 18 32261 32296 32275 44 ICV_69 $T=968400 796845 1 0 $X=967970 $Y=792290
X1429 18 32152 31881 32144 44 ICV_69 $T=980720 796845 1 0 $X=980290 $Y=792290
X1430 18 32622 31881 32762 44 ICV_69 $T=983520 812525 1 0 $X=983090 $Y=807970
X1431 18 58 33396 33412 44 ICV_69 $T=1002560 836045 0 0 $X=1002130 $Y=835655
X1432 18 33246 48 33524 44 ICV_69 $T=1009280 859565 1 0 $X=1008850 $Y=855010
X1433 18 58 33982 34071 44 ICV_69 $T=1023840 836045 1 0 $X=1023410 $Y=831490
X1434 18 34529 48 34752 44 ICV_69 $T=1046240 851725 0 0 $X=1045810 $Y=851335
X1435 18 45 35060 34936 44 ICV_69 $T=1056880 859565 0 0 $X=1056450 $Y=859175
X1436 18 82 169 35102 44 ICV_69 $T=1059120 741965 0 0 $X=1058690 $Y=741575
X1437 18 35039 48 35177 44 ICV_69 $T=1061360 859565 0 0 $X=1060930 $Y=859175
X1438 18 35699 35754 36292 44 ICV_69 $T=1094400 796845 1 0 $X=1093970 $Y=792290
X1439 18 86 34912 178 44 ICV_69 $T=1102800 734125 0 0 $X=1102370 $Y=733735
X1440 18 36640 36690 36398 44 ICV_69 $T=1107280 749805 0 0 $X=1106850 $Y=749415
X1441 18 36756 36792 36600 44 ICV_69 $T=1114000 781165 0 0 $X=1113570 $Y=780775
X1442 18 46 38049 37462 44 ICV_69 $T=1148720 851725 0 0 $X=1148290 $Y=851335
X1443 18 52 38128 38106 44 ICV_69 $T=1150960 828205 1 0 $X=1150530 $Y=823650
X1444 18 38963 39001 38984 44 ICV_69 $T=1177840 749805 0 0 $X=1177410 $Y=749415
X1445 18 45 39040 38892 44 ICV_69 $T=1178960 820365 0 0 $X=1178530 $Y=819975
X1446 18 45 39176 39019 44 ICV_69 $T=1182880 804685 1 0 $X=1182450 $Y=800130
X1447 18 58 195 39324 44 ICV_69 $T=1187920 741965 0 0 $X=1187490 $Y=741575
X1448 18 38912 48 39343 44 ICV_69 $T=1188480 796845 0 0 $X=1188050 $Y=796455
X1449 18 45 40412 40266 44 ICV_69 $T=1218720 765485 1 0 $X=1218290 $Y=760930
X1450 18 45 41023 40862 44 ICV_69 $T=1235520 741965 1 0 $X=1235090 $Y=737410
X1451 18 46 41344 41319 44 ICV_69 $T=1244480 757645 0 0 $X=1244050 $Y=757255
X1452 18 46 41246 41257 44 ICV_69 $T=1244480 781165 1 0 $X=1244050 $Y=776610
X1453 27803 73 18 44 27829 NOR2X1 $T=826720 741965 1 0 $X=826290 $Y=737410
X1454 84 28333 18 44 28334 NOR2X1 $T=843520 734125 0 0 $X=843090 $Y=733735
X1455 31391 31434 18 44 30770 NOR2X1 $T=941520 789005 1 0 $X=941090 $Y=784450
X1456 31512 31544 18 44 31531 NOR2X1 $T=944880 765485 0 0 $X=944450 $Y=765095
X1457 31528 31554 18 44 30307 NOR2X1 $T=945440 781165 1 0 $X=945010 $Y=776610
X1458 31667 31714 18 44 29349 NOR2X1 $T=950480 773325 0 0 $X=950050 $Y=772935
X1459 31715 31747 18 44 31597 NOR2X1 $T=951600 789005 0 0 $X=951170 $Y=788615
X1460 122 31462 18 44 31778 NOR2X1 $T=956080 749805 0 180 $X=952850 $Y=745250
X1461 31666 31863 18 44 31849 NOR2X1 $T=955520 804685 0 0 $X=955090 $Y=804295
X1462 132 125 18 44 31803 NOR2X1 $T=958880 749805 0 180 $X=955650 $Y=745250
X1463 109 125 18 44 31732 NOR2X1 $T=959440 757645 1 180 $X=956210 $Y=757255
X1464 31881 31643 18 44 31863 NOR2X1 $T=957760 812525 0 0 $X=957330 $Y=812135
X1465 122 137 18 44 31683 NOR2X1 $T=958880 749805 1 0 $X=958450 $Y=745250
X1466 31881 31666 18 44 31824 NOR2X1 $T=959440 796845 1 0 $X=959010 $Y=792290
X1467 31683 31778 18 44 31972 NOR2X1 $T=960000 757645 0 0 $X=959570 $Y=757255
X1468 132 129 18 44 31911 NOR2X1 $T=965040 749805 1 180 $X=961810 $Y=749415
X1469 31987 31849 18 44 32037 NOR2X1 $T=962240 812525 0 0 $X=961810 $Y=812135
X1470 32105 32053 18 44 32008 NOR2X1 $T=966720 812525 0 180 $X=963490 $Y=807970
X1471 32086 32121 18 44 31973 NOR2X1 $T=964480 781165 1 0 $X=964050 $Y=776610
X1472 32088 32144 18 44 31715 NOR2X1 $T=965040 789005 0 0 $X=964610 $Y=788615
X1473 109 31972 18 44 32262 NOR2X1 $T=969520 757645 0 0 $X=969090 $Y=757255
X1474 32105 32274 18 44 32086 NOR2X1 $T=969520 781165 1 0 $X=969090 $Y=776610
X1475 31733 32314 18 44 32295 NOR2X1 $T=970640 765485 1 0 $X=970210 $Y=760930
X1476 31913 32315 18 44 32100 NOR2X1 $T=970640 820365 0 0 $X=970210 $Y=819975
X1477 143 124 18 44 32354 NOR2X1 $T=975120 734125 1 180 $X=971890 $Y=733735
X1478 32107 32263 18 44 31684 NOR2X1 $T=973440 820365 0 0 $X=973010 $Y=819975
X1479 32459 32495 18 44 32476 NOR2X1 $T=976240 757645 0 0 $X=975810 $Y=757255
X1480 31861 31666 18 44 32315 NOR2X1 $T=976240 804685 0 0 $X=975810 $Y=804295
X1481 32388 134 18 44 31913 NOR2X1 $T=976800 820365 1 0 $X=976370 $Y=815810
X1482 32471 146 18 44 32599 NOR2X1 $T=979600 749805 0 0 $X=979170 $Y=749415
X1483 32088 32152 18 44 31825 NOR2X1 $T=984080 796845 1 180 $X=980850 $Y=796455
X1484 31881 32152 18 44 32514 NOR2X1 $T=984640 789005 1 180 $X=981410 $Y=788615
X1485 32085 32723 18 44 147 NOR2X1 $T=985200 749805 0 0 $X=984770 $Y=749415
X1486 31861 32516 18 44 32263 NOR2X1 $T=986320 804685 0 0 $X=985890 $Y=804295
X1487 31881 32107 18 44 32197 NOR2X1 $T=986320 828205 1 0 $X=985890 $Y=823650
X1488 32037 33111 18 44 32993 NOR2X1 $T=997520 812525 1 0 $X=997090 $Y=807970
X1489 35436 35476 18 44 30996 NOR2X1 $T=1070880 773325 0 0 $X=1070450 $Y=772935
X1490 35557 35599 18 44 35583 NOR2X1 $T=1074240 749805 0 0 $X=1073810 $Y=749415
X1491 35584 35617 18 44 35218 NOR2X1 $T=1074800 796845 1 0 $X=1074370 $Y=792290
X1492 35695 35568 18 44 35599 NOR2X1 $T=1079840 749805 1 180 $X=1076610 $Y=749415
X1493 35583 35753 18 44 35752 NOR2X1 $T=1079840 749805 0 0 $X=1079410 $Y=749415
X1494 177 34713 18 44 35695 NOR2X1 $T=1083200 765485 1 180 $X=1079970 $Y=765095
X1495 173 35749 18 44 35883 NOR2X1 $T=1083760 741965 0 0 $X=1083330 $Y=741575
X1496 35957 35646 18 44 35699 NOR2X1 $T=1087680 757645 1 180 $X=1084450 $Y=757255
X1497 35978 36009 18 44 35841 NOR2X1 $T=1086560 796845 1 0 $X=1086130 $Y=792290
X1498 151 82 18 44 86 NOR2X1 $T=1087680 734125 1 0 $X=1087250 $Y=729570
X1499 36050 35911 18 44 35978 NOR2X1 $T=1090480 789005 1 180 $X=1087250 $Y=788615
X1500 35749 34713 18 44 35873 NOR2X1 $T=1089920 773325 1 0 $X=1089490 $Y=768770
X1501 177 36102 18 44 36049 NOR2X1 $T=1090480 765485 0 0 $X=1090050 $Y=765095
X1502 36176 36137 18 44 36157 NOR2X1 $T=1094400 789005 0 180 $X=1091170 $Y=784450
X1503 35699 36157 18 44 36009 NOR2X1 $T=1091600 796845 1 0 $X=1091170 $Y=792290
X1504 35962 36229 18 44 36054 NOR2X1 $T=1097200 781165 0 180 $X=1093970 $Y=776610
X1505 35755 36137 18 44 36247 NOR2X1 $T=1094400 789005 1 0 $X=1093970 $Y=784450
X1506 177 35679 18 44 36176 NOR2X1 $T=1096080 773325 0 0 $X=1095650 $Y=772935
X1507 36229 36327 18 44 36137 NOR2X1 $T=1096640 781165 0 0 $X=1096210 $Y=780775
X1508 36309 35517 18 44 35957 NOR2X1 $T=1100000 757645 0 0 $X=1099570 $Y=757255
X1509 33543 35517 18 44 36254 NOR2X1 $T=1102800 765485 1 180 $X=1099570 $Y=765095
X1510 177 36494 18 44 36343 NOR2X1 $T=1102240 741965 1 0 $X=1101810 $Y=737410
X1511 33543 36460 18 44 35646 NOR2X1 $T=1104480 749805 1 0 $X=1104050 $Y=745250
X1512 35962 36102 18 44 35754 NOR2X1 $T=1105040 757645 0 0 $X=1104610 $Y=757255
X1513 36460 36247 18 44 36588 NOR2X1 $T=1108960 781165 0 180 $X=1105730 $Y=776610
X1514 36460 173 18 44 36494 NOR2X1 $T=1110080 741965 0 180 $X=1106850 $Y=737410
X1515 35962 173 18 44 36228 NOR2X1 $T=1107840 757645 0 0 $X=1107410 $Y=757255
X1516 36796 36622 18 44 36781 NOR2X1 $T=1115680 749805 0 180 $X=1112450 $Y=745250
X1517 35749 36690 18 44 36796 NOR2X1 $T=1116240 757645 0 180 $X=1113010 $Y=753090
X1518 36588 36847 18 44 36817 NOR2X1 $T=1114000 773325 1 0 $X=1113570 $Y=768770
X1519 18 44 58 63 26452 ICV_81 $T=781920 749805 0 0 $X=781490 $Y=749415
X1520 18 44 58 26897 26916 ICV_81 $T=795920 749805 1 0 $X=795490 $Y=745250
X1521 18 44 28190 28354 28335 ICV_81 $T=841280 812525 1 0 $X=840850 $Y=807970
X1522 18 44 58 29058 28870 ICV_81 $T=862000 820365 0 0 $X=861570 $Y=819975
X1523 18 44 45 30461 30302 ICV_81 $T=907920 859565 1 0 $X=907490 $Y=855010
X1524 18 44 30829 82 30679 ICV_81 $T=922480 765485 0 0 $X=922050 $Y=765095
X1525 18 44 31294 119 31375 ICV_81 $T=938160 741965 1 0 $X=937730 $Y=737410
X1526 18 44 109 133 131 ICV_81 $T=951600 734125 1 0 $X=951170 $Y=729570
X1527 18 44 31813 31633 31837 ICV_81 $T=952720 796845 0 0 $X=952290 $Y=796455
X1528 18 44 31911 31942 31770 ICV_81 $T=956080 734125 0 0 $X=955650 $Y=733735
X1529 18 44 31586 31989 31954 ICV_81 $T=957760 781165 0 0 $X=957330 $Y=780775
X1530 18 44 32197 32152 32183 ICV_81 $T=966720 812525 1 0 $X=966290 $Y=807970
X1531 18 44 32197 32263 32022 ICV_81 $T=966720 828205 0 0 $X=966290 $Y=827815
X1532 18 44 46 32915 31725 ICV_81 $T=986880 867405 0 0 $X=986450 $Y=867015
X1533 18 44 32816 33012 32994 ICV_81 $T=989680 836045 0 0 $X=989250 $Y=835655
X1534 18 44 32969 48 33264 ICV_81 $T=997520 859565 0 0 $X=997090 $Y=859175
X1535 18 44 86 155 33355 ICV_81 $T=1005920 757645 1 0 $X=1005490 $Y=753090
X1536 18 44 82 34070 34050 ICV_81 $T=1022720 773325 0 0 $X=1022290 $Y=772935
X1537 18 44 52 34935 34816 ICV_81 $T=1052400 843885 1 0 $X=1051970 $Y=839330
X1538 18 44 151 174 35144 ICV_81 $T=1073120 734125 0 0 $X=1072690 $Y=733735
X1539 18 44 35660 35646 35435 ICV_81 $T=1074800 765485 0 0 $X=1074370 $Y=765095
X1540 18 44 52 35979 35842 ICV_81 $T=1083760 843885 1 0 $X=1083330 $Y=839330
X1541 18 44 36228 35646 36599 ICV_81 $T=1104480 773325 1 0 $X=1104050 $Y=768770
X1542 18 44 37255 48 37506 ICV_81 $T=1133600 836045 0 0 $X=1133170 $Y=835655
X1543 18 44 45 37638 37470 ICV_81 $T=1134720 851725 0 0 $X=1134290 $Y=851335
X1544 18 44 86 37376 37652 ICV_81 $T=1135840 741965 1 0 $X=1135410 $Y=737410
X1545 18 44 45 37970 37814 ICV_81 $T=1145360 836045 0 0 $X=1144930 $Y=835655
X1546 18 44 52 39363 39509 ICV_81 $T=1192400 757645 0 0 $X=1191970 $Y=757255
X1547 18 44 52 38909 39429 ICV_81 $T=1194640 765485 1 0 $X=1194210 $Y=760930
X1548 18 44 45 24256 24724 ICV_76 $T=733200 781165 1 0 $X=732770 $Y=776610
X1549 18 44 45 24255 24807 ICV_76 $T=735440 749805 0 0 $X=735010 $Y=749415
X1550 18 44 46 24255 24835 ICV_76 $T=739920 749805 1 0 $X=739490 $Y=745250
X1551 18 44 25412 48 25413 ICV_76 $T=752800 773325 0 0 $X=752370 $Y=772935
X1552 18 44 45 26022 26004 ICV_76 $T=769040 828205 0 0 $X=768610 $Y=827815
X1553 18 44 26198 26237 26217 ICV_76 $T=775760 757645 0 0 $X=775330 $Y=757255
X1554 18 44 46 26309 26228 ICV_76 $T=778000 820365 0 0 $X=777570 $Y=819975
X1555 18 44 46 26310 26139 ICV_76 $T=778000 836045 1 0 $X=777570 $Y=831490
X1556 18 44 26254 48 26415 ICV_76 $T=781920 812525 0 0 $X=781490 $Y=812135
X1557 18 44 58 64 26754 ICV_76 $T=792560 749805 1 0 $X=792130 $Y=745250
X1558 18 44 45 26310 26751 ICV_76 $T=792560 836045 1 0 $X=792130 $Y=831490
X1559 18 44 26965 48 27017 ICV_76 $T=800960 796845 1 0 $X=800530 $Y=792290
X1560 18 44 46 25371 27178 ICV_76 $T=805440 820365 1 0 $X=805010 $Y=815810
X1561 18 44 46 27235 26282 ICV_76 $T=807120 851725 1 0 $X=806690 $Y=847170
X1562 18 44 45 27408 27384 ICV_76 $T=812160 836045 0 0 $X=811730 $Y=835655
X1563 18 44 58 27250 27669 ICV_76 $T=821120 773325 0 0 $X=820690 $Y=772935
X1564 18 44 27747 27809 27784 ICV_76 $T=825040 781165 0 0 $X=824610 $Y=780775
X1565 18 44 52 28303 28285 ICV_76 $T=841280 843885 1 0 $X=840850 $Y=839330
X1566 18 44 82 91 28524 ICV_76 $T=848560 749805 1 0 $X=848130 $Y=745250
X1567 18 44 28020 48 28799 ICV_76 $T=857520 843885 0 0 $X=857090 $Y=843495
X1568 18 44 58 29171 28977 ICV_76 $T=867040 820365 0 0 $X=866610 $Y=819975
X1569 18 44 45 29445 29053 ICV_76 $T=876000 859565 1 0 $X=875570 $Y=855010
X1570 18 44 46 29744 28812 ICV_76 $T=886640 867405 0 0 $X=886210 $Y=867015
X1571 18 44 82 110 30505 ICV_76 $T=911840 773325 1 0 $X=911410 $Y=768770
X1572 18 44 58 30489 30555 ICV_76 $T=913520 836045 1 0 $X=913090 $Y=831490
X1573 18 44 118 119 31318 ICV_76 $T=938160 749805 0 0 $X=937730 $Y=749415
X1574 18 44 31825 31881 31633 ICV_76 $T=955520 804685 1 0 $X=955090 $Y=800130
X1575 18 44 45 31514 31649 ICV_76 $T=960000 859565 1 0 $X=959570 $Y=855010
X1576 18 44 32348 122 32369 ICV_76 $T=972320 757645 0 0 $X=971890 $Y=757255
X1577 18 44 32315 32516 31586 ICV_76 $T=977360 804685 1 0 $X=976930 $Y=800130
X1578 18 44 32707 31666 32724 ICV_76 $T=983520 789005 1 0 $X=983090 $Y=784450
X1579 18 44 32741 48 32763 ICV_76 $T=984640 851725 0 0 $X=984210 $Y=851335
X1580 18 44 32932 33075 33051 ICV_76 $T=993040 796845 0 0 $X=992610 $Y=796455
X1581 18 44 151 34372 34370 ICV_76 $T=1034480 741965 1 0 $X=1034050 $Y=737410
X1582 18 44 86 33718 34362 ICV_76 $T=1035040 773325 0 0 $X=1034610 $Y=772935
X1583 18 44 52 35039 35028 ICV_76 $T=1057440 843885 1 0 $X=1057010 $Y=839330
X1584 18 44 35621 36054 35911 ICV_76 $T=1087120 781165 1 0 $X=1086690 $Y=776610
X1585 18 44 36023 36026 35854 ICV_76 $T=1087680 781165 0 0 $X=1087250 $Y=780775
X1586 18 44 36178 36363 36349 ICV_76 $T=1097200 734125 0 0 $X=1096770 $Y=733735
X1587 18 44 35517 33543 36215 ICV_76 $T=1099440 749805 1 0 $X=1099010 $Y=745250
X1588 18 44 35646 34713 36697 ICV_76 $T=1109520 757645 1 0 $X=1109090 $Y=753090
X1589 18 44 37747 48 37724 ICV_76 $T=1147600 828205 1 0 $X=1147170 $Y=823650
X1590 18 44 45 38808 38194 ICV_76 $T=1172800 836045 1 0 $X=1172370 $Y=831490
X1591 18 44 38823 38858 38859 ICV_76 $T=1174480 765485 1 0 $X=1174050 $Y=760930
X1592 18 44 46 38808 38985 ICV_76 $T=1178960 836045 1 0 $X=1178530 $Y=831490
X1593 18 44 46 39211 38669 ICV_76 $T=1185120 820365 1 0 $X=1184690 $Y=815810
X1594 18 44 46 39040 39366 ICV_76 $T=1190160 820365 0 0 $X=1189730 $Y=819975
X1595 18 44 46 40177 40178 ICV_76 $T=1213120 804685 1 0 $X=1212690 $Y=800130
X1596 18 44 40490 201 40509 ICV_76 $T=1223200 749805 0 0 $X=1222770 $Y=749415
X1597 24782 24835 24884 18 44 24866 NAND3X1 $T=736000 734125 0 0 $X=735570 $Y=733735
X1598 24724 24887 24987 18 44 24963 NAND3X1 $T=738800 781165 0 0 $X=738370 $Y=780775
X1599 24807 24909 25005 18 44 24986 NAND3X1 $T=739360 749805 0 0 $X=738930 $Y=749415
X1600 24827 25033 25044 18 44 25067 NAND3X1 $T=741600 765485 1 0 $X=741170 $Y=760930
X1601 25108 25292 25350 18 44 25331 NAND3X1 $T=748880 781165 0 0 $X=748450 $Y=780775
X1602 25313 25046 25413 18 44 25390 NAND3X1 $T=750560 804685 0 0 $X=750130 $Y=804295
X1603 25293 25525 25579 18 44 25560 NAND3X1 $T=755040 796845 1 0 $X=754610 $Y=792290
X1604 26004 26139 26088 18 44 26111 NAND3X1 $T=777440 828205 1 180 $X=773090 $Y=827815
X1605 26271 26228 26180 18 44 26199 NAND3X1 $T=780240 820365 0 180 $X=775890 $Y=815810
X1606 26331 26282 26233 18 44 26251 NAND3X1 $T=781920 836045 1 180 $X=777570 $Y=835655
X1607 26270 26308 26486 18 44 26469 NAND3X1 $T=782480 804685 1 0 $X=782050 $Y=800130
X1608 26591 26550 26415 18 44 26519 NAND3X1 $T=790320 843885 0 180 $X=785970 $Y=839330
X1609 26860 26570 26750 18 44 26787 NAND3X1 $T=798720 820365 0 180 $X=794370 $Y=815810
X1610 26751 26956 27000 18 44 26979 NAND3X1 $T=798720 836045 1 0 $X=798290 $Y=831490
X1611 26882 27045 27017 18 44 27071 NAND3X1 $T=801520 804685 0 0 $X=801090 $Y=804295
X1612 27218 27373 27424 18 44 27405 NAND3X1 $T=811600 851725 0 0 $X=811170 $Y=851335
X1613 27384 27142 27444 18 44 27464 NAND3X1 $T=819440 836045 1 180 $X=815090 $Y=835655
X1614 27688 27178 27634 18 44 27650 NAND3X1 $T=825600 828205 0 180 $X=821250 $Y=823650
X1615 27722 27567 27804 18 44 27785 NAND3X1 $T=823920 851725 1 0 $X=823490 $Y=847170
X1616 27635 27797 27848 18 44 27827 NAND3X1 $T=825040 859565 0 0 $X=824610 $Y=859175
X1617 81 79 27945 18 44 28153 NAND3X1 $T=840720 734125 1 180 $X=836370 $Y=733735
X1618 66 80 78 18 44 28022 NAND3X1 $T=841280 734125 0 180 $X=836930 $Y=729570
X1619 27687 83 85 18 44 28333 NAND3X1 $T=841840 734125 1 0 $X=841410 $Y=729570
X1620 28353 28284 88 18 44 28419 NAND3X1 $T=844640 749805 1 0 $X=844210 $Y=745250
X1621 28577 92 90 18 44 28543 NAND3X1 $T=853600 734125 0 180 $X=849250 $Y=729570
X1622 28334 28443 28543 18 44 28578 NAND3X1 $T=849680 734125 0 0 $X=849250 $Y=733735
X1623 28646 28524 93 18 44 28579 NAND3X1 $T=855840 749805 0 180 $X=851490 $Y=745250
X1624 28594 28812 28799 18 44 28848 NAND3X1 $T=857520 859565 0 0 $X=857090 $Y=859175
X1625 28593 28891 95 18 44 28933 NAND3X1 $T=859760 741965 1 0 $X=859330 $Y=737410
X1626 29053 28628 28648 18 44 28974 NAND3X1 $T=867040 851725 0 180 $X=862690 $Y=847170
X1627 29261 27957 29172 18 44 29225 NAND3X1 $T=874320 851725 1 180 $X=869970 $Y=851335
X1628 29095 29643 29670 18 44 29671 NAND3X1 $T=883280 859565 0 0 $X=882850 $Y=859175
X1629 29714 29678 102 18 44 29653 NAND3X1 $T=888880 765485 0 180 $X=884530 $Y=760930
X1630 30011 29775 105 18 44 29943 NAND3X1 $T=898960 734125 1 180 $X=894610 $Y=733735
X1631 29958 29776 106 18 44 30029 NAND3X1 $T=895600 765485 0 0 $X=895170 $Y=765095
X1632 30012 29789 108 18 44 30113 NAND3X1 $T=898400 749805 0 0 $X=897970 $Y=749415
X1633 30302 30253 30205 18 44 30224 NAND3X1 $T=907920 859565 0 180 $X=903570 $Y=855010
X1634 30303 30254 30047 18 44 30225 NAND3X1 $T=907920 867405 1 180 $X=903570 $Y=867015
X1635 30430 30609 113 18 44 30604 NAND3X1 $T=915200 741965 0 0 $X=914770 $Y=741575
X1636 30708 30539 30635 18 44 30651 NAND3X1 $T=921920 867405 1 180 $X=917570 $Y=867015
X1637 30721 30505 114 18 44 30664 NAND3X1 $T=922480 765485 1 180 $X=918130 $Y=765095
X1638 30679 30557 115 18 44 30736 NAND3X1 $T=919120 749805 1 0 $X=918690 $Y=745250
X1639 30828 30871 117 18 44 30890 NAND3X1 $T=924720 749805 1 0 $X=924290 $Y=745250
X1640 30750 30917 30911 18 44 30945 NAND3X1 $T=926400 867405 0 0 $X=925970 $Y=867015
X1641 31356 31318 31462 18 44 31245 NAND3X1 $T=940400 749805 1 0 $X=939970 $Y=745250
X1642 31461 31270 31355 18 44 121 NAND3X1 $T=944880 734125 1 180 $X=940530 $Y=733735
X1643 31529 31502 31616 18 44 31554 NAND3X1 $T=945440 796845 1 0 $X=945010 $Y=792290
X1644 31646 31558 31568 18 44 31391 NAND3X1 $T=951040 781165 1 180 $X=946690 $Y=780775
X1645 31647 31612 31569 18 44 31434 NAND3X1 $T=951040 820365 1 180 $X=946690 $Y=819975
X1646 31649 31248 31570 18 44 31585 NAND3X1 $T=951040 859565 0 180 $X=946690 $Y=855010
X1647 31622 109 124 18 44 126 NAND3X1 $T=951600 734125 0 180 $X=947250 $Y=729570
X1648 31601 31643 31684 18 44 31569 NAND3X1 $T=947680 820365 1 0 $X=947250 $Y=815810
X1649 31700 118 123 18 44 31665 NAND3X1 $T=952720 757645 1 180 $X=948370 $Y=757255
X1650 31531 31708 31665 18 44 31733 NAND3X1 $T=949920 765485 0 0 $X=949490 $Y=765095
X1651 31546 31725 31735 18 44 31748 NAND3X1 $T=950480 867405 0 0 $X=950050 $Y=867015
X1652 130 31770 31811 18 44 31563 NAND3X1 $T=952160 734125 0 0 $X=951730 $Y=733735
X1653 31812 31583 31732 18 44 31708 NAND3X1 $T=956640 757645 1 180 $X=952290 $Y=757255
X1654 31583 31803 135 18 44 31811 NAND3X1 $T=953280 741965 1 0 $X=952850 $Y=737410
X1655 31780 31824 31861 18 44 31568 NAND3X1 $T=953840 781165 0 0 $X=953410 $Y=780775
X1656 31782 31825 134 18 44 31647 NAND3X1 $T=953840 820365 1 0 $X=953410 $Y=815810
X1657 31973 31937 31894 18 44 31714 NAND3X1 $T=962240 773325 1 180 $X=957890 $Y=772935
X1658 31912 31781 31666 18 44 31941 NAND3X1 $T=958320 796845 0 0 $X=957890 $Y=796455
X1659 31974 31246 31895 18 44 31914 NAND3X1 $T=962240 867405 1 180 $X=957890 $Y=867015
X1660 31988 31949 31913 18 44 31685 NAND3X1 $T=962800 828205 0 180 $X=958450 $Y=823650
X1661 32088 32053 31881 18 44 31584 NAND3X1 $T=966160 804685 0 180 $X=961810 $Y=800130
X1662 127 137 109 18 44 32104 NAND3X1 $T=962800 749805 1 0 $X=962370 $Y=745250
X1663 32108 32070 32022 18 44 31677 NAND3X1 $T=966720 828205 1 180 $X=962370 $Y=827815
X1664 32087 31941 32178 18 44 32121 NAND3X1 $T=964480 796845 1 0 $X=964050 $Y=792290
X1665 32020 32151 32143 18 44 32177 NAND3X1 $T=965040 765485 0 0 $X=964610 $Y=765095
X1666 31812 139 140 18 44 32245 NAND3X1 $T=967280 749805 0 0 $X=966850 $Y=749415
X1667 32197 32053 31861 18 44 32178 NAND3X1 $T=967840 804685 0 0 $X=967410 $Y=804295
X1668 32142 141 32330 18 44 32314 NAND3X1 $T=969520 741965 1 0 $X=969090 $Y=737410
X1669 32123 32152 32388 18 44 32228 NAND3X1 $T=971760 820365 1 0 $X=971330 $Y=815810
X1670 32370 31781 32107 18 44 32371 NAND3X1 $T=973440 789005 0 0 $X=973010 $Y=788615
X1671 32354 125 122 18 44 32330 NAND3X1 $T=977920 741965 0 180 $X=973570 $Y=737410
X1672 32354 144 140 18 44 32421 NAND3X1 $T=979040 734125 1 180 $X=974690 $Y=733735
X1673 32280 32472 32474 18 44 31528 NAND3X1 $T=975120 773325 0 0 $X=974690 $Y=772935
X1674 31660 31295 32354 18 44 32513 NAND3X1 $T=976240 741965 0 0 $X=975810 $Y=741575
X1675 32245 32554 32513 18 44 32459 NAND3X1 $T=982400 757645 0 180 $X=978050 $Y=753090
X1676 32476 32349 32423 18 44 32564 NAND3X1 $T=982400 773325 0 180 $X=978050 $Y=768770
X1677 32385 32456 32674 18 44 32638 NAND3X1 $T=980160 820365 0 0 $X=979730 $Y=819975
X1678 32295 32492 32563 18 44 32673 NAND3X1 $T=980720 765485 0 0 $X=980290 $Y=765095
X1679 32497 32716 32763 18 44 32742 NAND3X1 $T=982960 867405 0 0 $X=982530 $Y=867015
X1680 32764 32225 32421 18 44 32723 NAND3X1 $T=988560 741965 1 180 $X=984210 $Y=741575
X1681 32724 32779 32872 18 44 32873 NAND3X1 $T=986880 789005 0 0 $X=986450 $Y=788615
X1682 32831 32708 32834 18 44 32913 NAND3X1 $T=988000 820365 1 0 $X=987570 $Y=815810
X1683 32993 32350 33032 18 44 33072 NAND3X1 $T=992480 796845 1 0 $X=992050 $Y=792290
X1684 32263 32152 31862 18 44 33075 NAND3X1 $T=993040 789005 0 0 $X=992610 $Y=788615
X1685 32762 33073 33031 18 44 33111 NAND3X1 $T=993600 812525 1 0 $X=993170 $Y=807970
X1686 32995 33238 33264 18 44 33265 NAND3X1 $T=998080 867405 1 0 $X=997650 $Y=862850
X1687 33338 33355 33303 18 44 33319 NAND3X1 $T=1005920 757645 0 180 $X=1001570 $Y=753090
X1688 33523 33544 33614 18 44 33598 NAND3X1 $T=1008160 757645 0 0 $X=1007730 $Y=757255
X1689 33616 31414 33524 18 44 33545 NAND3X1 $T=1012640 867405 0 180 $X=1008290 $Y=862850
X1690 33918 34050 34003 18 44 34117 NAND3X1 $T=1025520 781165 1 0 $X=1025090 $Y=776610
X1691 33917 34126 34165 18 44 34150 NAND3X1 $T=1026640 773325 1 0 $X=1026210 $Y=768770
X1692 33985 34179 34205 18 44 34200 NAND3X1 $T=1028320 875245 1 0 $X=1027890 $Y=870690
X1693 34321 34362 34370 18 44 34396 NAND3X1 $T=1034480 773325 1 0 $X=1034050 $Y=768770
X1694 34561 32916 34479 18 44 34500 NAND3X1 $T=1044000 875245 1 180 $X=1039650 $Y=874855
X1695 34714 34499 34560 18 44 34678 NAND3X1 $T=1049040 773325 1 180 $X=1044690 $Y=772935
X1696 34609 34706 34752 18 44 34734 NAND3X1 $T=1045680 859565 0 0 $X=1045250 $Y=859175
X1697 34797 34562 34712 18 44 34733 NAND3X1 $T=1051840 749805 1 180 $X=1047490 $Y=749415
X1698 34936 33899 34862 18 44 34877 NAND3X1 $T=1056880 859565 1 180 $X=1052530 $Y=859175
X1699 34876 34987 35025 18 44 35008 NAND3X1 $T=1055760 765485 0 0 $X=1055330 $Y=765095
X1700 35007 167 35094 18 44 168 NAND3X1 $T=1058000 734125 0 0 $X=1057570 $Y=733735
X1701 34957 35102 35144 18 44 35125 NAND3X1 $T=1059680 749805 0 0 $X=1059250 $Y=749415
X1702 34998 35169 35177 18 44 35195 NAND3X1 $T=1061920 875245 1 0 $X=1061490 $Y=870690
X1703 35435 35489 35541 18 44 35476 NAND3X1 $T=1070880 765485 0 0 $X=1070450 $Y=765095
X1704 35518 35569 35616 18 44 35436 NAND3X1 $T=1073120 781165 1 0 $X=1072690 $Y=776610
X1705 35752 35713 35659 18 44 175 NAND3X1 $T=1081520 741965 1 180 $X=1077170 $Y=741575
X1706 35798 35749 176 18 44 35713 NAND3X1 $T=1082640 741965 0 180 $X=1078290 $Y=737410
X1707 35718 35765 35815 18 44 35753 NAND3X1 $T=1078720 765485 1 0 $X=1078290 $Y=760930
X1708 35841 35737 35734 18 44 35617 NAND3X1 $T=1083760 796845 0 180 $X=1079410 $Y=792290
X1709 35641 35830 35754 18 44 35765 NAND3X1 $T=1080400 757645 0 0 $X=1079970 $Y=757255
X1710 35927 35699 177 18 44 35718 NAND3X1 $T=1086560 773325 0 180 $X=1082210 $Y=768770
X1711 35929 36040 35958 18 44 36068 NAND3X1 $T=1087120 859565 1 0 $X=1086690 $Y=855010
X1712 35695 36063 176 18 44 36067 NAND3X1 $T=1092160 749805 1 180 $X=1087810 $Y=749415
X1713 36138 34051 36052 18 44 36069 NAND3X1 $T=1093280 859565 1 180 $X=1088930 $Y=859175
X1714 36175 36129 36085 18 44 35977 NAND3X1 $T=1094400 765485 0 180 $X=1090050 $Y=760930
X1715 35679 36254 34713 18 44 36175 NAND3X1 $T=1098320 773325 0 180 $X=1093970 $Y=768770
X1716 35873 36228 36309 18 44 35815 NAND3X1 $T=1095520 765485 0 0 $X=1095090 $Y=765095
X1717 36328 35558 36121 18 44 36293 NAND3X1 $T=1099440 851725 1 180 $X=1095090 $Y=851335
X1718 34713 177 35962 18 44 36327 NAND3X1 $T=1096080 757645 0 0 $X=1095650 $Y=757255
X1719 36275 36343 36215 18 44 36363 NAND3X1 $T=1096640 741965 1 0 $X=1096210 $Y=737410
X1720 36054 36102 35517 18 44 36388 NAND3X1 $T=1097200 781165 1 0 $X=1096770 $Y=776610
X1721 36398 34713 36309 18 44 35659 NAND3X1 $T=1101680 749805 1 180 $X=1097330 $Y=749415
X1722 35873 36228 36460 18 44 36482 NAND3X1 $T=1100560 773325 1 0 $X=1100130 $Y=768770
X1723 36409 35517 35962 18 44 36443 NAND3X1 $T=1100560 789005 0 0 $X=1100130 $Y=788615
X1724 36176 36517 36460 18 44 35616 NAND3X1 $T=1107280 773325 1 180 $X=1102930 $Y=772935
X1725 36600 35754 36430 18 44 36539 NAND3X1 $T=1108960 781165 1 180 $X=1104610 $Y=780775
X1726 36634 36592 36539 18 44 35584 NAND3X1 $T=1110080 789005 1 180 $X=1105730 $Y=788615
X1727 36431 36613 173 18 44 36634 NAND3X1 $T=1106160 796845 1 0 $X=1105730 $Y=792290
X1728 36254 173 35962 18 44 36690 NAND3X1 $T=1109520 765485 0 0 $X=1109090 $Y=765095
X1729 36696 36229 33543 18 44 36756 NAND3X1 $T=1110640 789005 1 0 $X=1110210 $Y=784450
X1730 36604 36807 36653 18 44 36831 NAND3X1 $T=1112880 843885 0 0 $X=1112450 $Y=843495
X1731 35957 36102 173 18 44 36858 NAND3X1 $T=1114000 757645 0 0 $X=1113570 $Y=757255
X1732 36695 36817 36781 18 44 36932 NAND3X1 $T=1115680 741965 0 0 $X=1115250 $Y=741575
X1733 36859 35749 35962 18 44 36933 NAND3X1 $T=1115680 765485 1 0 $X=1115250 $Y=760930
X1734 36814 36660 36933 18 44 36847 NAND3X1 $T=1116800 773325 1 0 $X=1116370 $Y=768770
X1735 36988 36709 181 18 44 182 NAND3X1 $T=1121280 734125 0 180 $X=1116930 $Y=729570
X1736 37470 36601 37372 18 44 37399 NAND3X1 $T=1134720 851725 1 180 $X=1130370 $Y=851335
X1737 37235 37462 37506 18 44 37486 NAND3X1 $T=1131360 851725 1 0 $X=1130930 $Y=847170
X1738 37814 36782 37724 18 44 37748 NAND3X1 $T=1145360 836045 1 180 $X=1141010 $Y=835655
X1739 37652 37829 189 18 44 37895 NAND3X1 $T=1144240 741965 1 0 $X=1143810 $Y=737410
X1740 38194 37849 38108 18 44 38127 NAND3X1 $T=1157680 836045 1 180 $X=1153330 $Y=835655
X1741 38327 38437 38311 18 44 38407 NAND3X1 $T=1166080 836045 0 180 $X=1161730 $Y=831490
X1742 38628 38669 38725 18 44 38702 NAND3X1 $T=1168880 836045 1 0 $X=1168450 $Y=831490
X1743 38892 38484 38806 18 44 38825 NAND3X1 $T=1178960 820365 1 180 $X=1174610 $Y=819975
X1744 39019 38107 38928 18 44 38946 NAND3X1 $T=1182880 804685 1 180 $X=1178530 $Y=804295
X1745 39468 38985 39343 18 44 39383 NAND3X1 $T=1195760 804685 1 180 $X=1191410 $Y=804295
X1746 39449 39366 39488 18 44 39533 NAND3X1 $T=1193520 812525 0 0 $X=1193090 $Y=812135
X1747 39596 39564 39511 18 44 39534 NAND3X1 $T=1199680 820365 1 180 $X=1195330 $Y=819975
X1748 39914 40088 40026 18 44 40120 NAND3X1 $T=1210320 789005 0 0 $X=1209890 $Y=788615
X1749 40101 40178 40227 18 44 40212 NAND3X1 $T=1214240 820365 1 0 $X=1213810 $Y=815810
X1750 40266 39737 40123 18 44 40195 NAND3X1 $T=1218720 765485 0 180 $X=1214370 $Y=760930
X1751 40715 40355 40610 18 44 40631 NAND3X1 $T=1231600 781165 1 180 $X=1227250 $Y=780775
X1752 40862 40801 202 18 44 40776 NAND3X1 $T=1235520 741965 0 180 $X=1231170 $Y=737410
X1753 40863 41054 41040 18 44 41081 NAND3X1 $T=1237760 781165 1 0 $X=1237330 $Y=776610
X1754 41301 41257 41165 18 44 41222 NAND3X1 $T=1247840 781165 1 180 $X=1243490 $Y=780775
X1755 41343 41146 41264 18 44 41299 NAND3X1 $T=1250080 741965 0 180 $X=1245730 $Y=737410
X1756 41226 41319 41206 18 44 41300 NAND3X1 $T=1250080 765485 1 180 $X=1245730 $Y=765095
X1757 66 68 18 44 27583 OR2X1 $T=817200 734125 1 0 $X=816770 $Y=729570
X1758 77 27829 18 44 27945 OR2X1 $T=834560 741965 0 180 $X=830770 $Y=737410
X1759 66 94 18 44 28577 OR2X1 $T=855280 734125 1 0 $X=854850 $Y=729570
X1760 119 31269 18 44 120 OR2X1 $T=944320 734125 0 180 $X=940530 $Y=729570
X1761 31584 31520 18 44 31502 OR2X1 $T=948240 804685 0 180 $X=944450 $Y=800130
X1762 31586 31597 18 44 31558 OR2X1 $T=949920 789005 1 180 $X=946130 $Y=788615
X1763 124 31583 18 44 31356 OR2X1 $T=950480 749805 0 180 $X=946690 $Y=745250
X1764 123 31660 18 44 31622 OR2X1 $T=952160 734125 1 180 $X=948370 $Y=733735
X1765 31670 31633 18 44 31616 OR2X1 $T=952720 796845 1 180 $X=948930 $Y=796455
X1766 31666 31633 18 44 31740 OR2X1 $T=950480 804685 0 0 $X=950050 $Y=804295
X1767 31781 31740 18 44 31529 OR2X1 $T=954960 796845 0 180 $X=951170 $Y=792290
X1768 31824 31912 18 44 31917 OR2X1 $T=962240 804685 0 180 $X=958450 $Y=800130
X1769 32008 31825 18 44 31643 OR2X1 $T=962800 804685 1 180 $X=959010 $Y=804295
X1770 31812 31808 18 44 32020 OR2X1 $T=960000 765485 0 0 $X=959570 $Y=765095
X1771 31951 31911 18 44 32052 OR2X1 $T=961120 741965 0 0 $X=960690 $Y=741575
X1772 31584 32100 18 44 32070 OR2X1 $T=963920 820365 0 0 $X=963490 $Y=819975
X1773 32144 32132 18 44 31894 OR2X1 $T=968400 773325 1 180 $X=964610 $Y=772935
X1774 31670 32183 18 44 32087 OR2X1 $T=970080 796845 1 180 $X=966290 $Y=796455
X1775 32107 31825 18 44 31949 OR2X1 $T=970640 820365 1 180 $X=966850 $Y=819975
X1776 32127 139 18 44 32159 OR2X1 $T=972320 734125 1 180 $X=968530 $Y=733735
X1777 32440 32385 18 44 32108 OR2X1 $T=976800 828205 1 180 $X=973010 $Y=827815
X1778 32088 32371 18 44 32474 OR2X1 $T=974560 781165 1 0 $X=974130 $Y=776610
X1779 32599 32262 18 44 32495 OR2X1 $T=982400 757645 1 180 $X=978610 $Y=757255
X1780 32354 32597 18 44 32635 OR2X1 $T=979600 741965 1 0 $X=979170 $Y=737410
X1781 31670 32144 18 44 32932 OR2X1 $T=988560 804685 1 0 $X=988130 $Y=800130
X1782 32105 31670 18 44 32831 OR2X1 $T=991920 812525 0 180 $X=988130 $Y=807970
X1783 35679 35621 18 44 35594 OR2X1 $T=1078720 773325 1 180 $X=1074930 $Y=772935
X1784 35646 35883 18 44 35830 OR2X1 $T=1086000 749805 1 180 $X=1082210 $Y=749415
X1785 35949 35991 18 44 35927 OR2X1 $T=1086000 773325 0 0 $X=1085570 $Y=772935
X1786 36049 35873 18 44 35621 OR2X1 $T=1089920 773325 0 180 $X=1086130 $Y=768770
X1787 35646 36066 18 44 36063 OR2X1 $T=1088240 749805 1 0 $X=1087810 $Y=745250
X1788 35646 36242 18 44 36275 OR2X1 $T=1099440 749805 0 180 $X=1095650 $Y=745250
X1789 35749 35873 18 44 36409 OR2X1 $T=1103920 781165 1 180 $X=1100130 $Y=780775
X1790 36495 36327 18 44 36566 OR2X1 $T=1103920 749805 0 0 $X=1103490 $Y=749415
X1791 18 44 46 24867 24887 ICV_74 $T=737680 773325 1 0 $X=737250 $Y=768770
X1792 18 44 46 24256 25046 ICV_74 $T=742160 796845 1 0 $X=741730 $Y=792290
X1793 18 44 52 25370 25821 ICV_74 $T=763440 757645 0 0 $X=763010 $Y=757255
X1794 18 44 52 25703 26290 ICV_74 $T=778000 789005 1 0 $X=777570 $Y=784450
X1795 18 44 58 27601 27141 ICV_74 $T=819440 789005 1 0 $X=819010 $Y=784450
X1796 18 44 28285 28254 28270 ICV_74 $T=840720 828205 0 0 $X=840290 $Y=827815
X1797 18 44 89 87 28443 ICV_74 $T=846320 734125 0 0 $X=845890 $Y=733735
X1798 18 44 29315 97 29313 ICV_74 $T=872080 757645 1 0 $X=871650 $Y=753090
X1799 18 44 29687 29426 29669 ICV_74 $T=884400 828205 0 0 $X=883970 $Y=827815
X1800 18 44 86 100 29789 ICV_74 $T=888880 757645 1 0 $X=888450 $Y=753090
X1801 18 44 86 30153 29714 ICV_74 $T=901760 773325 1 0 $X=901330 $Y=768770
X1802 18 44 46 29280 31248 ICV_74 $T=936480 859565 0 0 $X=936050 $Y=859175
X1803 18 44 31491 119 31462 ICV_74 $T=942640 757645 1 0 $X=942210 $Y=753090
X1804 18 44 31734 48 31735 ICV_74 $T=951040 859565 1 0 $X=950610 $Y=855010
X1805 18 44 32052 135 32120 ICV_74 $T=964480 741965 0 0 $X=964050 $Y=741575
X1806 18 44 32244 127 32225 ICV_74 $T=967840 741965 0 0 $X=967410 $Y=741575
X1807 18 44 32597 32471 32554 ICV_74 $T=979600 749805 1 0 $X=979170 $Y=745250
X1808 18 44 52 32741 32816 ICV_74 $T=986320 836045 0 0 $X=985890 $Y=835655
X1809 18 44 31913 32152 32834 ICV_74 $T=986880 820365 0 0 $X=986450 $Y=819975
X1810 18 44 86 33700 33918 ICV_74 $T=1019920 781165 1 0 $X=1019490 $Y=776610
X1811 18 44 34184 34071 34168 ICV_74 $T=1028320 836045 1 0 $X=1027890 $Y=831490
X1812 18 44 34204 48 34205 ICV_74 $T=1029440 867405 1 0 $X=1029010 $Y=862850
X1813 18 44 45 34373 34998 ICV_74 $T=1056320 875245 0 0 $X=1055890 $Y=874855
X1814 18 44 46 35519 33238 ICV_74 $T=1072560 859565 0 0 $X=1072130 $Y=859175
X1815 18 44 35979 48 35958 ICV_74 $T=1084880 851725 0 0 $X=1084450 $Y=851335
X1816 18 44 35957 176 36026 ICV_74 $T=1087120 765485 1 0 $X=1086690 $Y=760930
X1817 18 44 38824 38285 38805 ICV_74 $T=1173360 789005 0 0 $X=1172930 $Y=788615
X1818 18 44 39429 39324 39406 ICV_74 $T=1191280 765485 1 0 $X=1190850 $Y=760930
X1819 18 44 39513 38787 39510 ICV_74 $T=1194080 765485 0 0 $X=1193650 $Y=765095
X1820 18 44 45 38329 40101 ICV_74 $T=1210880 820365 1 0 $X=1210450 $Y=815810
X1821 18 44 52 39933 40490 ICV_74 $T=1223200 765485 1 0 $X=1222770 $Y=760930
X1822 18 44 46 40412 40801 ICV_74 $T=1231040 765485 1 0 $X=1230610 $Y=760930
X1823 18 45 24783 25108 44 ICV_78 $T=742720 781165 0 0 $X=742290 $Y=780775
X1824 18 25226 48 24987 44 ICV_78 $T=745520 765485 1 0 $X=745090 $Y=760930
X1825 18 52 25412 25601 44 ICV_78 $T=756160 757645 0 0 $X=755730 $Y=757255
X1826 18 45 26333 26271 44 ICV_78 $T=780240 820365 1 0 $X=779810 $Y=815810
X1827 18 86 28004 28353 44 ICV_78 $T=844080 741965 0 0 $X=843650 $Y=741575
X1828 18 30166 30095 30154 44 ICV_78 $T=899520 828205 0 0 $X=899090 $Y=827815
X1829 18 30524 82 30011 44 ICV_78 $T=910720 765485 0 0 $X=910290 $Y=765095
X1830 18 31583 123 31439 44 ICV_78 $T=944320 757645 0 0 $X=943890 $Y=757255
X1831 18 32122 32088 31646 44 ICV_78 $T=962800 781165 0 0 $X=962370 $Y=780775
X1832 18 32159 31942 32142 44 ICV_78 $T=963920 734125 0 0 $X=963490 $Y=733735
X1833 18 32873 32007 33032 44 ICV_78 $T=991360 789005 1 0 $X=990930 $Y=784450
X1834 18 45 33152 33985 44 ICV_78 $T=1021040 875245 1 0 $X=1020610 $Y=870690
X1835 18 34816 34770 34801 44 ICV_78 $T=1047920 843885 1 0 $X=1047490 $Y=839330
X1836 18 36443 36292 36431 44 ICV_78 $T=1098880 796845 1 0 $X=1098450 $Y=792290
X1837 18 45 35777 36604 44 ICV_78 $T=1105040 851725 0 0 $X=1104610 $Y=851335
X1838 18 36690 36599 36727 44 ICV_78 $T=1109520 773325 1 0 $X=1109090 $Y=768770
X1839 18 58 37812 37816 44 ICV_78 $T=1142560 796845 1 0 $X=1142130 $Y=792290
X1840 18 45 37931 38628 44 ICV_78 $T=1166640 836045 0 0 $X=1166210 $Y=835655
X1841 18 39363 48 39488 44 ICV_78 $T=1192400 789005 1 0 $X=1191970 $Y=784450
X1842 18 40281 199 40265 44 ICV_78 $T=1214800 741965 0 0 $X=1214370 $Y=741575
X1874 18 44 45 24436 24827 ICV_72 $T=736560 765485 1 0 $X=736130 $Y=760930
X1875 18 44 46 25969 25525 ICV_72 $T=767920 796845 0 0 $X=767490 $Y=796455
X1876 18 44 25724 48 26088 ICV_72 $T=772960 796845 0 0 $X=772530 $Y=796455
X1877 18 44 58 27271 26982 ICV_72 $T=816080 773325 0 0 $X=815650 $Y=772935
X1878 18 44 27583 71 27668 ICV_72 $T=822240 734125 1 0 $X=821810 $Y=729570
X1879 18 44 75 28022 76 ICV_72 $T=832320 734125 1 0 $X=831890 $Y=729570
X1880 18 44 45 29280 29261 ICV_72 $T=870960 859565 1 0 $X=870530 $Y=855010
X1881 18 44 58 29491 29655 ICV_72 $T=884960 820365 1 0 $X=884530 $Y=815810
X1882 18 44 86 30031 29958 ICV_72 $T=896720 781165 1 0 $X=896290 $Y=776610
X1883 18 44 29761 48 30047 ICV_72 $T=897280 859565 1 0 $X=896850 $Y=855010
X1884 18 44 86 30753 30721 ICV_72 $T=920800 773325 0 0 $X=920370 $Y=772935
X1885 18 44 86 30769 30609 ICV_72 $T=921360 741965 0 0 $X=920930 $Y=741575
X1886 18 44 31668 31703 31686 ICV_72 $T=949920 851725 0 0 $X=949490 $Y=851335
X1887 18 44 31783 134 31648 ICV_72 $T=953840 828205 1 0 $X=953410 $Y=823650
X1888 18 44 137 138 32010 ICV_72 $T=961120 734125 1 0 $X=960690 $Y=729570
X1889 18 44 31837 32315 32350 ICV_72 $T=971760 796845 0 0 $X=971330 $Y=796455
X1890 18 44 45 33772 33616 ICV_72 $T=1014880 867405 1 0 $X=1014450 $Y=862850
X1891 18 44 58 33653 33619 ICV_72 $T=1018800 836045 1 0 $X=1018370 $Y=831490
X1892 18 44 151 160 34165 ICV_72 $T=1029440 741965 1 0 $X=1029010 $Y=737410
X1893 18 44 46 34373 34179 ICV_72 $T=1035040 875245 0 0 $X=1034610 $Y=874855
X1894 18 44 58 34322 34770 ICV_72 $T=1048480 828205 1 0 $X=1048050 $Y=823650
X1895 18 44 86 34894 34714 ICV_72 $T=1052400 773325 0 0 $X=1051970 $Y=772935
X1896 18 44 35542 35517 35518 ICV_72 $T=1073680 789005 1 0 $X=1073250 $Y=784450
X1897 18 44 46 35777 34706 ICV_72 $T=1079280 859565 0 0 $X=1078850 $Y=859175
X1898 18 44 35981 48 36121 ICV_72 $T=1090480 851725 0 0 $X=1090050 $Y=851335
X1899 18 44 36005 177 36178 ICV_72 $T=1092160 734125 0 0 $X=1091730 $Y=733735
X1900 18 44 36495 36102 36517 ICV_72 $T=1104480 765485 0 0 $X=1104050 $Y=765095
X1901 18 44 37637 37816 37795 ICV_72 $T=1142560 828205 1 0 $X=1142130 $Y=823650
X1902 18 44 58 38350 38684 ICV_72 $T=1169440 765485 1 0 $X=1169010 $Y=760930
X1903 18 44 58 193 38858 ICV_72 $T=1175600 741965 0 0 $X=1175170 $Y=741575
X1904 18 44 52 39056 39513 ICV_72 $T=1194640 781165 0 0 $X=1194210 $Y=780775
X1905 18 44 45 40905 40715 ICV_72 $T=1233840 781165 0 0 $X=1233410 $Y=780775
X1906 18 44 203 48 41040 ICV_72 $T=1238320 765485 0 0 $X=1237890 $Y=765095
X1907 18 44 46 40905 41054 ICV_72 $T=1238880 781165 0 0 $X=1238450 $Y=780775
X1908 74 72 18 44 27803 AND2X1 $T=830640 734125 0 180 $X=826850 $Y=729570
X1909 31295 118 18 44 31512 AND2X1 $T=943200 765485 1 0 $X=942770 $Y=760930
X1910 31586 31545 18 44 31520 AND2X1 $T=948800 804685 1 180 $X=945010 $Y=804295
X1911 31683 31779 18 44 31544 AND2X1 $T=958320 765485 0 180 $X=954530 $Y=760930
X1912 125 132 18 44 31295 AND2X1 $T=956080 749805 0 0 $X=955650 $Y=749415
X1913 31643 31862 18 44 31747 AND2X1 $T=959440 789005 1 180 $X=955650 $Y=788615
X1914 31295 119 18 44 31951 AND2X1 $T=957760 741965 1 0 $X=957330 $Y=737410
X1915 127 136 18 44 32127 AND2X1 $T=969520 734125 0 180 $X=965730 $Y=729570
X1916 123 124 18 44 32244 AND2X1 $T=971760 749805 1 0 $X=971330 $Y=745250
X1917 32371 32403 18 44 32274 AND2X1 $T=973440 781165 0 0 $X=973010 $Y=780775
X1918 32120 32369 18 44 32492 AND2X1 $T=975120 765485 1 0 $X=974690 $Y=760930
X1919 32517 32518 18 44 32440 AND2X1 $T=980720 828205 1 180 $X=976930 $Y=827815
X1920 118 143 18 44 32597 AND2X1 $T=981840 734125 0 0 $X=981410 $Y=733735
X1921 35641 173 18 44 35568 AND2X1 $T=1078160 757645 1 180 $X=1074370 $Y=757255
X1922 35873 35949 18 44 35755 AND2X1 $T=1084320 781165 0 0 $X=1083890 $Y=780775
X1923 35873 36054 18 44 35991 AND2X1 $T=1092720 773325 0 0 $X=1092290 $Y=772935
X1924 36482 36388 18 44 36660 AND2X1 $T=1107280 773325 0 0 $X=1106850 $Y=772935
X1925 31563 18 44 31461 INVX2 $T=947680 734125 0 180 $X=945570 $Y=729570
X1926 125 18 44 31491 INVX2 $T=948800 749805 1 180 $X=946690 $Y=749415
X1927 31462 18 44 127 INVX2 $T=951040 741965 1 180 $X=948930 $Y=741575
X1928 31677 18 44 31612 INVX2 $T=951600 828205 1 180 $X=949490 $Y=827815
X1929 31583 18 44 31660 INVX2 $T=951040 741965 0 0 $X=950610 $Y=741575
X1930 31700 18 44 31808 INVX2 $T=954400 765485 0 0 $X=953970 $Y=765095
X1931 31643 18 44 31780 INVX2 $T=956640 781165 0 180 $X=954530 $Y=776610
X1932 133 18 44 124 INVX2 $T=959440 734125 1 0 $X=959010 $Y=729570
X1933 137 18 44 31942 INVX2 $T=962240 734125 0 0 $X=961810 $Y=733735
X1934 31781 18 44 32007 INVX2 $T=962800 796845 1 0 $X=962370 $Y=792290
X1935 31584 18 44 31912 INVX2 $T=963360 796845 0 0 $X=962930 $Y=796455
X1936 31849 18 44 31988 INVX2 $T=963360 820365 1 0 $X=962930 $Y=815810
X1937 32010 18 44 31812 INVX2 $T=965040 765485 1 0 $X=964610 $Y=760930
X1938 32152 18 44 32053 INVX2 $T=967840 804685 1 180 $X=965730 $Y=804295
X1939 32203 18 44 32122 INVX2 $T=969520 789005 0 180 $X=967410 $Y=784450
X1940 32197 18 44 31816 INVX2 $T=969520 812525 1 180 $X=967410 $Y=812135
X1941 122 18 44 140 INVX2 $T=973440 734125 1 0 $X=973010 $Y=729570
X1942 31861 18 44 32388 INVX2 $T=976240 804685 1 180 $X=974130 $Y=804295
X1943 31684 18 44 32456 INVX2 $T=975680 828205 1 0 $X=975250 $Y=823650
X1944 129 18 44 32471 INVX2 $T=978480 749805 1 180 $X=976370 $Y=749415
X1945 32144 18 44 32370 INVX2 $T=979040 789005 0 180 $X=976930 $Y=784450
X1946 31862 18 44 31881 INVX2 $T=985200 796845 1 0 $X=984770 $Y=792290
X1947 31825 18 44 32755 INVX2 $T=985200 804685 1 0 $X=984770 $Y=800130
X1948 134 18 44 32516 INVX2 $T=986320 820365 1 0 $X=985890 $Y=815810
X1949 32105 18 44 32088 INVX2 $T=988560 781165 1 0 $X=988130 $Y=776610
X1950 32107 18 44 31666 INVX2 $T=989120 804685 0 0 $X=988690 $Y=804295
X1951 35646 18 44 35673 INVX2 $T=1077040 781165 0 0 $X=1076610 $Y=780775
X1952 35699 18 44 35641 INVX2 $T=1080400 757645 0 180 $X=1078290 $Y=753090
X1953 177 18 44 35749 INVX2 $T=1087120 741965 0 180 $X=1085010 $Y=737410
X1954 35679 18 44 35949 INVX2 $T=1085440 781165 1 0 $X=1085010 $Y=776610
X1955 35798 18 44 36005 INVX2 $T=1087120 734125 0 0 $X=1086690 $Y=733735
X1956 176 18 44 35962 INVX2 $T=1089360 757645 0 180 $X=1087250 $Y=753090
X1957 36066 18 44 36242 INVX2 $T=1094400 741965 0 0 $X=1093970 $Y=741575
X1958 36215 18 44 36050 INVX2 $T=1094400 757645 1 0 $X=1093970 $Y=753090
X1959 35517 18 44 36460 INVX2 $T=1101680 749805 0 0 $X=1101250 $Y=749415
X1960 33543 18 44 36309 INVX2 $T=1104480 757645 1 180 $X=1102370 $Y=757255
X1961 35957 18 44 36495 INVX2 $T=1103360 757645 1 0 $X=1102930 $Y=753090
X1962 36176 18 44 36640 INVX2 $T=1110640 781165 0 180 $X=1108530 $Y=776610
X1963 179 18 44 180 INVX2 $T=1109520 883085 0 0 $X=1109090 $Y=882695
X1964 173 18 44 36229 INVX2 $T=1111760 789005 1 180 $X=1109650 $Y=788615
X1965 34713 18 44 36102 INVX2 $T=1112320 757645 1 180 $X=1110210 $Y=757255
X1966 36254 18 44 36792 INVX2 $T=1113440 773325 0 0 $X=1113010 $Y=772935
X2027 54 18 44 53 BUFX1 $T=752800 741965 0 180 $X=749570 $Y=737410
X2028 54 18 44 26172 BUFX1 $T=774080 765485 0 0 $X=773650 $Y=765095
X2029 28186 18 44 28142 BUFX1 $T=840720 820365 0 180 $X=837490 $Y=815810
X2030 28186 18 44 28177 BUFX1 $T=841840 796845 0 180 $X=838610 $Y=792290
X2031 54 18 44 101 BUFX1 $T=874880 734125 0 0 $X=874450 $Y=733735
X2032 28186 18 44 29573 BUFX1 $T=884960 781165 1 180 $X=881730 $Y=780775
X2033 28186 18 44 112 BUFX1 $T=914080 765485 0 180 $X=910850 $Y=760930
X2034 28186 18 44 30498 BUFX1 $T=915760 812525 0 180 $X=912530 $Y=807970
X2035 28186 18 44 31362 BUFX1 $T=939280 843885 0 0 $X=938850 $Y=843495
X2036 128 18 44 28186 BUFX1 $T=951040 765485 0 180 $X=947810 $Y=760930
X2037 128 18 44 31888 BUFX1 $T=956080 765485 0 0 $X=955650 $Y=765095
X2038 31888 18 44 33085 BUFX1 $T=993600 812525 0 0 $X=993170 $Y=812135
X2039 33085 18 44 33783 BUFX1 $T=1014880 812525 0 0 $X=1014450 $Y=812135
X2040 33085 18 44 34541 BUFX1 $T=1040080 812525 0 0 $X=1039650 $Y=812135
X2041 33085 18 44 36041 BUFX1 $T=1087120 820365 0 0 $X=1086690 $Y=819975
X2042 33085 18 44 37384 BUFX1 $T=1129120 828205 0 0 $X=1128690 $Y=827815
X2043 185 18 44 37802 BUFX1 $T=1146480 757645 1 180 $X=1143250 $Y=757255
X2044 185 18 44 39868 BUFX1 $T=1203600 773325 0 0 $X=1203170 $Y=772935
X2045 185 18 44 200 BUFX1 $T=1219280 741965 0 0 $X=1218850 $Y=741575
X2062 18 44 47 48 24884 ICV_77 $T=737680 734125 1 0 $X=737250 $Y=729570
X2063 18 44 49 48 25044 ICV_77 $T=739920 734125 0 0 $X=739490 $Y=733735
X2064 18 44 46 24783 25033 ICV_77 $T=741040 773325 1 0 $X=740610 $Y=768770
X2065 18 44 45 27704 27688 ICV_77 $T=819440 836045 0 0 $X=819010 $Y=835655
X2066 18 44 31513 48 31895 ICV_77 $T=954400 859565 1 0 $X=953970 $Y=855010
X2067 18 44 31942 109 32143 ICV_77 $T=962800 757645 0 0 $X=962370 $Y=757255
X2068 18 44 32263 32152 32518 ICV_77 $T=980720 828205 0 0 $X=980290 $Y=827815
X2069 18 44 151 33752 34003 ICV_77 $T=1020480 734125 0 0 $X=1020050 $Y=733735
X2070 18 44 45 34735 34561 ICV_77 $T=1044000 875245 0 0 $X=1043570 $Y=874855
X2071 18 44 151 170 35094 ICV_77 $T=1061920 734125 0 0 $X=1061490 $Y=733735
X2072 18 44 151 172 35025 ICV_77 $T=1067520 734125 0 0 $X=1067090 $Y=733735
X2073 18 44 36102 33543 36101 ICV_77 $T=1087680 757645 0 0 $X=1087250 $Y=757255
X2074 18 44 45 36497 36328 ICV_77 $T=1099440 851725 0 0 $X=1099010 $Y=851335
X2075 18 44 58 37779 37915 ICV_77 $T=1143680 812525 0 0 $X=1143250 $Y=812135
X2076 18 44 38909 48 40026 ICV_77 $T=1206400 773325 0 0 $X=1205970 $Y=772935
X2077 18 44 46 39856 40355 ICV_77 $T=1216480 804685 1 0 $X=1216050 $Y=800130
X2103 28153 28004 44 18 28299 XOR2X1 $T=837920 741965 0 0 $X=837490 $Y=741575
X2104 29349 28441 44 18 29330 XOR2X1 $T=870960 773325 1 0 $X=870530 $Y=768770
X2105 107 28300 44 18 109 XOR2X1 $T=900640 734125 0 0 $X=900210 $Y=733735
X2106 30307 30031 44 18 30028 XOR2X1 $T=907920 781165 0 180 $X=901330 $Y=776610
X2107 28578 30288 44 18 30431 XOR2X1 $T=905120 749805 1 0 $X=904690 $Y=745250
X2108 30770 30153 44 18 30524 XOR2X1 $T=924160 789005 0 180 $X=917570 $Y=784450
X2109 30996 30753 44 18 30829 XOR2X1 $T=932000 773325 1 180 $X=925410 $Y=772935
X2110 122 119 44 18 31583 XOR2X1 $T=944320 741965 1 0 $X=943890 $Y=737410
X2111 32385 134 44 18 32616 XOR2X1 $T=979600 781165 0 0 $X=979170 $Y=780775
X2112 32105 31666 44 18 32385 XOR2X1 $T=986320 804685 1 180 $X=979730 $Y=804295
X2113 149 148 44 18 31861 XOR2X1 $T=989120 773325 1 180 $X=982530 $Y=772935
X2114 150 99 44 18 32107 XOR2X1 $T=993040 757645 1 180 $X=986450 $Y=757255
X2115 154 30769 44 18 32152 XOR2X1 $T=1005360 781165 0 180 $X=998770 $Y=776610
X2116 32564 33147 44 18 33360 XOR2X1 $T=999760 765485 0 0 $X=999330 $Y=765095
X2117 153 30769 44 18 33543 XOR2X1 $T=1003680 741965 1 0 $X=1003250 $Y=737410
X2118 157 33718 44 18 31862 XOR2X1 $T=1018800 781165 0 180 $X=1012210 $Y=776610
X2119 33072 33700 44 18 33932 XOR2X1 $T=1018240 781165 0 0 $X=1017810 $Y=780775
X2120 163 34070 44 18 34713 XOR2X1 $T=1042320 765485 1 0 $X=1041890 $Y=760930
X2121 32673 34513 44 18 34577 XOR2X1 $T=1052400 773325 0 180 $X=1045810 $Y=768770
X2122 166 34912 44 18 32105 XOR2X1 $T=1056320 765485 0 180 $X=1049730 $Y=760930
X2123 164 34528 44 18 34953 XOR2X1 $T=1050720 741965 0 0 $X=1050290 $Y=741575
X2124 35218 34894 44 18 35057 XOR2X1 $T=1066400 796845 0 180 $X=1059810 $Y=792290
X2125 171 99 44 18 35517 XOR2X1 $T=1068080 741965 0 0 $X=1067650 $Y=741575
X2126 35699 173 44 18 35798 XOR2X1 $T=1078720 734125 0 0 $X=1078290 $Y=733735
X2127 173 33543 44 18 36066 XOR2X1 $T=1088240 741965 1 0 $X=1087810 $Y=737410
X2128 36932 37376 44 18 37469 XOR2X1 $T=1129680 741965 1 0 $X=1129250 $Y=737410
X2146 18 44 52 50 51 ICV_79 $T=749440 734125 0 180 $X=746210 $Y=729570
X2147 18 44 46 26022 26550 ICV_79 $T=790320 836045 0 180 $X=787090 $Y=831490
X2148 18 44 45 28041 29095 ICV_79 $T=868720 859565 0 180 $X=865490 $Y=855010
X2149 18 44 29595 29655 29673 ICV_79 $T=887760 843885 0 180 $X=884530 $Y=839330
X2150 18 44 82 100 29776 ICV_79 $T=891680 765485 1 180 $X=888450 $Y=765095
X2151 18 44 82 98 29678 ICV_79 $T=894480 765485 0 180 $X=891250 $Y=760930
X2152 18 44 86 110 30557 ICV_79 $T=916880 749805 0 180 $X=913650 $Y=745250
X2153 18 44 45 29929 31546 ICV_79 $T=948240 867405 1 180 $X=945010 $Y=867015
X2154 18 44 31670 31666 31545 ICV_79 $T=953280 804685 0 180 $X=950050 $Y=800130
X2155 18 44 139 124 32151 ICV_79 $T=969520 749805 0 180 $X=966290 $Y=745250
X2156 18 44 32275 32132 32280 ICV_79 $T=972880 773325 1 180 $X=969650 $Y=772935
X2157 18 44 45 35396 35929 ICV_79 $T=1087120 859565 1 180 $X=1083890 $Y=859175
X2158 18 44 35977 177 35489 ICV_79 $T=1088240 765485 1 180 $X=1085010 $Y=765095
X2159 18 44 36101 35749 35926 ICV_79 $T=1092160 757645 0 180 $X=1088930 $Y=753090
X2160 18 44 36229 35962 35679 ICV_79 $T=1103920 781165 0 180 $X=1100690 $Y=776610
X2161 18 44 52 37255 37637 ICV_79 $T=1140320 828205 0 180 $X=1137090 $Y=823650
X2162 18 44 52 38461 38823 ICV_79 $T=1178960 781165 0 180 $X=1175730 $Y=776610
X2163 18 44 40025 197 40003 ICV_79 $T=1211440 741965 0 180 $X=1208210 $Y=737410
X2236 18 44 25371 25390 180 26172 ICV_80 $T=753360 812525 0 0 $X=752930 $Y=812135
X2237 18 44 26897 26859 180 101 ICV_80 $T=786960 741965 1 0 $X=786530 $Y=737410
X2238 18 44 28220 28272 180 28142 ICV_80 $T=833440 851725 0 0 $X=833010 $Y=851335
X2239 18 44 30461 30224 180 30498 ICV_80 $T=895600 867405 1 0 $X=895170 $Y=862850
X2240 18 44 32054 31914 180 31362 ICV_80 $T=949360 883085 1 0 $X=948930 $Y=878530
X2241 18 44 32317 33265 180 31362 ICV_80 $T=979040 859565 1 0 $X=978610 $Y=855010
X2242 18 44 155 33319 180 295 ICV_80 $T=996400 749805 1 0 $X=995970 $Y=745250
X2243 18 44 33772 33545 180 31362 ICV_80 $T=1000880 867405 0 0 $X=1000450 $Y=867015
X2244 18 44 34166 34132 180 33783 ICV_80 $T=1018240 828205 1 0 $X=1017810 $Y=823650
X2245 18 44 34735 34500 180 33783 ICV_80 $T=1033360 890925 1 0 $X=1032930 $Y=886370
X2246 18 44 34935 34801 180 33783 ICV_80 $T=1041200 851725 1 0 $X=1040770 $Y=847170
X2247 18 44 35060 34877 180 33783 ICV_80 $T=1049040 867405 0 0 $X=1048610 $Y=867015
X2248 18 44 35756 35799 180 34541 ICV_80 $T=1055760 812525 1 0 $X=1055330 $Y=807970
X2249 18 44 36497 36293 180 36041 ICV_80 $T=1100560 851725 1 0 $X=1100130 $Y=847170
X2250 18 44 37970 37748 180 37384 ICV_80 $T=1130240 843885 0 0 $X=1129810 $Y=843495
X2251 18 44 37779 37746 180 37802 ICV_80 $T=1132480 789005 1 0 $X=1132050 $Y=784450
X2252 18 44 38894 39534 180 39868 ICV_80 $T=1198000 836045 1 0 $X=1197570 $Y=831490
X2253 18 44 38329 40212 180 39868 ICV_80 $T=1199680 828205 1 0 $X=1199250 $Y=823650
X2254 18 44 46 24436 24909 ICV_71 $T=737680 757645 0 0 $X=737250 $Y=757255
X2255 18 44 46 24257 25292 ICV_71 $T=748320 789005 0 0 $X=747890 $Y=788615
X2256 18 44 27685 27669 27684 ICV_71 $T=821120 796845 0 0 $X=820690 $Y=796455
X2257 18 44 27383 48 27634 ICV_71 $T=821120 812525 0 0 $X=820690 $Y=812135
X2258 18 44 28220 48 27848 ICV_71 $T=837920 859565 0 0 $X=837490 $Y=859175
X2259 18 44 45 27235 28594 ICV_71 $T=850800 859565 0 0 $X=850370 $Y=859175
X2260 18 44 29330 82 29315 ICV_71 $T=871520 757645 0 0 $X=871090 $Y=757255
X2261 18 44 32007 31824 31989 ICV_71 $T=959440 789005 0 0 $X=959010 $Y=788615
X2262 18 44 123 140 142 ICV_71 $T=969520 734125 1 0 $X=969090 $Y=729570
X2263 18 44 32422 32315 32261 ICV_71 $T=972880 796845 1 0 $X=972450 $Y=792290
X2264 18 44 32516 32388 31670 ICV_71 $T=975680 812525 1 0 $X=975250 $Y=807970
X2265 18 44 32515 32496 32422 ICV_71 $T=976800 796845 1 0 $X=976370 $Y=792290
X2266 18 44 32616 32514 32472 ICV_71 $T=979040 773325 0 0 $X=978610 $Y=772935
X2267 18 44 32638 31586 32622 ICV_71 $T=979600 812525 1 0 $X=979170 $Y=807970
X2268 18 44 46 32054 32916 ICV_71 $T=988560 875245 1 0 $X=988130 $Y=870690
X2269 18 44 52 32969 33263 ICV_71 $T=998640 836045 0 0 $X=998210 $Y=835655
X2270 18 44 45 32915 34609 ICV_71 $T=1042320 867405 1 0 $X=1041890 $Y=862850
X2271 18 44 35057 82 34797 ICV_71 $T=1057440 765485 1 0 $X=1057010 $Y=760930
X2272 18 44 36792 36102 36835 ICV_71 $T=1116800 781165 1 0 $X=1116370 $Y=776610
X2273 18 44 45 35519 37235 ICV_71 $T=1124640 851725 0 0 $X=1124210 $Y=851335
X2274 18 44 38804 38684 38788 ICV_71 $T=1172240 781165 1 0 $X=1171810 $Y=776610
X2275 18 44 46 41023 41146 ICV_71 $T=1240000 741965 1 0 $X=1239570 $Y=737410
X2276 18 44 25412 25641 180 53 ICV_73 $T=752240 749805 0 0 $X=751810 $Y=749415
X2277 18 44 27408 27464 180 28142 ICV_73 $T=803760 843885 1 0 $X=803330 $Y=839330
X2278 18 44 29058 29331 180 29573 ICV_73 $T=863120 781165 1 0 $X=862690 $Y=776610
X2279 18 44 29280 29225 180 30498 ICV_73 $T=863120 875245 1 0 $X=862690 $Y=870690
X2280 18 44 29761 29669 180 29573 ICV_73 $T=872640 836045 1 0 $X=872210 $Y=831490
X2281 18 44 30030 29991 180 29573 ICV_73 $T=884960 789005 0 0 $X=884530 $Y=788615
X2282 18 44 30395 30225 180 30498 ICV_73 $T=894480 875245 1 0 $X=894050 $Y=870690
X2283 18 44 30489 30459 180 30498 ICV_73 $T=909040 804685 0 0 $X=908610 $Y=804295
X2284 18 44 34912 302 180 303 ICV_73 $T=1090480 734125 1 0 $X=1090050 $Y=729570
X2285 18 44 37813 37778 180 37802 ICV_73 $T=1131920 773325 1 0 $X=1131490 $Y=768770
X2286 18 44 37948 37914 180 37802 ICV_73 $T=1131920 781165 1 0 $X=1131490 $Y=776610
X2287 18 44 38350 38308 180 37802 ICV_73 $T=1148720 749805 0 0 $X=1148290 $Y=749415
X2288 18 44 198 312 180 200 ICV_73 $T=1199120 734125 1 0 $X=1198690 $Y=729570
X2289 18 44 40177 40176 180 39868 ICV_73 $T=1199680 781165 0 0 $X=1199250 $Y=780775
X2290 18 44 40551 40265 180 200 ICV_73 $T=1205840 749805 1 0 $X=1205410 $Y=745250
X2291 18 44 40905 40631 180 39868 ICV_73 $T=1221520 789005 0 0 $X=1221090 $Y=788615
X2292 18 44 207 41222 180 39868 ICV_73 $T=1232720 796845 1 0 $X=1232290 $Y=792290
X2293 18 44 25370 48 25350 ICV_82 $T=753920 773325 0 180 $X=750690 $Y=768770
X2294 18 44 52 26808 27109 ICV_82 $T=810480 789005 0 180 $X=807250 $Y=784450
X2295 18 44 52 27361 27685 ICV_82 $T=825040 804685 0 180 $X=821810 $Y=800130
X2296 18 44 30028 82 30012 ICV_82 $T=899520 765485 0 180 $X=896290 $Y=760930
X2297 18 44 45 29744 30750 ICV_82 $T=924160 875245 0 180 $X=920930 $Y=870690
X2298 18 44 45 31440 32497 ICV_82 $T=979600 875245 0 180 $X=976370 $Y=870690
X2299 18 44 32635 31295 32764 ICV_82 $T=988000 741965 0 180 $X=984770 $Y=737410
X2300 18 44 33051 32105 33031 ICV_82 $T=995840 804685 1 180 $X=992610 $Y=804295
X2301 18 44 35028 35058 35106 ICV_82 $T=1063600 843885 0 180 $X=1060370 $Y=839330
X2302 18 44 58 34954 35618 ICV_82 $T=1078160 828205 1 180 $X=1074930 $Y=827815
X2303 18 44 177 36309 36430 ICV_82 $T=1103360 765485 0 180 $X=1100130 $Y=760930
X2304 18 44 46 36264 36601 ICV_82 $T=1109520 859565 0 180 $X=1106290 $Y=855010
X2305 18 44 52 36311 36651 ICV_82 $T=1111200 836045 0 180 $X=1107970 $Y=831490
X2306 18 44 82 34912 36709 ICV_82 $T=1113440 734125 1 180 $X=1110210 $Y=733735
X2307 18 44 46 35060 36782 ICV_82 $T=1115680 851725 1 180 $X=1112450 $Y=851335
X2308 18 44 37469 82 184 ICV_82 $T=1134720 734125 1 180 $X=1131490 $Y=733735
X2309 18 44 52 37747 38158 ICV_82 $T=1158240 812525 1 180 $X=1155010 $Y=812135
X2310 18 44 38461 48 38725 ICV_82 $T=1176160 820365 0 180 $X=1172930 $Y=815810
X2311 18 44 39509 39431 39487 ICV_82 $T=1196880 749805 0 180 $X=1193650 $Y=745250
X2312 18 150 ANTENNA $T=993040 757645 0 0 $X=992610 $Y=757255
X2313 18 154 ANTENNA $T=1005360 781165 1 0 $X=1004930 $Y=776610
X2314 18 157 ANTENNA $T=1018800 781165 1 0 $X=1018370 $Y=776610
X2315 18 163 ANTENNA $T=1041200 765485 1 0 $X=1040770 $Y=760930
X2316 18 166 ANTENNA $T=1056320 765485 1 0 $X=1055890 $Y=760930
X2335 18 44 25703 26436 180 26172 ICV_84 $T=761200 789005 0 0 $X=760770 $Y=788615
X2336 18 44 25724 26146 180 26172 ICV_84 $T=761760 781165 1 0 $X=761330 $Y=776610
X2337 18 44 26310 26979 180 28142 ICV_84 $T=781920 836045 0 0 $X=781490 $Y=835655
X2338 18 44 26435 26827 180 101 ICV_84 $T=783600 757645 1 0 $X=783170 $Y=753090
X2339 18 44 26607 27405 180 28142 ICV_84 $T=789200 859565 0 0 $X=788770 $Y=859175
X2340 18 44 27383 27784 180 28177 ICV_84 $T=813280 796845 1 0 $X=812850 $Y=792290
X2341 18 44 27851 28184 180 28177 ICV_84 $T=829520 773325 1 0 $X=829090 $Y=768770
X2342 18 44 28041 29671 180 30498 ICV_84 $T=863120 867405 1 0 $X=862690 $Y=862850
X2343 18 44 30127 30830 180 112 ICV_84 $T=901200 796845 0 0 $X=900770 $Y=796455
X2344 18 44 110 30736 180 112 ICV_84 $T=907920 757645 1 0 $X=907490 $Y=753090
X2345 18 44 33074 33395 180 33783 ICV_84 $T=994720 820365 0 0 $X=994290 $Y=819975
X2346 18 44 34529 34911 180 36041 ICV_84 $T=1041200 836045 1 0 $X=1040770 $Y=831490
X2347 18 44 36311 36860 180 37384 ICV_84 $T=1097200 836045 0 0 $X=1096770 $Y=835655
X2348 18 44 37255 37795 180 37384 ICV_84 $T=1126880 836045 1 0 $X=1126450 $Y=831490
X2349 18 44 37747 38181 180 37384 ICV_84 $T=1141440 812525 1 0 $X=1141010 $Y=807970
X2350 18 44 37931 38702 180 37384 ICV_84 $T=1153200 851725 0 0 $X=1152770 $Y=851335
X2351 18 44 52 26254 26198 ICV_83 $T=776880 765485 1 0 $X=776450 $Y=760930
X2352 18 44 26290 26452 26436 ICV_83 $T=783040 789005 1 0 $X=782610 $Y=784450
X2353 18 44 26881 26916 26917 ICV_83 $T=798160 765485 1 0 $X=797730 $Y=760930
X2354 18 44 46 27326 27373 ICV_83 $T=818320 859565 1 0 $X=817890 $Y=855010
X2355 18 44 46 28041 27045 ICV_83 $T=832880 843885 0 0 $X=832450 $Y=843495
X2356 18 44 28252 28289 28272 ICV_83 $T=841280 851725 1 0 $X=840850 $Y=847170
X2357 18 44 29332 48 29670 ICV_83 $T=884960 851725 0 0 $X=884530 $Y=851335
X2358 18 44 52 29761 29687 ICV_83 $T=887760 828205 0 0 $X=887330 $Y=827815
X2359 18 44 58 30707 30771 ICV_83 $T=922480 836045 1 0 $X=922050 $Y=831490
X2360 18 44 31633 31670 31601 ICV_83 $T=948800 812525 1 0 $X=948370 $Y=807970
X2361 18 44 46 32317 30917 ICV_83 $T=970640 867405 0 0 $X=970210 $Y=867015
X2362 18 44 82 33718 34987 ICV_83 $T=1057440 773325 0 0 $X=1057010 $Y=772935
X2363 18 44 34953 82 35007 ICV_83 $T=1058560 741965 1 0 $X=1058130 $Y=737410
X2364 18 44 52 35981 35964 ICV_83 $T=1085440 836045 0 0 $X=1085010 $Y=835655
X2365 18 44 37357 37284 37374 ICV_83 $T=1129680 812525 1 0 $X=1129250 $Y=807970
X2366 18 44 52 39002 38963 ICV_83 $T=1179520 765485 1 0 $X=1179090 $Y=760930
.ENDS
***************************************
.SUBCKT ICV_46
** N=35 EP=0 IP=38 FDC=0
.ENDS
***************************************
.SUBCKT ICV_47
** N=69 EP=0 IP=75 FDC=0
.ENDS
***************************************
.SUBCKT ICV_48
** N=69 EP=0 IP=138 FDC=0
.ENDS
***************************************
.SUBCKT ICV_36
** N=5 EP=0 IP=8 FDC=0
.ENDS
***************************************
.SUBCKT ICV_40
** N=7 EP=0 IP=17 FDC=0
.ENDS
***************************************
.SUBCKT ICV_49 62 101
** N=219244 EP=2 IP=870 FDC=1
D0 62 101 pdio_m AREA=9e-10 PJ=0.00012 $X=171260 $Y=969475 $D=31
.ENDS
***************************************
.SUBCKT ICV_31
** N=4 EP=0 IP=8 FDC=0
.ENDS
***************************************
.SUBCKT ICV_32 72 131
** N=77687 EP=2 IP=210 FDC=1
D0 72 131 ndio_m AREA=9e-10 PJ=0.00012 $X=707490 $Y=1314355 $D=30
.ENDS
***************************************
.SUBCKT ICV_14
** N=2 EP=0 IP=4 FDC=0
.ENDS
***************************************
.SUBCKT ICV_30
** N=120060 EP=0 IP=51 FDC=0
.ENDS
***************************************
.SUBCKT ICV_7
** N=714 EP=0 IP=4 FDC=0
.ENDS
***************************************
.SUBCKT ICV_5
** N=632 EP=0 IP=4 FDC=0
.ENDS
***************************************
.SUBCKT ICV_3
** N=693 EP=0 IP=4 FDC=0
.ENDS
***************************************
.SUBCKT ICV_9 32 33 34
** N=3232 EP=3 IP=5 FDC=96
X0 32 33 34 pad_in $T=0 0 0 0 $X=-900 $Y=0
.ENDS
***************************************
.SUBCKT ICV_8 32 33 37
** N=3326 EP=3 IP=5 FDC=96
X0 32 33 37 pad_in $T=0 0 0 0 $X=-900 $Y=0
.ENDS
***************************************
.SUBCKT ICV_1 30 31 32
** N=3314 EP=3 IP=5 FDC=96
X0 30 31 32 pad_in $T=0 0 0 0 $X=-900 $Y=0
.ENDS
***************************************
.SUBCKT ICV_26
** N=13676 EP=0 IP=34 FDC=0
.ENDS
***************************************
.SUBCKT ICV_25
** N=22248 EP=0 IP=62 FDC=0
.ENDS
***************************************
.SUBCKT ICV_6
** N=708 EP=0 IP=4 FDC=0
.ENDS
***************************************
.SUBCKT ICV_24 57 58 114
** N=22601 EP=3 IP=97 FDC=96
X31 57 58 114 pad_in $T=1771680 531325 0 90 $X=1537580 $Y=530425
.ENDS
***************************************
.SUBCKT ICV_4
** N=708 EP=0 IP=4 FDC=0
.ENDS
***************************************
.SUBCKT ICV_23 1 2 3 4 5 62
** N=21377 EP=6 IP=98 FDC=52
M0 4 1 62 62 N L=3.5e-07 W=2e-05 $X=1549200 $Y=933815 $D=0
M1 62 1 4 62 N L=3.5e-07 W=2e-05 $X=1554110 $Y=933815 $D=0
M2 4 1 62 62 N L=3.5e-07 W=2e-05 $X=1555680 $Y=933815 $D=0
M3 62 1 4 62 N L=3.5e-07 W=2e-05 $X=1560590 $Y=933815 $D=0
M4 4 1 62 62 N L=3.5e-07 W=2e-05 $X=1562160 $Y=933815 $D=0
M5 62 1 4 62 N L=3.5e-07 W=2e-05 $X=1567070 $Y=933815 $D=0
M6 4 1 62 62 N L=3.5e-07 W=2e-05 $X=1568640 $Y=933815 $D=0
M7 62 1 4 62 N L=3.5e-07 W=2e-05 $X=1573550 $Y=933815 $D=0
M8 4 1 62 62 N L=3.5e-07 W=2e-05 $X=1575120 $Y=933815 $D=0
M9 62 1 4 62 N L=3.5e-07 W=2e-05 $X=1580030 $Y=933815 $D=0
M10 62 3 554 62 N L=3.5e-07 W=9e-06 $X=1615580 $Y=923745 $D=0
M11 555 554 62 62 N L=3.5e-07 W=9e-06 $X=1615580 $Y=926145 $D=0
M12 62 2 1 62 N L=3.5e-07 W=9e-06 $X=1615580 $Y=931245 $D=0
M13 1 2 62 62 N L=3.5e-07 W=9e-06 $X=1615580 $Y=933645 $D=0
M14 62 2 1 62 N L=3.5e-07 W=9e-06 $X=1615580 $Y=936045 $D=0
M15 1 2 62 62 N L=3.5e-07 W=9e-06 $X=1615580 $Y=938445 $D=0
M16 62 2 1 62 N L=3.5e-07 W=9e-06 $X=1615580 $Y=940845 $D=0
M17 1 554 62 62 N L=3.5e-07 W=9e-06 $X=1615580 $Y=943245 $D=0
M18 62 554 1 62 N L=3.5e-07 W=9e-06 $X=1615580 $Y=945645 $D=0
M19 1 554 62 62 N L=3.5e-07 W=9e-06 $X=1615580 $Y=948045 $D=0
M20 62 554 1 62 N L=3.5e-07 W=9e-06 $X=1615580 $Y=950445 $D=0
M21 1 554 62 62 N L=3.5e-07 W=9e-06 $X=1615580 $Y=952845 $D=0
M22 5 555 1 62 N L=3.5e-07 W=9e-06 $X=1615580 $Y=955245 $D=0
M23 1 555 5 62 N L=3.5e-07 W=9e-06 $X=1615580 $Y=957645 $D=0
M24 5 555 1 62 N L=3.5e-07 W=9e-06 $X=1615580 $Y=960045 $D=0
M25 1 555 5 62 N L=3.5e-07 W=9e-06 $X=1615580 $Y=962445 $D=0
M26 3 3 554 3 P L=3.5e-07 W=1.56e-05 $X=1590530 $Y=923745 $D=16
M27 555 554 3 3 P L=3.5e-07 W=1.56e-05 $X=1590530 $Y=926145 $D=16
M28 3 2 5 3 P L=3.5e-07 W=1.56e-05 $X=1590530 $Y=931245 $D=16
M29 5 2 3 3 P L=3.5e-07 W=1.56e-05 $X=1590530 $Y=933645 $D=16
M30 3 2 5 3 P L=3.5e-07 W=1.56e-05 $X=1590530 $Y=936045 $D=16
M31 5 2 3 3 P L=3.5e-07 W=1.56e-05 $X=1590530 $Y=938445 $D=16
M32 3 2 5 3 P L=3.5e-07 W=1.56e-05 $X=1590530 $Y=940845 $D=16
M33 5 555 3 3 P L=3.5e-07 W=1.56e-05 $X=1590530 $Y=943245 $D=16
M34 3 555 5 3 P L=3.5e-07 W=1.56e-05 $X=1590530 $Y=945645 $D=16
M35 5 555 3 3 P L=3.5e-07 W=1.56e-05 $X=1590530 $Y=948045 $D=16
M36 3 555 5 3 P L=3.5e-07 W=1.56e-05 $X=1590530 $Y=950445 $D=16
M37 5 555 3 3 P L=3.5e-07 W=1.56e-05 $X=1590530 $Y=952845 $D=16
M38 1 554 5 3 P L=3.5e-07 W=1.56e-05 $X=1590530 $Y=955245 $D=16
M39 5 554 1 3 P L=3.5e-07 W=1.56e-05 $X=1590530 $Y=957645 $D=16
M40 1 554 5 3 P L=3.5e-07 W=1.56e-05 $X=1590530 $Y=960045 $D=16
M41 5 554 1 3 P L=3.5e-07 W=1.56e-05 $X=1590530 $Y=962445 $D=16
M42 4 5 3 3 P L=3.5e-07 W=2e-05 $X=1643415 $Y=933840 $D=16
M43 3 5 4 3 P L=3.5e-07 W=2e-05 $X=1648325 $Y=933840 $D=16
M44 4 5 3 3 P L=3.5e-07 W=2e-05 $X=1649895 $Y=933840 $D=16
M45 3 5 4 3 P L=3.5e-07 W=2e-05 $X=1654805 $Y=933840 $D=16
M46 4 5 3 3 P L=3.5e-07 W=2e-05 $X=1656375 $Y=933840 $D=16
M47 3 5 4 3 P L=3.5e-07 W=2e-05 $X=1661285 $Y=933840 $D=16
M48 4 5 3 3 P L=3.5e-07 W=2e-05 $X=1662855 $Y=933840 $D=16
M49 3 5 4 3 P L=3.5e-07 W=2e-05 $X=1667765 $Y=933840 $D=16
M50 4 5 3 3 P L=3.5e-07 W=2e-05 $X=1669335 $Y=933840 $D=16
M51 3 5 4 3 P L=3.5e-07 W=2e-05 $X=1674245 $Y=933840 $D=16
.ENDS
***************************************
.SUBCKT ICV_22 1 2 3 60 61
** N=23582 EP=5 IP=58 FDC=44
M0 2 1 60 60 N L=3.5e-07 W=2e-05 $X=1549200 $Y=972275 $D=0
M1 60 1 2 60 N L=3.5e-07 W=2e-05 $X=1554110 $Y=972275 $D=0
M2 2 1 60 60 N L=3.5e-07 W=2e-05 $X=1555680 $Y=972275 $D=0
M3 60 1 2 60 N L=3.5e-07 W=2e-05 $X=1560590 $Y=972275 $D=0
M4 2 1 60 60 N L=3.5e-07 W=2e-05 $X=1562160 $Y=972275 $D=0
M5 60 1 2 60 N L=3.5e-07 W=2e-05 $X=1567070 $Y=972275 $D=0
M6 2 1 60 60 N L=3.5e-07 W=2e-05 $X=1568640 $Y=972275 $D=0
M7 60 1 2 60 N L=3.5e-07 W=2e-05 $X=1573550 $Y=972275 $D=0
M8 2 1 60 60 N L=3.5e-07 W=2e-05 $X=1575120 $Y=972275 $D=0
M9 60 1 2 60 N L=3.5e-07 W=2e-05 $X=1580030 $Y=972275 $D=0
M10 567 2 60 60 N L=3.5e-07 W=9e-06 $X=1615730 $Y=977445 $D=0
M11 60 2 567 60 N L=3.5e-07 W=9e-06 $X=1615730 $Y=979845 $D=0
M12 567 2 60 60 N L=3.5e-07 W=9e-06 $X=1615730 $Y=982245 $D=0
M13 60 2 567 60 N L=3.5e-07 W=9e-06 $X=1615730 $Y=984645 $D=0
M14 567 2 60 60 N L=3.5e-07 W=9e-06 $X=1615730 $Y=987045 $D=0
M15 60 2 567 60 N L=3.5e-07 W=9e-06 $X=1615730 $Y=989445 $D=0
M16 2360 567 60 60 N L=3.5e-07 W=9e-06 $X=1615730 $Y=991845 $D=0
M17 60 567 2360 60 N L=3.5e-07 W=9e-06 $X=1615730 $Y=994245 $D=0
M18 2360 567 60 60 N L=3.5e-07 W=9e-06 $X=1615730 $Y=996645 $D=0
M19 60 567 2360 60 N L=3.5e-07 W=9e-06 $X=1615730 $Y=999045 $D=0
M20 2360 567 60 60 N L=3.5e-07 W=9e-06 $X=1615730 $Y=1001445 $D=0
M21 60 567 2360 60 N L=3.5e-07 W=9e-06 $X=1615730 $Y=1003845 $D=0
M22 567 2 61 61 P L=3.5e-07 W=1.56e-05 $X=1590530 $Y=977445 $D=16
M23 61 2 567 61 P L=3.5e-07 W=1.56e-05 $X=1590530 $Y=979845 $D=16
M24 567 2 61 61 P L=3.5e-07 W=1.56e-05 $X=1590530 $Y=982245 $D=16
M25 61 2 567 61 P L=3.5e-07 W=1.56e-05 $X=1590530 $Y=984645 $D=16
M26 567 2 61 61 P L=3.5e-07 W=1.56e-05 $X=1590530 $Y=987045 $D=16
M27 61 2 567 61 P L=3.5e-07 W=1.56e-05 $X=1590530 $Y=989445 $D=16
M28 2360 567 61 61 P L=3.5e-07 W=1.56e-05 $X=1590530 $Y=991845 $D=16
M29 61 567 2360 61 P L=3.5e-07 W=1.56e-05 $X=1590530 $Y=994245 $D=16
M30 2360 567 61 61 P L=3.5e-07 W=1.56e-05 $X=1590530 $Y=996645 $D=16
M31 61 567 2360 61 P L=3.5e-07 W=1.56e-05 $X=1590530 $Y=999045 $D=16
M32 2360 567 61 61 P L=3.5e-07 W=1.56e-05 $X=1590530 $Y=1001445 $D=16
M33 61 567 2360 61 P L=3.5e-07 W=1.56e-05 $X=1590530 $Y=1003845 $D=16
M34 2 3 61 61 P L=3.5e-07 W=2e-05 $X=1643415 $Y=971375 $D=16
M35 61 3 2 61 P L=3.5e-07 W=2e-05 $X=1648325 $Y=971375 $D=16
M36 2 3 61 61 P L=3.5e-07 W=2e-05 $X=1649895 $Y=971375 $D=16
M37 61 3 2 61 P L=3.5e-07 W=2e-05 $X=1654805 $Y=971375 $D=16
M38 2 3 61 61 P L=3.5e-07 W=2e-05 $X=1656375 $Y=971375 $D=16
M39 61 3 2 61 P L=3.5e-07 W=2e-05 $X=1661285 $Y=971375 $D=16
M40 2 3 61 61 P L=3.5e-07 W=2e-05 $X=1662855 $Y=971375 $D=16
M41 61 3 2 61 P L=3.5e-07 W=2e-05 $X=1667765 $Y=971375 $D=16
M42 2 3 61 61 P L=3.5e-07 W=2e-05 $X=1669335 $Y=971375 $D=16
M43 61 3 2 61 P L=3.5e-07 W=2e-05 $X=1674245 $Y=971375 $D=16
.ENDS
***************************************
.SUBCKT ICV_2
** N=704 EP=0 IP=4 FDC=0
.ENDS
***************************************
.SUBCKT ICV_21
** N=20695 EP=0 IP=94 FDC=0
.ENDS
***************************************
.SUBCKT ICV_27
** N=23929 EP=0 IP=60 FDC=0
.ENDS
***************************************
.SUBCKT ICV_20
** N=28070 EP=0 IP=48 FDC=0
.ENDS
***************************************
.SUBCKT top_pad_merged VSS VDD
** N=8486 EP=2 IP=17137 FDC=42683
X4 VSS VDD 1240 1243 1242 2887 1366 1246 4387 4386 4385 4384 1245 1248 4390 1249 4391 1250 4389 4394
+ 4454 1278 1251 1256 4460 4430 4461 1253 1252 1331 4400 4395 4416 4393 1269 1287 4404 1303 1255 1254
+ 4402 1283 4403 4396 1258 1257 4458 4401 4405 4399 1321 4407 4406 1267 1265 1310 4467 4397 2888 4421
+ 1259 1260 4412 1261 1262 1263 2889 4411 1271 1264 2890 4413 4415 4414 1306 1266 4426 4418 4409 4417
+ 1268 4419 1270 4427 4446 1344 4420 4424 2801 4398 4422 1272 4433 4423 4431 1277 4410 4425 1273 1274
+ 4408 1276 1275 1285 4442 4448 1297 4434 1280 4428 1279 1282 1281 4432 4457 4435 4436 4444 1284 4447
+ 1286 1288 4440 1289 1290 4439 4438 4429 4441 4456 1329 1291 4443 4464 1292 4445 4452 1298 4453 4449
+ 1295 1307 1294 4455 1304 1301 1293 2802 1300 1296 1317 4451 4459 1305 4501 1302 1351 1311 4463 1312
+ 4505 4468 4469 1313 4487 1315 1314 1316 4466 1319 1318 4462 4471 2892 4475 4480 4478 4472 4473 4482
+ 4476 1323 1309 1308 1299 4470 4494 1320 4474 1322 1327 4465 1324 4479 2803 1325 4504 4483 1326 1328
+ 1372 4485 4486 1371 1330 4489 4484 1332 4492 4490 4488 4491 4493 1338 1333 4500 4495 1334 1335 4496
+ 1337 4515 4497 4498 4514 4392 1349 4503 1339 1336 1342 4477 4481 1341 1343 1340 4499 1350 4502 4506
+ 4510 4509 4507 4512 1352 4508 1345 1347 1348 1346 1355 4527 1356 4533 1364 4528 4524 1357 1358 1495
+ 1362 1363 1365 1367 4535 1480 4538 4536 1239 1241 4382 4383 1244 1247 4388 1361 4532 4520 4522 4534
+ 1368 4537
+ ICV_117 $T=0 0 0 0 $X=-80000 $Y=234005
X7 VSS VDD 1415 4617 1414 1417 1366 4528 1246 1239 4631 1495 1418 2887 1419 1240 4619 1478 1416 1243
+ 1420 1480 4622 1241 1351 2978 4385 1242 4621 4620 4382 1245 1244 1421 1422 4629 4384 1247 4387 4386
+ 4625 1423 1248 1249 1424 4628 4624 1425 4626 4655 1440 4389 1426 4627 1433 1427 1428 4388 1430 1431
+ 1432 1429 4390 1434 1435 1436 1437 1438 4630 1439 1441 1442 4392 4632 4633 4639 4636 1443 4634 4393
+ 1445 4394 4635 1444 4395 4645 1251 1446 4391 1250 1270 4637 1448 1253 1252 4400 4420 4460 4640 1274
+ 4401 4404 1331 1355 4396 4638 1254 4411 4407 4399 1447 4405 4403 1255 1260 4397 4402 2888 4406 4408
+ 4642 1256 4641 1258 4467 4436 1259 1303 1257 1449 1261 4409 4412 1321 4458 4398 1450 4429 1262 1310
+ 1264 4410 4644 4461 1267 1263 1265 4413 4454 1266 4414 2889 1451 4419 1344 1285 4416 4415 4417 4446
+ 1269 4422 1268 1272 4434 1452 1271 1306 2890 4425 1453 4421 1273 4423 1454 4418 4424 4443 4450 4426
+ 1238 1276 1279 4428 4427 1277 1278 4448 2802 1280 4437 4501 1284 4432 4442 1281 1282 1455 4664 1275
+ 4457 4433 4431 4435 1283 4451 4646 4430 4648 1456 4438 1287 1286 4654 1329 4440 4439 4447 1459 1288
+ 1457 4449 1473 1469 4647 1458 1292 1289 1290 1291 4464 4441 1460 1462 4656 4657 1472 4444 1463 4652
+ 4456 1465 4445 1464 1466 1302 1461 1293 4650 1294 1467 1468 4452 4459 1295 4455 4651 1470 1307 1301
+ 4649 1317 1298 4653 1471 1305 1297 1296 1474 4671 1475 1476 4453 1300 1477 2993 2994 1311 1479 1343
+ 1312 1304 4490 4462 4502 2803 4660 1484 1315 1314 4465 1324 4466 4486 2995 1316 4472 1341 4468 1318
+ 4470 1319 1313 4659 4471 1320 4661 4474 4463 4475 1322 4482 4480 1350 4473 4662 4477 4476 1323 4478
+ 4479 4469 1325 4488 4663 4484 1352 4483 4481 1328 1327 2999 4485 1330 4493 1326 1332 1348 4491 4489
+ 1333 4492 1482 1483 4487 1334 4658 4495 3002 4494 3000 2892 1335 4500 1347 4515 1337 4496 4498 1336
+ 1340 4499 4514 4497 1339 1338 3003 4506 4503 4510 1342 4504 4665 1490 4505 4672 4666 4509 4507 4508
+ 1345 1349 4512 4667 1346 4668 1486 1485 1488 1489 4670 4520 3010 4673 4522 4524 4669 4674 1358 4675
+ 1357 4676 4527 1491 4677 1494 4532 1492 1493 1362 1365 1364 1367 4534 4678 1368 1496 4536 4533 4537
+ 1497 4535 4679 4680 1500 1499 1501 1498 4682 4683 4684 4538 4685 2936 4618 4383 4623 4643 1481 1487
+ 1356 1363 4681
+ ICV_114 $T=0 0 0 0 $X=-80000 $Y=486530
X8 VSS VDD 4682 4684 1415 1500 4617 1414 1419 1417 4618 4635 1416 1418 4619 1495 2978 4528 4620 4622
+ 4621 1422 4625 1423 4626 1424 4624 4627 1426 1425 1428 1427 1429 1431 4628 1433 1430 1435 1434 1351
+ 1436 1432 1437 4631 1438 4630 1439 1440 4639 1441 4632 1442 1443 4629 4633 4641 1445 4634 4623 4636
+ 4637 1448 4638 1451 4642 1447 1461 4640 1449 4643 1452 4644 1453 4645 1454 1458 4648 1456 1455 1457
+ 1471 1468 4654 1459 1469 4646 4647 1460 1462 4650 1465 4649 1463 1464 1466 1467 4651 1470 4653 1473
+ 4652 1472 1474 1475 1476 4656 4659 1309 1478 2993 1479 1299 4658 2994 1308 2995 1480 4661 4662 4663
+ 1372 1477 2999 1371 3000 1481 4664 3002 3003 1482 1484 1483 4655 4665 4667 1486 1565 4383 1488 1487
+ 4668 4670 4672 1490 4674 4671 4673 4675 3010 4676 1491 4677 1492 1494 4678 1497 4679 4681 4680 1498
+ 4683 1499 4685 1501 3055 1420 1421 1446 1444 1450 4657 4660 1485 4666 1489 4669 1493 1496
+ ICV_85 $T=0 0 0 0 $X=-80000 $Y=729570
X9 VSS VDD ICV_49 $T=0 0 0 0 $X=-80000 $Y=964770
X10 VSS VDD ICV_32 $T=0 0 0 0 $X=-80000 $Y=1224800
X15 VSS VDD 1238 ICV_9 $T=658270 1405 0 0 $X=657370 $Y=1405
X16 VSS VDD 1361 ICV_8 $T=1098375 1405 0 0 $X=1097475 $Y=1405
X17 VSS VDD 1565 ICV_1 $T=1188375 1537965 0 180 $X=1097475 $Y=1303865
X21 VSS VDD 2936 ICV_24 $T=0 0 0 0 $X=1537580 $Y=487800
X23 905 3055 VDD 390 476 VSS ICV_23 $T=0 0 0 0 $X=1537580 $Y=729600
X24 905 390 476 VSS VDD ICV_22 $T=0 0 0 0 $X=1537580 $Y=964800
.ENDS
***************************************
